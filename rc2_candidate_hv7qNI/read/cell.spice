* NGSPICE file created from comet_ram_2x1.ext - technology: sky130A

.subckt comet_ram_2x1 vdd vss a en din we pc_b sa_en dout
X0 a_0_n11917.t4 pc_b.t0 vdd.t47 vdd.t46 sky130_fd_pr__pfet_01v8 ad=0.212 pd=2.13 as=0.212 ps=2.13 w=0.8 l=0.15
X1 vss.t35 we.t0 a_11200_n23917.t1 vss.t34 sky130_fd_pr__nfet_01v8 ad=0.848 pd=6.93 as=0.848 ps=6.93 w=3.2 l=0.15
X2 a_19896_8041.t2 a_6400_83.t2 a_1600_n11917.t1 vss.t43 sky130_fd_pr__nfet_01v8 ad=0.212 pd=2.13 as=0.212 ps=2.13 w=0.8 l=0.15
X3 a_9600_n35917.t2 a_0_n11917.t6 a_n104_n35959.t2 vss.t36 sky130_fd_pr__nfet_01v8 ad=0.424 pd=3.73 as=0.424 ps=3.73 w=1.6 l=0.15
X4 a_9600_169.t1 en.t0 a_9600_83.t1 vss.t28 sky130_fd_pr__nfet_01v8 ad=0.848 pd=6.93 as=0.448 ps=3.48 w=3.2 l=0.15
X5 a_0_83.t1 a.t0 vdd.t29 vdd.t28 sky130_fd_pr__pfet_01v8 ad=0.636 pd=5.33 as=0.636 ps=5.33 w=2.4 l=0.15
X6 a_3200_169.t1 en.t1 vdd.t38 vdd.t37 sky130_fd_pr__pfet_01v8 ad=0.636 pd=5.33 as=0.336 ps=2.68 w=2.4 l=0.15
X7 vdd.t5 sa_en.t0 a_n104_n35959.t0 vdd.t4 sky130_fd_pr__pfet_01v8 ad=0.636 pd=5.33 as=0.636 ps=5.33 w=2.4 l=0.15
X8 a_19896_16041.t1 a_20000_14483.t3 vss.t18 vss.t17 sky130_fd_pr__nfet_01v8 ad=0.424 pd=3.73 as=0.424 ps=3.73 w=1.6 l=0.15
X9 a_12800_83.t0 a_9600_169.t3 vss.t27 vss.t26 sky130_fd_pr__nfet_01v8 ad=0.424 pd=3.73 as=0.424 ps=3.73 w=1.6 l=0.15
X10 a_19896_8041.t0 a_20000_6483.t3 vss.t8 vss.t7 sky130_fd_pr__nfet_01v8 ad=0.424 pd=3.73 as=0.424 ps=3.73 w=1.6 l=0.15
X11 a_20000_6483.t2 a_6400_83.t3 a_0_n11917.t0 vss.t6 sky130_fd_pr__nfet_01v8 ad=0.212 pd=2.13 as=0.212 ps=2.13 w=0.8 l=0.15
X12 a_9600_169.t2 en.t2 vdd.t1 vdd.t0 sky130_fd_pr__pfet_01v8 ad=0.636 pd=5.33 as=0.336 ps=2.68 w=2.4 l=0.15
X13 a_3200_n23917.t0 we.t1 vss.t33 vss.t32 sky130_fd_pr__nfet_01v8 ad=0.424 pd=3.73 as=0.424 ps=3.73 w=1.6 l=0.15
X14 vdd.t25 a_9600_n36000.t3 a_n104_n35959.t1 vdd.t24 sky130_fd_pr__pfet_01v8 ad=0.636 pd=5.33 as=0.636 ps=5.33 w=2.4 l=0.15
X15 a_3200_n35917.t0 a_0_n35917.t2 vss.t10 vss.t9 sky130_fd_pr__nfet_01v8 ad=0.424 pd=3.73 as=0.424 ps=3.73 w=1.6 l=0.15
X16 a_20000_14483.t0 a_19896_16041.t3 vdd.t21 vdd.t20 sky130_fd_pr__pfet_01v8 ad=0.636 pd=5.33 as=0.636 ps=5.33 w=2.4 l=0.15
X17 a_3200_83.t0 a_0_83.t2 vss.t41 vss.t40 sky130_fd_pr__nfet_01v8 ad=0.448 pd=3.48 as=0.848 ps=6.93 w=3.2 l=0.15
X18 a_0_n23917.t0 din.t0 vss.t23 vss.t22 sky130_fd_pr__nfet_01v8 ad=0.424 pd=3.73 as=0.424 ps=3.73 w=1.6 l=0.15
X19 a_20000_6483.t0 a_19896_8041.t3 vss.t16 vss.t15 sky130_fd_pr__nfet_01v8 ad=0.424 pd=3.73 as=0.424 ps=3.73 w=1.6 l=0.15
X20 vss.t2 sa_en.t1 a_9600_n35917.t1 vss.t1 sky130_fd_pr__nfet_01v8 ad=0.1113 pd=1.37 as=0.1113 ps=1.37 w=0.42 l=0.6
X21 a_20000_14483.t2 a_12800_83.t2 a_0_n11917.t3 vss.t29 sky130_fd_pr__nfet_01v8 ad=0.212 pd=2.13 as=0.212 ps=2.13 w=0.8 l=0.15
X22 a_19896_8041.t1 a_20000_6483.t4 vdd.t23 vdd.t22 sky130_fd_pr__pfet_01v8 ad=0.636 pd=5.33 as=0.636 ps=5.33 w=2.4 l=0.15
X23 a_1600_n11917.t2 pc_b.t1 vdd.t45 vdd.t44 sky130_fd_pr__pfet_01v8 ad=0.212 pd=2.13 as=0.212 ps=2.13 w=0.8 l=0.15
X24 a_0_n23917.t1 din.t1 vdd.t42 vdd.t41 sky130_fd_pr__pfet_01v8 ad=0.636 pd=5.33 as=0.636 ps=5.33 w=2.4 l=0.15
X25 a_0_n35917.t0 a_n104_n35959.t3 vss.t4 vss.t3 sky130_fd_pr__nfet_01v8 ad=0.424 pd=3.73 as=0.424 ps=3.73 w=1.6 l=0.15
X26 vdd.t31 a.t1 a_9600_169.t0 vdd.t30 sky130_fd_pr__pfet_01v8 ad=0.336 pd=2.68 as=0.636 ps=5.33 w=2.4 l=0.15
X27 a_12800_83.t1 a_9600_169.t4 vdd.t19 vdd.t18 sky130_fd_pr__pfet_01v8 ad=0.636 pd=5.33 as=0.636 ps=5.33 w=2.4 l=0.15
X28 dout.t1 a_3200_n35917.t2 vdd.t36 vdd.t35 sky130_fd_pr__pfet_01v8 ad=0.636 pd=5.33 as=0.636 ps=5.33 w=2.4 l=0.15
X29 a_9600_n35917.t0 a_1600_n11917.t6 a_9600_n36000.t2 vss.t5 sky130_fd_pr__nfet_01v8 ad=0.424 pd=3.73 as=0.424 ps=3.73 w=1.6 l=0.15
X30 vdd.t3 a_9600_n36000.t0 a_9600_n36000.t1 vdd.t2 sky130_fd_pr__pfet_01v8 ad=0.636 pd=5.33 as=0.636 ps=5.33 w=2.4 l=0.15
X31 a_9600_83.t0 a.t2 vss.t21 vss.t20 sky130_fd_pr__nfet_01v8 ad=0.448 pd=3.48 as=0.848 ps=6.93 w=3.2 l=0.15
X32 vdd.t34 a_3200_n23917.t2 a_16000_n24000.t1 vdd.t33 sky130_fd_pr__pfet_01v8 ad=1.272 pd=10.13 as=1.272 ps=10.13 w=4.8 l=0.15
X33 a_0_n35917.t1 a_n104_n35959.t4 vdd.t7 vdd.t6 sky130_fd_pr__pfet_01v8 ad=0.636 pd=5.33 as=0.636 ps=5.33 w=2.4 l=0.15
X34 a_20000_14483.t1 a_19896_16041.t4 vss.t25 vss.t24 sky130_fd_pr__nfet_01v8 ad=0.424 pd=3.73 as=0.424 ps=3.73 w=1.6 l=0.15
X35 a_20000_6483.t1 a_19896_8041.t4 vdd.t13 vdd.t12 sky130_fd_pr__pfet_01v8 ad=0.636 pd=5.33 as=0.636 ps=5.33 w=2.4 l=0.15
X36 vdd.t15 a_3200_n23917.t3 a_6400_n24000.t1 vdd.t14 sky130_fd_pr__pfet_01v8 ad=1.272 pd=10.13 as=1.272 ps=10.13 w=4.8 l=0.15
X37 a_11200_n23917.t0 a_0_n23917.t2 a_0_n11917.t1 vss.t19 sky130_fd_pr__nfet_01v8 ad=0.848 pd=6.93 as=0.848 ps=6.93 w=3.2 l=0.15
X38 a_3200_169.t2 en.t3 a_3200_83.t1 vss.t39 sky130_fd_pr__nfet_01v8 ad=0.848 pd=6.93 as=0.448 ps=3.48 w=3.2 l=0.15
X39 vss.t31 we.t2 a_20800_n23917.t1 vss.t30 sky130_fd_pr__nfet_01v8 ad=0.848 pd=6.93 as=0.848 ps=6.93 w=3.2 l=0.15
X40 a_3200_n23917.t1 we.t3 vdd.t9 vdd.t8 sky130_fd_pr__pfet_01v8 ad=0.636 pd=5.33 as=0.636 ps=5.33 w=2.4 l=0.15
X41 a_0_83.t0 a.t3 vss.t38 vss.t37 sky130_fd_pr__nfet_01v8 ad=0.424 pd=3.73 as=0.424 ps=3.73 w=1.6 l=0.15
X42 a_3200_n35917.t1 a_0_n35917.t3 vdd.t27 vdd.t26 sky130_fd_pr__pfet_01v8 ad=0.636 pd=5.33 as=0.636 ps=5.33 w=2.4 l=0.15
X43 a_1600_n11917.t3 pc_b.t2 a_0_n11917.t5 vdd.t43 sky130_fd_pr__pfet_01v8 ad=0.212 pd=2.13 as=0.212 ps=2.13 w=0.8 l=0.15
X44 a_6400_n24000.t0 a_0_n23917.t3 a_0_n11917.t2 vdd.t32 sky130_fd_pr__pfet_01v8 ad=1.272 pd=10.13 as=1.272 ps=10.13 w=4.8 l=0.15
X45 a_16000_n24000.t0 din.t2 a_1600_n11917.t5 vdd.t48 sky130_fd_pr__pfet_01v8 ad=1.272 pd=10.13 as=1.272 ps=10.13 w=4.8 l=0.15
X46 dout.t0 a_3200_n35917.t3 vss.t12 vss.t11 sky130_fd_pr__nfet_01v8 ad=0.424 pd=3.73 as=0.424 ps=3.73 w=1.6 l=0.15
X47 a_19896_16041.t2 a_20000_14483.t4 vdd.t11 vdd.t10 sky130_fd_pr__pfet_01v8 ad=0.636 pd=5.33 as=0.636 ps=5.33 w=2.4 l=0.15
X48 vdd.t40 a_0_83.t3 a_3200_169.t0 vdd.t39 sky130_fd_pr__pfet_01v8 ad=0.336 pd=2.68 as=0.636 ps=5.33 w=2.4 l=0.15
X49 a_6400_83.t0 a_3200_169.t3 vss.t14 vss.t13 sky130_fd_pr__nfet_01v8 ad=0.424 pd=3.73 as=0.424 ps=3.73 w=1.6 l=0.15
X50 a_6400_83.t1 a_3200_169.t4 vdd.t17 vdd.t16 sky130_fd_pr__pfet_01v8 ad=0.636 pd=5.33 as=0.636 ps=5.33 w=2.4 l=0.15
X51 a_19896_16041.t0 a_12800_83.t3 a_1600_n11917.t0 vss.t0 sky130_fd_pr__nfet_01v8 ad=0.212 pd=2.13 as=0.212 ps=2.13 w=0.8 l=0.15
X52 a_20800_n23917.t0 din.t3 a_1600_n11917.t4 vss.t42 sky130_fd_pr__nfet_01v8 ad=0.848 pd=6.93 as=0.848 ps=6.93 w=3.2 l=0.15
R0 pc_b pc_b.n0 0.09425
R1 pc_b.n0 pc_b.n1 2.5005
R2 pc_b.n1 pc_b.t2 393.777
R3 pc_b.n1 pc_b.t1 391.277
R4 pc_b.n0 pc_b.t0 391.277
R5 vdd vdd.n0 0.063
R6 vdd.n0 vdd.n12 7.7005
R7 vdd.n12 vdd.n22 4.2505
R8 vdd.n22 vdd.n46 22.463
R9 vdd.n46 vdd.n27 10.473
R10 vdd.n46 vdd.n42 2.04925
R11 vdd.n42 vdd.n45 4.2518
R12 vdd.n45 vdd.n44 21.6803
R13 vdd.n44 vdd.t22 886.304
R14 vdd.n44 vdd.t23 96.7659
R15 vdd.n45 vdd.n43 21.6803
R16 vdd.n43 vdd.t12 886.304
R17 vdd.n43 vdd.t13 96.7659
R18 vdd.n42 vdd.n41 10.9568
R19 vdd.n41 vdd.n40 21.6803
R20 vdd.n40 vdd.t10 886.304
R21 vdd.n40 vdd.t11 96.7659
R22 vdd.n41 vdd.n39 21.6803
R23 vdd.n39 vdd.t20 886.304
R24 vdd.n39 vdd.t21 96.7664
R25 vdd.n27 vdd.n32 4.5005
R26 vdd.n27 vdd.n37 5.5005
R27 vdd.n37 vdd.n38 30.7758
R28 vdd.n38 vdd.t18 886.304
R29 vdd.n38 vdd.t19 96.7659
R30 vdd.n34 vdd.n35 76.7109
R31 vdd.n37 vdd.n34 46.8431
R32 vdd.n34 vdd.n36 595.211
R33 vdd.n36 vdd.t30 37.7547
R34 vdd.n36 vdd.t0 37.7547
R35 vdd.n35 vdd.t31 11.4922
R36 vdd.n35 vdd.t1 11.4922
R37 vdd.n27 vdd.n33 26.2758
R38 vdd.n33 vdd.t16 886.304
R39 vdd.n33 vdd.t17 96.7659
R40 vdd.n29 vdd.n30 76.7109
R41 vdd.n32 vdd.n29 46.8431
R42 vdd.n29 vdd.n31 595.211
R43 vdd.n31 vdd.t39 37.7547
R44 vdd.n31 vdd.t37 37.7547
R45 vdd.n30 vdd.t40 11.4922
R46 vdd.n30 vdd.t38 11.4922
R47 vdd.n32 vdd.n28 31.7758
R48 vdd.n28 vdd.t28 886.304
R49 vdd.n28 vdd.t29 96.7659
R50 vdd.n22 vdd.n26 13.3648
R51 vdd.n23 vdd.n24 1.92238
R52 vdd.n26 vdd.n23 0.289562
R53 vdd.n26 vdd.n25 0.289562
R54 vdd.n25 vdd.t43 972.231
R55 vdd.n25 vdd.t44 969.731
R56 vdd.n24 vdd.t46 969.731
R57 vdd.n23 vdd.t45 384.753
R58 vdd.n24 vdd.t47 385.332
R59 vdd.n12 vdd.n21 10.9217
R60 vdd.n16 vdd.n15 5.39269
R61 vdd.n17 vdd.n16 0.445812
R62 vdd.n18 vdd.n17 3.7505
R63 vdd.n21 vdd.n18 0.20675
R64 vdd.n21 vdd.n19 10.5989
R65 vdd.n19 vdd.n20 0.445812
R66 vdd.n20 vdd.t48 1579.93
R67 vdd.n20 vdd.t33 1576.18
R68 vdd.n19 vdd.t34 357.281
R69 vdd.n18 vdd.t32 1576.18
R70 vdd.n17 vdd.t14 1576.18
R71 vdd.n16 vdd.t15 357.281
R72 vdd.n15 vdd.n14 29.8053
R73 vdd.n14 vdd.t8 886.304
R74 vdd.n14 vdd.t9 96.7659
R75 vdd.n15 vdd.n13 34.8053
R76 vdd.n13 vdd.t41 886.304
R77 vdd.n13 vdd.t42 96.7659
R78 vdd.n0 vdd.n11 10.4517
R79 vdd.n5 vdd.n3 5.0005
R80 vdd.n11 vdd.n5 7.29425
R81 vdd.n11 vdd.n6 8.60206
R82 vdd.n6 vdd.n7 1.19269
R83 vdd.n7 vdd.n8 2.55831
R84 vdd.n8 vdd.n9 1.19269
R85 vdd.n9 vdd.n10 2.55831
R86 vdd.n10 vdd.t4 1967.95
R87 vdd.n10 vdd.t5 162.504
R88 vdd.n9 vdd.t24 1966.76
R89 vdd.n8 vdd.t25 162.504
R90 vdd.n7 vdd.t2 1966.76
R91 vdd.n6 vdd.t3 162.504
R92 vdd.n5 vdd.n4 28.6288
R93 vdd.n4 vdd.t35 886.304
R94 vdd.n4 vdd.t36 96.7659
R95 vdd.n3 vdd.n2 28.6288
R96 vdd.n2 vdd.t26 886.304
R97 vdd.n2 vdd.t27 96.7659
R98 vdd.n3 vdd.n1 33.6288
R99 vdd.n1 vdd.t6 886.304
R100 vdd.n1 vdd.t7 96.7659
R101 a_0_n11917.t2 a_0_n11917.n0 357.127
R102 a_0_n11917.n0 a_0_n11917.n4 10.7108
R103 a_0_n11917.n4 a_0_n11917.t6 536.716
R104 a_0_n11917.n4 a_0_n11917.n1 5.9005
R105 a_0_n11917.n1 a_0_n11917.n3 20.0667
R106 a_0_n11917.n3 a_0_n11917.t0 160.169
R107 a_0_n11917.n3 a_0_n11917.t3 162.169
R108 a_0_n11917.n1 a_0_n11917.n2 13.1695
R109 a_0_n11917.n2 a_0_n11917.t5 388.462
R110 a_0_n11917.n2 a_0_n11917.t4 388.147
R111 a_0_n11917.n0 a_0_n11917.t1 90.9415
R112 we we.n0 0.09425
R113 we.n0 we.n1 16.2505
R114 we.n1 we.t2 790.702
R115 we.n1 we.t0 775.702
R116 we.n0 we.t1 518.635
R117 we.t1 we.t3 809.76
R118 a_11200_n23917.t0 a_11200_n23917.t1 173.665
R119 vss vss.n0 0.063
R120 vss.n0 vss.n1 7.7005
R121 vss.n1 vss.n79 26.763
R122 vss.n79 vss.n26 10.7665
R123 vss.n79 vss.n2 1.71425
R124 vss.n2 vss.n78 4.24475
R125 vss.n78 vss.n3 22.5626
R126 vss.n3 vss.n77 1182.18
R127 vss.n76 vss.n77 309.524
R128 vss.n77 vss.t7 714.287
R129 vss.n47 vss.n4 1202.1
R130 vss.n48 vss.n5 1203.06
R131 vss.t42 vss.n6 74.0998
R132 vss.n76 vss.t42 75.3145
R133 vss.n4 vss.n76 13.7676
R134 vss.n4 vss.t43 48.5902
R135 vss.t43 vss.t30 105.278
R136 vss.n5 vss.t30 89.0816
R137 vss.n5 vss.n7 2281.84
R138 vss.n75 vss.n7 5807.5
R139 vss.n8 vss.t17 714.287
R140 vss.t17 vss.n75 247.619
R141 vss.t7 vss.n7 5811.71
R142 vss.n7 vss.t0 3820.19
R143 vss.n8 vss.t0 2053.43
R144 vss.n9 vss.n8 1182.18
R145 vss.n9 vss.t18 98.3331
R146 vss.n74 vss.n9 22.5626
R147 vss.n2 vss.n74 10.9498
R148 vss.n74 vss.n10 22.5626
R149 vss.n10 vss.t25 98.3331
R150 vss.n10 vss.n73 1182.18
R151 vss.n6 vss.t6 1873.04
R152 vss.n11 vss.t6 860.409
R153 vss.n11 vss.t15 198.556
R154 vss.t15 vss.n13 680.385
R155 vss.n13 vss.n7 1859.15
R156 vss.n7 vss.t29 1696.33
R157 vss.n73 vss.t29 860.409
R158 vss.n73 vss.t24 198.556
R159 vss.t24 vss.n75 4194.67
R160 vss.n31 vss.n15 764.122
R161 vss.n15 vss.n14 2455.96
R162 vss.n72 vss.n14 688.819
R163 vss.n72 vss.n6 2781.45
R164 vss.n33 vss.n32 558.067
R165 vss.n34 vss.n33 1098.17
R166 vss.n72 vss.n34 1397.73
R167 vss.n35 vss.n72 362.267
R168 vss.n6 vss.n36 1420.7
R169 vss.n53 vss.n52 328.325
R170 vss.n52 vss.n54 904.817
R171 vss.n54 vss.n37 1072.45
R172 vss.n37 vss.n71 1466.28
R173 vss.n35 vss.n71 383.43
R174 vss.n36 vss.n35 226.511
R175 vss.n66 vss.n55 1200.93
R176 vss.n67 vss.n56 1200.93
R177 vss.n55 vss.t5 7862.54
R178 vss.n55 vss.n71 9465.29
R179 vss.n71 vss.t36 816.495
R180 vss.t36 vss.n56 7862.54
R181 vss.n56 vss.t1 9389.69
R182 vss.t1 vss.n68 9957.07
R183 vss.n57 vss.t5 68895.5
R184 vss.n58 vss.n57 255.892
R185 vss.n58 vss.t11 498.49
R186 vss.t11 vss.n54 172.81
R187 vss.n59 vss.n58 1182.18
R188 vss.n59 vss.t12 98.3331
R189 vss.n70 vss.n59 29.8053
R190 vss.n70 vss.n65 5.0005
R191 vss.n69 vss.n70 2.00362
R192 vss.n69 vss.n66 4.50519
R193 vss.n66 vss.n67 3.7505
R194 vss.n67 vss.n68 2.2505
R195 vss.n0 vss.n69 11.6899
R196 vss.n68 vss.t2 328.7
R197 vss.n65 vss.n60 29.8053
R198 vss.n60 vss.n64 1182.18
R199 vss.n64 vss.n63 255.892
R200 vss.n64 vss.t9 498.49
R201 vss.t9 vss.n53 172.81
R202 vss.n63 vss.n57 50600
R203 vss.n63 vss.n61 51905.6
R204 vss.n61 vss.t3 2543.35
R205 vss.n53 vss.t3 1704.82
R206 vss.n62 vss.n61 1182.18
R207 vss.n62 vss.t4 98.3331
R208 vss.n65 vss.n62 34.8053
R209 vss.n60 vss.t10 98.3321
R210 vss.n38 vss.n52 78100
R211 vss.n38 vss.n39 196902
R212 vss.n39 vss.t22 2543.35
R213 vss.n51 vss.t22 881.697
R214 vss.n51 vss.n32 6505.98
R215 vss.n32 vss.n31 7541.55
R216 vss.n40 vss.n38 216.012
R217 vss.n40 vss.t32 498.49
R218 vss.t32 vss.n51 172.81
R219 vss.n41 vss.n40 1182.18
R220 vss.n41 vss.t33 98.3331
R221 vss.n50 vss.n41 30.9817
R222 vss.n49 vss.n50 13.8786
R223 vss.n49 vss.n43 0.130188
R224 vss.n43 vss.n44 2.78956
R225 vss.n44 vss.n46 0.961438
R226 vss.n46 vss.n47 11.2505
R227 vss.n47 vss.n48 2.78956
R228 vss.n1 vss.n49 10.3974
R229 vss.n48 vss.t31 92.2694
R230 vss.n45 vss.t19 6652.92
R231 vss.n45 vss.n35 4891.41
R232 vss.n35 vss.t34 6600
R233 vss.n46 vss.t34 7855.02
R234 vss.n43 vss.n45 1202.1
R235 vss.n44 vss.t35 92.2694
R236 vss.n50 vss.n42 35.9817
R237 vss.n42 vss.n39 1182.18
R238 vss.n42 vss.t23 98.3321
R239 vss.n52 vss.n33 196856
R240 vss.n37 vss.n34 2476.6
R241 vss.n36 vss.t1 254.149
R242 vss.n16 vss.n31 1690.33
R243 vss.n16 vss.t37 2543.35
R244 vss.t37 vss.n17 90928.2
R245 vss.t40 vss.t39 127.493
R246 vss.t39 vss.n17 27449.9
R247 vss.n18 vss.t40 14946.8
R248 vss.n18 vss.n15 4642.94
R249 vss.n15 vss.n30 27331.3
R250 vss.n25 vss.n30 10238.6
R251 vss.n30 vss.t13 14194.2
R252 vss.n30 vss.n19 90046.5
R253 vss.t20 vss.t28 127.493
R254 vss.t28 vss.n19 60143
R255 vss.n20 vss.t20 14946.8
R256 vss.n20 vss.n14 4642.94
R257 vss.n14 vss.n29 27331.3
R258 vss.n21 vss.n29 10238.6
R259 vss.n29 vss.t26 14194.2
R260 vss.n29 vss.n13 16708.8
R261 vss.n19 vss.n17 1427.11
R262 vss.n13 vss.n19 1007.23
R263 vss.n21 vss.t27 98.3331
R264 vss.n28 vss.n21 31.9367
R265 vss.n26 vss.n24 4.48488
R266 vss.n26 vss.n28 5.51612
R267 vss.n27 vss.n20 1173.1
R268 vss.n28 vss.n27 34.4013
R269 vss.n27 vss.t21 24.8661
R270 vss.n26 vss.n25 27.4523
R271 vss.n25 vss.t14 98.3321
R272 vss.n23 vss.n18 1173.1
R273 vss.n24 vss.n23 34.4013
R274 vss.n23 vss.t41 24.8661
R275 vss.n24 vss.n22 32.9679
R276 vss.n22 vss.n16 1182.18
R277 vss.n22 vss.t38 98.3321
R278 vss.n12 vss.n11 1182.18
R279 vss.n12 vss.t16 98.3331
R280 vss.n78 vss.n12 22.5626
R281 vss.n3 vss.t8 98.3321
R282 a_6400_83.t1 a_6400_83.n0 243.772
R283 a_6400_83.n1 a_6400_83.t2 474.57
R284 a_6400_83.n1 a_6400_83.t3 474.57
R285 a_6400_83.n0 a_6400_83.n1 66.2113
R286 a_6400_83.n0 a_6400_83.t0 87.4532
R287 a_1600_n11917.t5 a_1600_n11917.n0 358.303
R288 a_1600_n11917.n0 a_1600_n11917.n4 8.00831
R289 a_1600_n11917.n4 a_1600_n11917.t6 538.716
R290 a_1600_n11917.n4 a_1600_n11917.n1 5.9005
R291 a_1600_n11917.n1 a_1600_n11917.n3 20.3517
R292 a_1600_n11917.n3 a_1600_n11917.t1 162.274
R293 a_1600_n11917.n3 a_1600_n11917.t0 163.475
R294 a_1600_n11917.n1 a_1600_n11917.n2 13.0373
R295 a_1600_n11917.n2 a_1600_n11917.t3 388.151
R296 a_1600_n11917.n2 a_1600_n11917.t2 388.151
R297 a_1600_n11917.n0 a_1600_n11917.t4 92.118
R298 a_19896_8041.t1 a_19896_8041.n0 173.365
R299 a_19896_8041.n0 a_19896_8041.t0 157.859
R300 a_19896_8041.n0 a_19896_8041.n1 18.9927
R301 a_19896_8041.n1 a_19896_8041.t2 161.6
R302 a_19896_8041.n1 a_19896_8041.t3 522.378
R303 a_19896_8041.t3 a_19896_8041.t4 809.76
R304 a_n104_n35959.t0 a_n104_n35959.n1 160.689
R305 a_n104_n35959.n1 a_n104_n35959.n0 11.2161
R306 a_n104_n35959.n1 a_n104_n35959.t1 156.94
R307 a_n104_n35959.n0 a_n104_n35959.t2 142.284
R308 a_n104_n35959.n0 a_n104_n35959.t3 541.126
R309 a_n104_n35959.t3 a_n104_n35959.t4 809.76
R310 a_9600_n35917.n0 a_9600_n35917.t0 233.036
R311 a_9600_n35917.t0 a_9600_n35917.n0 191.975
R312 a_9600_n35917.n0 a_9600_n35917.n1 41.6317
R313 a_9600_n35917.n1 a_9600_n35917.t1 252.34
R314 a_9600_n35917.n1 a_9600_n35917.t2 143.143
R315 en en.n0 0.09425
R316 en.n0 en.t0 786.543
R317 en.t0 en.t2 1066.83
R318 en.n0 en.t3 776.543
R319 en.t3 en.t1 1066.83
R320 a_9600_83.t0 a_9600_83.t1 10.5005
R321 a_9600_169.n0 a_9600_169.n1 87.4731
R322 a_9600_169.t1 a_9600_169.n0 10.5504
R323 a_9600_169.n0 a_9600_169.t3 596.885
R324 a_9600_169.n1 a_9600_169.t0 223.06
R325 a_9600_169.t3 a_9600_169.t4 809.76
R326 a_9600_169.n1 a_9600_169.t2 171.107
R327 a a.n0 0.09425
R328 a.n0 a.t2 891.894
R329 a.t2 a.t1 1066.83
R330 a.n0 a.t3 517.458
R331 a.t3 a.t0 809.76
R332 a_0_83.t1 a_0_83.n0 243.772
R333 a_0_83.n0 a_0_83.t2 929.572
R334 a_0_83.t2 a_0_83.t3 1066.83
R335 a_0_83.n0 a_0_83.t0 87.4532
R336 a_3200_169.n0 a_3200_169.n1 87.4731
R337 a_3200_169.t2 a_3200_169.n0 10.5504
R338 a_3200_169.n0 a_3200_169.t3 594.533
R339 a_3200_169.n1 a_3200_169.t0 223.06
R340 a_3200_169.t3 a_3200_169.t4 809.76
R341 a_3200_169.n1 a_3200_169.t1 171.107
R342 sa_en sa_en.n0 0.09425
R343 sa_en.n0 sa_en.t0 659.595
R344 sa_en.n0 sa_en.t1 228.804
R345 a_20000_14483.t0 a_20000_14483.n0 173.365
R346 a_20000_14483.n0 a_20000_14483.t1 157.859
R347 a_20000_14483.n0 a_20000_14483.n1 17.7244
R348 a_20000_14483.n1 a_20000_14483.t3 520.534
R349 a_20000_14483.t3 a_20000_14483.t4 809.76
R350 a_20000_14483.n1 a_20000_14483.t2 161.103
R351 a_19896_16041.t2 a_19896_16041.n0 173.365
R352 a_19896_16041.n0 a_19896_16041.t1 157.859
R353 a_19896_16041.n0 a_19896_16041.n1 18.9927
R354 a_19896_16041.n1 a_19896_16041.t0 161.6
R355 a_19896_16041.n1 a_19896_16041.t4 522.378
R356 a_19896_16041.t4 a_19896_16041.t3 809.76
R357 a_12800_83.t1 a_12800_83.n0 243.772
R358 a_12800_83.n1 a_12800_83.t3 474.57
R359 a_12800_83.n1 a_12800_83.t2 474.57
R360 a_12800_83.n0 a_12800_83.n1 70.3078
R361 a_12800_83.n0 a_12800_83.t0 87.4532
R362 a_20000_6483.t1 a_20000_6483.n0 173.365
R363 a_20000_6483.n0 a_20000_6483.t0 157.859
R364 a_20000_6483.n0 a_20000_6483.n1 17.7244
R365 a_20000_6483.n1 a_20000_6483.t3 520.534
R366 a_20000_6483.t3 a_20000_6483.t4 809.76
R367 a_20000_6483.n1 a_20000_6483.t2 161.103
R368 a_3200_n23917.t1 a_3200_n23917.n0 243.772
R369 a_3200_n23917.n0 a_3200_n23917.n1 53.8552
R370 a_3200_n23917.n1 a_3200_n23917.t2 1050.12
R371 a_3200_n23917.n1 a_3200_n23917.t3 1035.12
R372 a_3200_n23917.n0 a_3200_n23917.t0 87.4532
R373 a_9600_n36000.t1 a_9600_n36000.n1 155.762
R374 a_9600_n36000.n1 a_9600_n36000.n0 0.178625
R375 a_9600_n36000.n1 a_9600_n36000.t3 653.092
R376 a_9600_n36000.n0 a_9600_n36000.t0 649.52
R377 a_9600_n36000.n0 a_9600_n36000.t2 152.144
R378 a_0_n35917.t1 a_0_n35917.n0 243.772
R379 a_0_n35917.n0 a_0_n35917.t2 581.902
R380 a_0_n35917.t2 a_0_n35917.t3 809.76
R381 a_0_n35917.n0 a_0_n35917.t0 87.4532
R382 a_3200_n35917.t1 a_3200_n35917.n0 243.772
R383 a_3200_n35917.n0 a_3200_n35917.t3 584.254
R384 a_3200_n35917.t3 a_3200_n35917.t2 809.76
R385 a_3200_n35917.n0 a_3200_n35917.t0 87.4532
R386 a_3200_83.t0 a_3200_83.t1 10.5005
R387 din din.n0 0.09425
R388 din.n0 din.n1 28.7505
R389 din.n1 din.t3 778.274
R390 din.n1 din.t2 1031.59
R391 din.n0 din.t0 517.458
R392 din.t0 din.t1 809.76
R393 a_0_n23917.t1 a_0_n23917.n0 243.772
R394 a_0_n23917.n0 a_0_n23917.n1 61.4287
R395 a_0_n23917.n1 a_0_n23917.t2 780.628
R396 a_0_n23917.n1 a_0_n23917.t3 1033.94
R397 a_0_n23917.n0 a_0_n23917.t0 87.4532
R398 dout dout.n0 55.0751
R399 dout.n0 dout.t1 243.772
R400 dout.n0 dout.t0 87.4532
R401 a_16000_n24000.t0 a_16000_n24000.t1 710.574
R402 a_6400_n24000.t0 a_6400_n24000.t1 705.87
R403 a_20800_n23917.t0 a_20800_n23917.t1 178.37
CMODEL0 a_9600_n36000.t1 vss 0.123834891840801f
CMODEL1 a_9600_n36000.t2 vss 0.162045842707831f
CMODEL2 a_9600_n36000.t0 vss 0.050035955646245f
CMODEL3 a_9600_n36000.n0 vss 2.56864602970831f
CMODEL4 a_9600_n36000.t3 vss 0.0535423033622669f
CMODEL5 a_9600_n36000.n1 vss 1.28473497673455f
CMODEL6 a_9600_n35917.t0 vss 0.0554199602903479f
CMODEL7 a_9600_n35917.n0 vss 0.304212371216764f
CMODEL8 a_9600_n35917.t2 vss 0.112474422304769f
CMODEL9 a_9600_n35917.n1 vss 3.55803783635424f
CMODEL10 a_9600_n35917.t1 vss 0.0590954098338814f
CMODEL11 dout vss 1.00347847169054f
CMODEL12 dout.n0 vss 0.430265305702608f
CMODEL13 dout.t0 vss 0.0721275827476623f
CMODEL14 dout.t1 vss 0.317708639859185f
CMODEL15 a_3200_n35917.t1 vss 0.226197834895805f
CMODEL16 a_3200_n35917.n0 vss 2.93407982057808f
CMODEL17 a_3200_n35917.t0 vss 0.0513524172698856f
CMODEL18 a_3200_n35917.t3 vss 0.377982816252566f
CMODEL19 a_3200_n35917.t2 vss 0.0863571110036596f
CMODEL20 a_n104_n35959.t0 vss 0.152998424080034f
CMODEL21 a_n104_n35959.t3 vss 0.133518067480185f
CMODEL22 a_n104_n35959.t4 vss 0.0535324154766194f
CMODEL23 a_n104_n35959.t2 vss 0.0732703676548568f
CMODEL24 a_n104_n35959.n0 vss 5.46957981943717f
CMODEL25 a_n104_n35959.t1 vss 0.135595148142012f
CMODEL26 a_n104_n35959.n1 vss 2.55511575772912f
CMODEL27 a_0_n35917.t1 vss 0.227563232506142f
CMODEL28 a_0_n35917.n0 vss 2.8344614221107f
CMODEL29 a_0_n35917.t0 vss 0.0516623502987025f
CMODEL30 a_0_n35917.t2 vss 0.362364466748895f
CMODEL31 a_0_n35917.t3 vss 0.0868785283355643f
CMODEL32 sa_en vss 0.0109747042362131f
CMODEL33 sa_en.t1 vss 0.0743626977060658f
CMODEL34 sa_en.n0 vss 3.2582813649237f
CMODEL35 sa_en.t0 vss 0.0911012331340242f
CMODEL36 a_20800_n23917.t0 vss 1.87078873731988f
CMODEL37 a_20800_n23917.t1 vss 1.87008126268012f
CMODEL38 a_16000_n24000.t0 vss 1.45988367543653f
CMODEL39 a_16000_n24000.t1 vss 1.45959632456347f
CMODEL40 a_11200_n23917.t0 vss 1.50716396884595f
CMODEL41 a_11200_n23917.t1 vss 1.50652603115405f
CMODEL42 a_6400_n24000.t0 vss 1.17971328991049f
CMODEL43 a_6400_n24000.t1 vss 1.17945671008951f
CMODEL44 we vss 0.00784447129838387f
CMODEL45 we.t1 vss 0.0448496050397835f
CMODEL46 we.t3 vss 0.045694152745167f
CMODEL47 we.n0 vss 1.56132577920174f
CMODEL48 we.t0 vss 0.0553832109477389f
CMODEL49 we.n1 vss 4.26376004189076f
CMODEL50 we.t2 vss 0.0833427388764314f
CMODEL51 a_3200_n23917.t1 vss 0.151625363154269f
CMODEL52 a_3200_n23917.n0 vss 0.216504322968656f
CMODEL53 a_3200_n23917.t0 vss 0.0344226676279924f
CMODEL54 a_3200_n23917.t3 vss 0.100141919147837f
CMODEL55 a_3200_n23917.n1 vss 5.11701653853717f
CMODEL56 a_3200_n23917.t2 vss 0.128239188564079f
CMODEL57 din vss 0.00914937507665365f
CMODEL58 din.t0 vss 0.0515076925184528f
CMODEL59 din.t1 vss 0.0532950265447546f
CMODEL60 din.n0 vss 3.00028411030679f
CMODEL61 din.t2 vss 0.090780257037938f
CMODEL62 din.n1 vss 3.95491507931919f
CMODEL63 din.t3 vss 0.0668384591962148f
CMODEL64 a_0_n23917.t1 vss 0.13106558198853f
CMODEL65 a_0_n23917.n0 vss 0.438713873265466f
CMODEL66 a_0_n23917.t0 vss 0.0297550816569583f
CMODEL67 a_0_n23917.t3 vss 0.0860764468458524f
CMODEL68 a_0_n23917.n1 vss 3.60939899357776f
CMODEL69 a_0_n23917.t2 vss 0.0642100226654283f
CMODEL70 pc_b vss 0.0146210385767942f
CMODEL71 pc_b.t0 vss 0.0446107677518642f
CMODEL72 pc_b.n0 vss 0.820139193127584f
CMODEL73 pc_b.t1 vss 0.0446107677518642f
CMODEL74 pc_b.n1 vss 2.0248677897928f
CMODEL75 pc_b.t2 vss 0.04991044299909f
CMODEL76 a_9600_83.t0 vss 0.0112149f
CMODEL77 a_9600_83.t1 vss 0.0112149f
CMODEL78 a_3200_83.t0 vss 0.0112149f
CMODEL79 a_3200_83.t1 vss 0.0112149f
CMODEL80 a vss 0.010935799591037f
CMODEL81 a.t3 vss 0.0615648154633281f
CMODEL82 a.t0 vss 0.0637011102941773f
CMODEL83 a.n0 vss 3.88923080019432f
CMODEL84 a.t2 vss 0.121520823493213f
CMODEL85 a.t1 vss 0.0746366509639246f
CMODEL86 a_0_83.t1 vss 0.205714930658285f
CMODEL87 a_0_83.n0 vss 2.0323387104634f
CMODEL88 a_0_83.t0 vss 0.0467023606819066f
CMODEL89 a_0_83.t2 vss 0.214143701885648f
CMODEL90 a_0_83.t3 vss 0.0920202963107599f
CMODEL91 a_9600_169.t1 vss 0.120095385823275f
CMODEL92 a_9600_169.n0 vss 2.26123403330171f
CMODEL93 a_9600_169.t2 vss 0.175327339198983f
CMODEL94 a_9600_169.t3 vss 0.365966087150939f
CMODEL95 a_9600_169.t4 vss 0.0779436817218657f
CMODEL96 a_9600_169.t0 vss 0.19494494721025f
CMODEL97 a_9600_169.n1 vss 0.176258525592976f
CMODEL98 en vss 0.00853318215189031f
CMODEL99 en.t3 vss 0.0647026584899287f
CMODEL100 en.t1 vss 0.058239150470204f
CMODEL101 en.n0 vss 2.32737861617664f
CMODEL102 en.t0 vss 0.0796472422411344f
CMODEL103 en.t2 vss 0.058239150470204f
CMODEL104 a_3200_169.t2 vss 0.102162764641537f
CMODEL105 a_3200_169.n0 vss 1.8358661488846f
CMODEL106 a_3200_169.t1 vss 0.149147718872781f
CMODEL107 a_3200_169.t3 vss 0.295833214695178f
CMODEL108 a_3200_169.t4 vss 0.066304854708284f
CMODEL109 a_3200_169.t0 vss 0.165835946285837f
CMODEL110 a_3200_169.n1 vss 0.14993935191178f
CMODEL111 a_6400_83.t1 vss 0.102028241450873f
CMODEL112 a_6400_83.n0 vss 1.15097450786502f
CMODEL113 a_6400_83.t0 vss 0.0231628771393179f
CMODEL114 a_6400_83.t3 vss 0.022844088907078f
CMODEL115 a_6400_83.t2 vss 0.022844088907078f
CMODEL116 a_6400_83.n1 vss 8.41242619573063f
CMODEL117 a_19896_8041.t1 vss 0.227895059808692f
CMODEL118 a_19896_8041.t0 vss 0.107899223545133f
CMODEL119 a_19896_8041.n0 vss 0.3232595133535f
CMODEL120 a_19896_8041.t3 vss 0.107725038068313f
CMODEL121 a_19896_8041.t4 vss 0.100800117857541f
CMODEL122 a_19896_8041.t2 vss 0.101366968876609f
CMODEL123 a_19896_8041.n1 vss 3.06159407849021f
CMODEL124 a_20000_6483.t1 vss 0.264636837770145f
CMODEL125 a_20000_6483.t0 vss 0.125295170822678f
CMODEL126 a_20000_6483.n0 vss 0.34009429856903f
CMODEL127 a_20000_6483.t2 vss 0.113594963976292f
CMODEL128 a_20000_6483.t3 vss 0.119666735239244f
CMODEL129 a_20000_6483.t4 vss 0.117051254131448f
CMODEL130 a_20000_6483.n1 vss 2.98311073949116f
CMODEL131 a_1600_n11917.t5 vss 0.0669342642226639f
CMODEL132 a_1600_n11917.t4 vss 0.106393787806727f
CMODEL133 a_1600_n11917.n0 vss 1.85219517192402f
CMODEL134 a_1600_n11917.t6 vss 0.196417253989695f
CMODEL135 a_1600_n11917.n1 vss 10.9118269957379f
CMODEL136 a_1600_n11917.t2 vss 0.0137191832791459f
CMODEL137 a_1600_n11917.t3 vss 0.0137191832791459f
CMODEL138 a_1600_n11917.n2 vss 3.32799803203974f
CMODEL139 a_1600_n11917.t1 vss 0.0484684620116736f
CMODEL140 a_1600_n11917.t0 vss 0.0666177779562203f
CMODEL141 a_1600_n11917.n3 vss 9.23441007389225f
CMODEL142 a_1600_n11917.n4 vss 13.5390998138608f
CMODEL143 a_0_n11917.t2 vss 0.0812185667852036f
CMODEL144 a_0_n11917.t1 vss 0.127055190491774f
CMODEL145 a_0_n11917.n0 vss 3.4645649969805f
CMODEL146 a_0_n11917.t6 vss 0.216469767119322f
CMODEL147 a_0_n11917.n1 vss 13.4314368182111f
CMODEL148 a_0_n11917.t4 vss 0.0171849702863132f
CMODEL149 a_0_n11917.t5 vss 0.0173504671279327f
CMODEL150 a_0_n11917.n2 vss 4.36341526781953f
CMODEL151 a_0_n11917.t0 vss 0.0343910472687764f
CMODEL152 a_0_n11917.t3 vss 0.0617617531005184f
CMODEL153 a_0_n11917.n3 vss 9.57577745644826f
CMODEL154 a_0_n11917.n4 vss 17.4425736983608f
CMODEL155 a_12800_83.t1 vss 0.0882605072356663f
CMODEL156 a_12800_83.n0 vss 1.22910419969751f
CMODEL157 a_12800_83.t0 vss 0.0200373161096969f
CMODEL158 a_12800_83.t2 vss 0.0197614947508154f
CMODEL159 a_12800_83.t3 vss 0.0197614947508154f
CMODEL160 a_12800_83.n1 vss 8.3040849874555f
CMODEL161 a_19896_16041.t2 vss 0.209340783157665f
CMODEL162 a_19896_16041.t1 vss 0.0991143350007962f
CMODEL163 a_19896_16041.n0 vss 0.296941063337867f
CMODEL164 a_19896_16041.t4 vss 0.0989545268691188f
CMODEL165 a_19896_16041.t3 vss 0.0925930736274577f
CMODEL166 a_19896_16041.t0 vss 0.0931136607230737f
CMODEL167 a_19896_16041.n1 vss 2.81233255728402f
CMODEL168 a_20000_14483.t0 vss 0.219478298721679f
CMODEL169 a_20000_14483.t1 vss 0.103914153245734f
CMODEL170 a_20000_14483.n0 vss 0.282059777305864f
CMODEL171 a_20000_14483.t2 vss 0.0942109994654228f
CMODEL172 a_20000_14483.t3 vss 0.0992464957952992f
CMODEL173 a_20000_14483.t4 vss 0.0970771049174443f
CMODEL174 a_20000_14483.n1 vss 2.47406317054856f
CMODEL175 vdd vss 0.0341729826877495f
CMODEL176 vdd.n0 vss 11.4678170829525f
CMODEL177 vdd.n1 vss 1.06273130059874f
CMODEL178 vdd.t7 vss 0.0876077445049696f
CMODEL179 vdd.t6 vss 0.692493828758306f
CMODEL180 vdd.n2 vss 0.952993919918036f
CMODEL181 vdd.t27 vss 0.0876077445049696f
CMODEL182 vdd.t26 vss 0.692493828758306f
CMODEL183 vdd.n3 vss 1.78746344402956f
CMODEL184 vdd.n4 vss 0.952993919918036f
CMODEL185 vdd.t36 vss 0.0876077445049696f
CMODEL186 vdd.t35 vss 0.692493828758306f
CMODEL187 vdd.n5 vss 1.35977253520766f
CMODEL188 vdd.t3 vss 0.139553849540466f
CMODEL189 vdd.n6 vss 1.3351849421981f
CMODEL190 vdd.t2 vss 1.74985180942258f
CMODEL191 vdd.n7 vss 1.78987084543389f
CMODEL192 vdd.t25 vss 0.139553849540466f
CMODEL193 vdd.n8 vss 0.806463421107823f
CMODEL194 vdd.t24 vss 1.74985180942258f
CMODEL195 vdd.n9 vss 1.78987084543389f
CMODEL196 vdd.t5 vss 0.139553849540466f
CMODEL197 vdd.n10 vss 2.3880137983537f
CMODEL198 vdd.t4 vss 1.75081476998431f
CMODEL199 vdd.n11 vss 5.77381523208867f
CMODEL200 vdd.n12 vss 14.2360879577914f
CMODEL201 vdd.n13 vss 1.07907755613414f
CMODEL202 vdd.t42 vss 0.0876077445049696f
CMODEL203 vdd.t41 vss 0.692493828758306f
CMODEL204 vdd.n14 vss 0.970174741273604f
CMODEL205 vdd.t9 vss 0.0876077445049696f
CMODEL206 vdd.t8 vss 0.692493828758306f
CMODEL207 vdd.n15 vss 1.86260646653005f
CMODEL208 vdd.t15 vss 0.147540002465763f
CMODEL209 vdd.n16 vss 1.16051994564262f
CMODEL210 vdd.t14 vss 1.99022281497358f
CMODEL211 vdd.n17 vss 1.62563792163051f
CMODEL212 vdd.t32 vss 1.99022281497358f
CMODEL213 vdd.n18 vss 1.60472562809823f
CMODEL214 vdd.t34 vss 0.147540002465763f
CMODEL215 vdd.n19 vss 1.6159762173278f
CMODEL216 vdd.t33 vss 1.99022281497358f
CMODEL217 vdd.n20 vss 3.2249147978836f
CMODEL218 vdd.t48 vss 1.99402650919242f
CMODEL219 vdd.n21 vss 5.72457584869878f
CMODEL220 vdd.n22 vss 25.087209047668f
CMODEL221 vdd.t47 vss 0.0283629601385397f
CMODEL222 vdd.t45 vss 0.0280717448153293f
CMODEL223 vdd.n23 vss 0.320547101920796f
CMODEL224 vdd.t46 vss 0.765003154122453f
CMODEL225 vdd.n24 vss 0.821926962794968f
CMODEL226 vdd.t44 vss 0.765003154122453f
CMODEL227 vdd.n25 vss 1.29625726149009f
CMODEL228 vdd.t43 vss 0.766660248755767f
CMODEL229 vdd.n26 vss 6.93570739653176f
CMODEL230 vdd.n27 vss 4.63666312941075f
CMODEL231 vdd.n28 vss 1.04733998095373f
CMODEL232 vdd.t29 vss 0.0876077445049696f
CMODEL233 vdd.t28 vss 0.692493828758306f
CMODEL234 vdd.n29 vss 0.156341461999993f
CMODEL235 vdd.n30 vss 0.04987638180148f
CMODEL236 vdd.t38 vss 0.022964201995903f
CMODEL237 vdd.t40 vss 0.022964201995903f
CMODEL238 vdd.t37 vss 0.464037855224476f
CMODEL239 vdd.t39 vss 0.464037855224476f
CMODEL240 vdd.n31 vss 0.150290859803777f
CMODEL241 vdd.n32 vss 1.81369609466541f
CMODEL242 vdd.n33 vss 0.919001412088898f
CMODEL243 vdd.t17 vss 0.0876077445049696f
CMODEL244 vdd.t16 vss 0.692493828758306f
CMODEL245 vdd.n34 vss 0.156341461999993f
CMODEL246 vdd.n35 vss 0.04987638180148f
CMODEL247 vdd.t1 vss 0.022964201995903f
CMODEL248 vdd.t31 vss 0.022964201995903f
CMODEL249 vdd.t0 vss 0.464037855224476f
CMODEL250 vdd.t30 vss 0.464037855224476f
CMODEL251 vdd.n36 vss 0.150290859803777f
CMODEL252 vdd.n37 vss 1.75892771271691f
CMODEL253 vdd.n38 vss 1.01463142054023f
CMODEL254 vdd.t19 vss 0.0876077445049696f
CMODEL255 vdd.t18 vss 0.692493828758306f
CMODEL256 vdd.n39 vss 0.856208358792626f
CMODEL257 vdd.t21 vss 0.0876085469721044f
CMODEL258 vdd.t20 vss 0.692493828758306f
CMODEL259 vdd.n40 vss 0.856208358792626f
CMODEL260 vdd.t11 vss 0.0876077445049696f
CMODEL261 vdd.t10 vss 0.692493828758306f
CMODEL262 vdd.n41 vss 3.68356488876519f
CMODEL263 vdd.n42 vss 7.05586080062187f
CMODEL264 vdd.n43 vss 0.856208358792626f
CMODEL265 vdd.t13 vss 0.0876077445049696f
CMODEL266 vdd.t12 vss 0.692493828758306f
CMODEL267 vdd.n44 vss 0.856208358792626f
CMODEL268 vdd.t23 vss 0.0876077445049696f
CMODEL269 vdd.t22 vss 0.692493828758306f
CMODEL270 vdd.n45 vss 1.05695353722835f
CMODEL271 vdd.n46 vss 17.4461169903249f
CMODEL272 a_11200_n23917.t0 din 7.88409274549922e-05f
CMODEL273 a_11200_n23917.t0 din.t0 0.000443846078579024f
CMODEL274 a_11200_n23917.t0 din.t1 0.00045924768482261f
CMODEL275 a_11200_n23917.t0 din.n0 0.0258536981928583f
CMODEL276 a_11200_n23917.t0 din.t2 0.000782261039634996f
CMODEL277 a_11200_n23917.t0 din.n1 0.0340798328024499f
CMODEL278 a_11200_n23917.t0 din.t3 0.000575952572557509f
CMODEL279 a_11200_n23917.t1 din 7.88075564347662e-05f
CMODEL280 a_11200_n23917.t1 din.t0 0.000443658211731898f
CMODEL281 a_11200_n23917.t1 din.t1 0.000459053298933534f
CMODEL282 a_11200_n23917.t1 din.n0 0.0258427550911831f
CMODEL283 a_11200_n23917.t1 din.t2 0.000781929931797757f
CMODEL284 a_11200_n23917.t1 din.n1 0.0340654078226018f
CMODEL285 a_11200_n23917.t1 din.t3 0.00057570878895972f
CMODEL286 a vdd 1.61376619331574e-07f
CMODEL287 a vdd.n0 5.4154990475068e-05f
CMODEL288 a vdd.n1 5.0185840116892e-06f
CMODEL289 a vdd.t7 4.13714008070605e-07f
CMODEL290 a vdd.t6 3.27019487921535e-06f
CMODEL291 a vdd.n2 4.50036622337473e-06f
CMODEL292 a vdd.t27 4.13714008070605e-07f
CMODEL293 a vdd.t26 3.27019487921535e-06f
CMODEL294 a vdd.n3 8.44101934010195e-06f
CMODEL295 a vdd.n4 4.50036622337473e-06f
CMODEL296 a vdd.t36 4.13714008070605e-07f
CMODEL297 a vdd.t35 3.27019487921535e-06f
CMODEL298 a vdd.n5 6.42131524768542e-06f
CMODEL299 a vdd.t3 6.59021445664465e-07f
CMODEL300 a vdd.n6 6.30520414688867e-06f
CMODEL301 a vdd.t2 8.26340421952938e-06f
CMODEL302 a vdd.n7 8.45238792046717e-06f
CMODEL303 a vdd.t25 6.59021445664465e-07f
CMODEL304 a vdd.n8 3.80839863181187e-06f
CMODEL305 a vdd.t24 8.26340421952938e-06f
CMODEL306 a vdd.n9 8.45238792046717e-06f
CMODEL307 a vdd.t5 6.59021445664465e-07f
CMODEL308 a vdd.n10 1.12770253980089e-05f
CMODEL309 a vdd.t4 8.26795165167547e-06f
CMODEL310 a vdd.n11 2.72659484047214e-05f
CMODEL311 a vdd.n12 6.72277210370308e-05f
CMODEL312 a vdd.n13 5.09577667236902e-06f
CMODEL313 a vdd.t42 4.13714008070605e-07f
CMODEL314 a vdd.t41 3.27019487921535e-06f
CMODEL315 a vdd.n14 4.58149999191449e-06f
CMODEL316 a vdd.t9 4.13714008070605e-07f
CMODEL317 a vdd.t8 3.27019487921535e-06f
CMODEL318 a vdd.n15 8.79587062856825e-06f
CMODEL319 a vdd.t15 6.96734816262678e-07f
CMODEL320 a vdd.n16 5.4803757461243e-06f
CMODEL321 a vdd.t14 9.3985190737284e-06f
CMODEL322 a vdd.n17 7.67682336795208e-06f
CMODEL323 a vdd.t32 9.3985190737284e-06f
CMODEL324 a vdd.n18 7.57806829984623e-06f
CMODEL325 a vdd.t34 6.96734816262678e-07f
CMODEL326 a vdd.n19 7.63119746541967e-06f
CMODEL327 a vdd.t33 9.3985190737284e-06f
CMODEL328 a vdd.n20 1.5229160780905e-05f
CMODEL329 a vdd.t48 9.41648143070544e-06f
CMODEL330 a vdd.n21 2.70334230409848e-05f
CMODEL331 a vdd.n22 0.000118470460175209f
CMODEL332 a vdd.t47 1.3393968747816e-07f
CMODEL333 a vdd.t45 1.32564468206647e-07f
CMODEL334 a vdd.n23 1.5137340546822e-06f
CMODEL335 a vdd.t46 3.6126089407621e-06f
CMODEL336 a vdd.n24 3.88142281302444e-06f
CMODEL337 a vdd.t44 3.6126089407621e-06f
CMODEL338 a vdd.n25 6.12137420238311e-06f
CMODEL339 a vdd.t43 3.62043431358016e-06f
CMODEL340 a vdd.n26 3.27528042416539e-05f
CMODEL341 a vdd.n27 2.18959236786755e-05f
CMODEL342 a vdd.n28 4.94590088788758e-06f
CMODEL343 a vdd.t29 4.13714008070605e-07f
CMODEL344 a vdd.t28 3.27019487921535e-06f
CMODEL345 a vdd.n29 7.38298346077911e-07f
CMODEL346 a vdd.n30 2.35533490101204e-07f
CMODEL347 a vdd.t38 1.08444888103803e-07f
CMODEL348 a vdd.t40 1.08444888103803e-07f
CMODEL349 a vdd.t37 2.19134691877058e-06f
CMODEL350 a vdd.t39 2.19134691877058e-06f
CMODEL351 a vdd.n31 7.09725314093332e-07f
CMODEL352 a vdd.n32 8.56489897081493e-06f
CMODEL353 a vdd.n33 4.33984186861787e-06f
CMODEL354 a vdd.t17 4.13714008070605e-07f
CMODEL355 a vdd.t16 3.27019487921535e-06f
CMODEL356 a vdd.n34 7.38298346077911e-07f
CMODEL357 a vdd.n35 2.35533490101204e-07f
CMODEL358 a vdd.t1 1.08444888103803e-07f
CMODEL359 a vdd.t31 1.08444888103803e-07f
CMODEL360 a vdd.t0 2.19134691877058e-06f
CMODEL361 a vdd.t30 2.19134691877058e-06f
CMODEL362 a vdd.n36 7.09725314093332e-07f
CMODEL363 a vdd.n37 8.30626376750625e-06f
CMODEL364 a vdd.n38 4.79143977599216e-06f
CMODEL365 a vdd.t19 4.13714008070605e-07f
CMODEL366 a vdd.t18 3.27019487921535e-06f
CMODEL367 a vdd.n39 4.04331139742513e-06f
CMODEL368 a vdd.t21 4.13717797597394e-07f
CMODEL369 a vdd.t20 3.27019487921535e-06f
CMODEL370 a vdd.n40 4.04331139742513e-06f
CMODEL371 a vdd.t11 4.13714008070605e-07f
CMODEL372 a vdd.t10 3.27019487921535e-06f
CMODEL373 a vdd.n41 1.73950648168183e-05f
CMODEL374 a vdd.n42 3.33202100876819e-05f
CMODEL375 a vdd.n43 4.04331139742513e-06f
CMODEL376 a vdd.t13 4.13714008070605e-07f
CMODEL377 a vdd.t12 3.27019487921535e-06f
CMODEL378 a vdd.n44 4.04331139742513e-06f
CMODEL379 a vdd.t23 4.13714008070605e-07f
CMODEL380 a vdd.t22 3.27019487921535e-06f
CMODEL381 a vdd.n45 4.99129941881268e-06f
CMODEL382 a vdd.n46 8.23865860960109e-05f
CMODEL383 a.t3 vdd 9.08495232245016e-07f
CMODEL384 a.t3 vdd.n0 0.000304874094231614f
CMODEL385 a.t3 vdd.n1 2.82529133781937e-05f
CMODEL386 a.t3 vdd.t7 2.3290685193551e-06f
CMODEL387 a.t3 vdd.t6 1.84100799024356e-05f
CMODEL388 a.t3 vdd.n2 2.53355242799569e-05f
CMODEL389 a.t3 vdd.t27 2.3290685193551e-06f
CMODEL390 a.t3 vdd.t26 1.84100799024356e-05f
CMODEL391 a.t3 vdd.n3 4.75200549964068e-05f
CMODEL392 a.t3 vdd.n4 2.53355242799569e-05f
CMODEL393 a.t3 vdd.t36 2.3290685193551e-06f
CMODEL394 a.t3 vdd.t35 1.84100799024356e-05f
CMODEL395 a.t3 vdd.n5 3.61498109913809e-05f
CMODEL396 a.t3 vdd.t3 3.71006558331243e-06f
CMODEL397 a.t3 vdd.n6 3.54961451634469e-05f
CMODEL398 a.t3 vdd.t2 4.6520142550086e-05f
CMODEL399 a.t3 vdd.n7 4.75840562197685e-05f
CMODEL400 a.t3 vdd.t25 3.71006558331243e-06f
CMODEL401 a.t3 vdd.n8 2.14399831513423e-05f
CMODEL402 a.t3 vdd.t24 4.6520142550086e-05f
CMODEL403 a.t3 vdd.n9 4.75840562197685e-05f
CMODEL404 a.t3 vdd.t5 3.71006558331243e-06f
CMODEL405 a.t3 vdd.n10 6.34858001762129e-05f
CMODEL406 a.t3 vdd.t4 4.65457430394307e-05f
CMODEL407 a.t3 vdd.n11 0.000153497974061732f
CMODEL408 a.t3 vdd.n12 0.000378469100975216f
CMODEL409 a.t3 vdd.n13 2.86874816848196e-05f
CMODEL410 a.t3 vdd.t42 2.3290685193551e-06f
CMODEL411 a.t3 vdd.t41 1.84100799024356e-05f
CMODEL412 a.t3 vdd.n14 2.57922796773481e-05f
CMODEL413 a.t3 vdd.t9 2.3290685193551e-06f
CMODEL414 a.t3 vdd.t8 1.84100799024356e-05f
CMODEL415 a.t3 vdd.n15 4.95177465149362e-05f
CMODEL416 a.t3 vdd.t15 3.92237897494427e-06f
CMODEL417 a.t3 vdd.n16 3.08526430711454e-05f
CMODEL418 a.t3 vdd.t14 5.29104513653391e-05f
CMODEL419 a.t3 vdd.n17 4.32178927620343e-05f
CMODEL420 a.t3 vdd.t32 5.29104513653391e-05f
CMODEL421 a.t3 vdd.n18 4.26619354684324e-05f
CMODEL422 a.t3 vdd.t34 3.92237897494427e-06f
CMODEL423 a.t3 vdd.n19 4.29610345189427e-05f
CMODEL424 a.t3 vdd.t33 5.29104513653391e-05f
CMODEL425 a.t3 vdd.n20 8.57349721282581e-05f
CMODEL426 a.t3 vdd.t48 5.30115732982506e-05f
CMODEL427 a.t3 vdd.n21 0.000152188935706575f
CMODEL428 a.t3 vdd.n22 0.000666948215155678f
CMODEL429 a.t3 vdd.t47 7.54034679783924e-07f
CMODEL430 a.t3 vdd.t45 7.46292665131272e-07f
CMODEL431 a.t3 vdd.n23 8.52180555809069e-06f
CMODEL432 a.t3 vdd.t46 2.03377540826073e-05f
CMODEL433 a.t3 vdd.n24 2.18510843427355e-05f
CMODEL434 a.t3 vdd.t44 2.03377540826073e-05f
CMODEL435 a.t3 vdd.n25 3.44612453816884e-05f
CMODEL436 a.t3 vdd.t43 2.03818082580213e-05f
CMODEL437 a.t3 vdd.n26 0.000184387097830194f
CMODEL438 a.t3 vdd.n27 0.000123266569532018f
CMODEL439 a.t3 vdd.n28 2.78437322235013e-05f
CMODEL440 a.t3 vdd.t29 2.3290685193551e-06f
CMODEL441 a.t3 vdd.t28 1.84100799024356e-05f
CMODEL442 a.t3 vdd.n29 4.15636744755459e-06f
CMODEL443 a.t3 vdd.n30 1.32597307885918e-06f
CMODEL444 a.t3 vdd.t38 6.10507669647119e-07f
CMODEL445 a.t3 vdd.t40 6.10507669647119e-07f
CMODEL446 a.t3 vdd.t37 1.23365344753406e-05f
CMODEL447 a.t3 vdd.t39 1.23365344753406e-05f
CMODEL448 a.t3 vdd.n31 3.99551103950555e-06f
CMODEL449 a.t3 vdd.n32 4.82174549936379e-05f
CMODEL450 a.t3 vdd.n33 2.44318270060899e-05f
CMODEL451 a.t3 vdd.t17 2.3290685193551e-06f
CMODEL452 a.t3 vdd.t16 1.84100799024356e-05f
CMODEL453 a.t3 vdd.n34 4.15636744755459e-06f
CMODEL454 a.t3 vdd.n35 1.32597307885918e-06f
CMODEL455 a.t3 vdd.t1 6.10507669647119e-07f
CMODEL456 a.t3 vdd.t31 6.10507669647119e-07f
CMODEL457 a.t3 vdd.t0 1.23365344753406e-05f
CMODEL458 a.t3 vdd.t30 1.23365344753406e-05f
CMODEL459 a.t3 vdd.n36 3.99551103950555e-06f
CMODEL460 a.t3 vdd.n37 4.67614271621596e-05f
CMODEL461 a.t3 vdd.n38 2.69741689354272e-05f
CMODEL462 a.t3 vdd.t19 2.3290685193551e-06f
CMODEL463 a.t3 vdd.t18 1.84100799024356e-05f
CMODEL464 a.t3 vdd.n39 2.27624617634059e-05f
CMODEL465 a.t3 vdd.t21 2.32908985309622e-06f
CMODEL466 a.t3 vdd.t20 1.84100799024356e-05f
CMODEL467 a.t3 vdd.n40 2.27624617634059e-05f
CMODEL468 a.t3 vdd.t11 2.3290685193551e-06f
CMODEL469 a.t3 vdd.t10 1.84100799024356e-05f
CMODEL470 a.t3 vdd.n41 9.79282718657152e-05f
CMODEL471 a.t3 vdd.n42 0.000187581398888176f
CMODEL472 a.t3 vdd.n43 2.27624617634059e-05f
CMODEL473 a.t3 vdd.t13 2.3290685193551e-06f
CMODEL474 a.t3 vdd.t12 1.84100799024356e-05f
CMODEL475 a.t3 vdd.n44 2.27624617634059e-05f
CMODEL476 a.t3 vdd.t23 2.3290685193551e-06f
CMODEL477 a.t3 vdd.t22 1.84100799024356e-05f
CMODEL478 a.t3 vdd.n45 2.80993104421257e-05f
CMODEL479 a.t3 vdd.n46 0.000463808332205688f
CMODEL480 a.t0 vdd 9.40019953855727e-07f
CMODEL481 a.t0 vdd.n0 0.000315453204177209f
CMODEL482 a.t0 vdd.n1 2.92332875148176e-05f
CMODEL483 a.t0 vdd.t7 2.40988703559927e-06f
CMODEL484 a.t0 vdd.t6 1.90489083994449e-05f
CMODEL485 a.t0 vdd.n2 2.62146652170132e-05f
CMODEL486 a.t0 vdd.t27 2.40988703559927e-06f
CMODEL487 a.t0 vdd.t26 1.90489083994449e-05f
CMODEL488 a.t0 vdd.n3 4.9168997612193e-05f
CMODEL489 a.t0 vdd.n4 2.62146652170132e-05f
CMODEL490 a.t0 vdd.t36 2.40988703559927e-06f
CMODEL491 a.t0 vdd.t35 1.90489083994449e-05f
CMODEL492 a.t0 vdd.n5 3.74042069280189e-05f
CMODEL493 a.t0 vdd.t3 3.83880460198883e-06f
CMODEL494 a.t0 vdd.n6 3.6727858941147e-05f
CMODEL495 a.t0 vdd.t2 4.81343882732673e-05f
CMODEL496 a.t0 vdd.n7 4.92352196735708e-05f
CMODEL497 a.t0 vdd.t25 3.83880460198883e-06f
CMODEL498 a.t0 vdd.n8 2.21839490811515e-05f
CMODEL499 a.t0 vdd.t24 4.81343882732673e-05f
CMODEL500 a.t0 vdd.n9 4.92352196735708e-05f
CMODEL501 a.t0 vdd.t5 3.83880460198883e-06f
CMODEL502 a.t0 vdd.n10 6.56887530434972e-05f
CMODEL503 a.t0 vdd.t4 4.81608770978184e-05f
CMODEL504 a.t0 vdd.n11 0.000158824343126044f
CMODEL505 a.t0 vdd.n12 0.000391601952555533f
CMODEL506 a.t0 vdd.n13 2.96829353115728e-05f
CMODEL507 a.t0 vdd.t42 2.40988703559927e-06f
CMODEL508 a.t0 vdd.t41 1.90489083994449e-05f
CMODEL509 a.t0 vdd.n14 2.6687269995046e-05f
CMODEL510 a.t0 vdd.t9 2.40988703559927e-06f
CMODEL511 a.t0 vdd.t8 1.90489083994449e-05f
CMODEL512 a.t0 vdd.n15 5.12360088879985e-05f
CMODEL513 a.t0 vdd.t15 4.05848525359943e-06f
CMODEL514 a.t0 vdd.n16 3.19232276479835e-05f
CMODEL515 a.t0 vdd.t14 5.47464403616353e-05f
CMODEL516 a.t0 vdd.n17 4.47175506463777e-05f
CMODEL517 a.t0 vdd.t32 5.47464403616353e-05f
CMODEL518 a.t0 vdd.n18 4.41423016732093e-05f
CMODEL519 a.t0 vdd.t34 4.05848525359943e-06f
CMODEL520 a.t0 vdd.n19 4.44517794400482e-05f
CMODEL521 a.t0 vdd.t33 5.47464403616353e-05f
CMODEL522 a.t0 vdd.n20 8.87099697206686e-05f
CMODEL523 a.t0 vdd.t48 5.48510712186122e-05f
CMODEL524 a.t0 vdd.n21 0.000157469881230663f
CMODEL525 a.t0 vdd.n22 0.000690091272009798f
CMODEL526 a.t0 vdd.t47 7.80199630926561e-07f
CMODEL527 a.t0 vdd.t45 7.72188968901894e-07f
CMODEL528 a.t0 vdd.n23 8.81751162049407e-06f
CMODEL529 a.t0 vdd.t46 2.10434727401031e-05f
CMODEL530 a.t0 vdd.n24 2.26093154554015e-05f
CMODEL531 a.t0 vdd.t44 2.10434727401031e-05f
CMODEL532 a.t0 vdd.n25 3.56570482086681e-05f
CMODEL533 a.t0 vdd.t43 2.10890555923515e-05f
CMODEL534 a.t0 vdd.n26 0.000190785317349013f
CMODEL535 a.t0 vdd.n27 0.000127543910953834f
CMODEL536 a.t0 vdd.n28 2.88099078024089e-05f
CMODEL537 a.t0 vdd.t29 2.40988703559927e-06f
CMODEL538 a.t0 vdd.t28 1.90489083994449e-05f
CMODEL539 a.t0 vdd.n29 4.30059310999664e-06f
CMODEL540 a.t0 vdd.n30 1.37198425282102e-06f
CMODEL541 a.t0 vdd.t38 6.31692243482768e-07f
CMODEL542 a.t0 vdd.t40 6.31692243482768e-07f
CMODEL543 a.t0 vdd.t37 1.2764611366856e-05f
CMODEL544 a.t0 vdd.t39 1.2764611366856e-05f
CMODEL545 a.t0 vdd.n31 4.13415499573378e-06f
CMODEL546 a.t0 vdd.n32 4.98905973410063e-05f
CMODEL547 a.t0 vdd.n33 2.52796097103587e-05f
CMODEL548 a.t0 vdd.t17 2.40988703559927e-06f
CMODEL549 a.t0 vdd.t16 1.90489083994449e-05f
CMODEL550 a.t0 vdd.n34 4.30059310999664e-06f
CMODEL551 a.t0 vdd.n35 1.37198425282102e-06f
CMODEL552 a.t0 vdd.t1 6.31692243482768e-07f
CMODEL553 a.t0 vdd.t31 6.31692243482768e-07f
CMODEL554 a.t0 vdd.t0 1.2764611366856e-05f
CMODEL555 a.t0 vdd.t30 1.2764611366856e-05f
CMODEL556 a.t0 vdd.n36 4.13415499573378e-06f
CMODEL557 a.t0 vdd.n37 4.83840454446615e-05f
CMODEL558 a.t0 vdd.n38 2.79101707284893e-05f
CMODEL559 a.t0 vdd.t19 2.40988703559927e-06f
CMODEL560 a.t0 vdd.t18 1.90489083994449e-05f
CMODEL561 a.t0 vdd.n39 2.35523176094213e-05f
CMODEL562 a.t0 vdd.t21 2.40990910961973e-06f
CMODEL563 a.t0 vdd.t20 1.90489083994449e-05f
CMODEL564 a.t0 vdd.n40 2.35523176094213e-05f
CMODEL565 a.t0 vdd.t11 2.40988703559927e-06f
CMODEL566 a.t0 vdd.t10 1.90489083994449e-05f
CMODEL567 a.t0 vdd.n41 0.000101326376114161f
CMODEL568 a.t0 vdd.n42 0.000194090460432378f
CMODEL569 a.t0 vdd.n43 2.35523176094213e-05f
CMODEL570 a.t0 vdd.t13 2.40988703559927e-06f
CMODEL571 a.t0 vdd.t12 1.90489083994449e-05f
CMODEL572 a.t0 vdd.n44 2.35523176094213e-05f
CMODEL573 a.t0 vdd.t23 2.40988703559927e-06f
CMODEL574 a.t0 vdd.t22 1.90489083994449e-05f
CMODEL575 a.t0 vdd.n45 2.90743545675109e-05f
CMODEL576 a.t0 vdd.n46 0.000479902449196683f
CMODEL577 a.n0 vdd 5.73923208002092e-05f
CMODEL578 a.n0 vdd.n0 0.0192597948770468f
CMODEL579 a.n0 vdd.n1 0.00178481978836022f
CMODEL580 a.n0 vdd.t7 0.000147134121219523f
CMODEL581 a.n0 vdd.t6 0.00116301899472502f
CMODEL582 a.n0 vdd.n2 0.00160051972262263f
CMODEL583 a.n0 vdd.t27 0.000147134121219523f
CMODEL584 a.n0 vdd.t26 0.00116301899472502f
CMODEL585 a.n0 vdd.n3 0.00300198189709578f
CMODEL586 a.n0 vdd.n4 0.00160051972262263f
CMODEL587 a.n0 vdd.t36 0.000147134121219523f
CMODEL588 a.n0 vdd.t35 0.00116301899472502f
CMODEL589 a.n0 vdd.n5 0.0022836900796467f
CMODEL590 a.n0 vdd.t3 0.000234375775006662f
CMODEL591 a.n0 vdd.n6 0.00224239608319917f
CMODEL592 a.n0 vdd.t2 0.00293881448151172f
CMODEL593 a.n0 vdd.n7 0.00300602504296205f
CMODEL594 a.n0 vdd.t25 0.000234375775006662f
CMODEL595 a.n0 vdd.n8 0.00135442691089551f
CMODEL596 a.n0 vdd.t24 0.00293881448151172f
CMODEL597 a.n0 vdd.n9 0.00300602504296205f
CMODEL598 a.n0 vdd.t5 0.000234375775006662f
CMODEL599 a.n0 vdd.n10 0.00401058506489612f
CMODEL600 a.n0 vdd.t4 0.00294043173985823f
CMODEL601 a.n0 vdd.n11 0.00969691931983331f
CMODEL602 a.n0 vdd.n12 0.0239090083086736f
CMODEL603 a.n0 vdd.n13 0.00181227274879221f
CMODEL604 a.n0 vdd.t42 0.000147134121219523f
CMODEL605 a.n0 vdd.t41 0.00116301899472502f
CMODEL606 a.n0 vdd.n14 0.00162937430695493f
CMODEL607 a.n0 vdd.t9 0.000147134121219523f
CMODEL608 a.n0 vdd.t8 0.00116301899472502f
CMODEL609 a.n0 vdd.n15 0.00312818195673503f
CMODEL610 a.n0 vdd.t15 0.000247788237560376f
CMODEL611 a.n0 vdd.n16 0.00194905237344821f
CMODEL612 a.n0 vdd.t14 0.00334250911910614f
CMODEL613 a.n0 vdd.n17 0.00273020163196494f
CMODEL614 a.n0 vdd.t32 0.00334250911910614f
CMODEL615 a.n0 vdd.n18 0.00269508017153992f
CMODEL616 a.n0 vdd.t34 0.000247788237560376f
CMODEL617 a.n0 vdd.n19 0.0027139751398883f
CMODEL618 a.n0 vdd.t33 0.00334250911910614f
CMODEL619 a.n0 vdd.n20 0.0054161308166942f
CMODEL620 a.n0 vdd.t48 0.00334889728957485f
CMODEL621 a.n0 vdd.n21 0.00961422350971515f
CMODEL622 a.n0 vdd.n22 0.0421330839863102f
CMODEL623 a.n0 vdd.t47 4.76345925665472e-05f
CMODEL624 a.n0 vdd.t45 4.71455066882571e-05f
CMODEL625 a.n0 vdd.n23 0.000538347567524761f
CMODEL626 a.n0 vdd.t46 0.00128479585278657f
CMODEL627 a.n0 vdd.n24 0.00138039738450987f
CMODEL628 a.n0 vdd.t44 0.00128479585278657f
CMODEL629 a.n0 vdd.n25 0.00217701841454154f
CMODEL630 a.n0 vdd.t43 0.00128757888485785f
CMODEL631 a.n0 vdd.n26 0.0116482762864253f
CMODEL632 a.n0 vdd.n27 0.00778711241559372f
CMODEL633 a.n0 vdd.n28 0.00175897060912185f
CMODEL634 a.n0 vdd.t29 0.000147134121219523f
CMODEL635 a.n0 vdd.t28 0.00116301899472502f
CMODEL636 a.n0 vdd.n29 0.000262569978847469f
CMODEL637 a.n0 vdd.n30 8.37656265143759e-05f
CMODEL638 a.n0 vdd.t38 3.85675684183734e-05f
CMODEL639 a.n0 vdd.t40 3.85675684183734e-05f
CMODEL640 a.n0 vdd.t37 0.000779335233738067f
CMODEL641 a.n0 vdd.t39 0.000779335233738067f
CMODEL642 a.n0 vdd.n31 0.000252408205570237f
CMODEL643 a.n0 vdd.n32 0.00304603870988526f
CMODEL644 a.n0 vdd.n33 0.00154343050299086f
CMODEL645 a.n0 vdd.t17 0.000147134121219523f
CMODEL646 a.n0 vdd.t16 0.00116301899472502f
CMODEL647 a.n0 vdd.n34 0.000262569978847469f
CMODEL648 a.n0 vdd.n35 8.37656265143759e-05f
CMODEL649 a.n0 vdd.t1 3.85675684183734e-05f
CMODEL650 a.n0 vdd.t31 3.85675684183734e-05f
CMODEL651 a.n0 vdd.t0 0.000779335233738067f
CMODEL652 a.n0 vdd.t30 0.000779335233738067f
CMODEL653 a.n0 vdd.n36 0.000252408205570237f
CMODEL654 a.n0 vdd.n37 0.00295405714142756f
CMODEL655 a.n0 vdd.n38 0.0017040377339521f
CMODEL656 a.n0 vdd.t19 0.000147134121219523f
CMODEL657 a.n0 vdd.t18 0.00116301899472502f
CMODEL658 a.n0 vdd.n39 0.00143797178164559f
CMODEL659 a.n0 vdd.t21 0.000147135468934811f
CMODEL660 a.n0 vdd.t20 0.00116301899472502f
CMODEL661 a.n0 vdd.n40 0.00143797178164559f
CMODEL662 a.n0 vdd.t11 0.000147134121219523f
CMODEL663 a.n0 vdd.t10 0.00116301899472502f
CMODEL664 a.n0 vdd.n41 0.00618641748998355f
CMODEL665 a.n0 vdd.n42 0.011850069696611f
CMODEL666 a.n0 vdd.n43 0.00143797178164559f
CMODEL667 a.n0 vdd.t13 0.000147134121219523f
CMODEL668 a.n0 vdd.t12 0.00116301899472502f
CMODEL669 a.n0 vdd.n44 0.00143797178164559f
CMODEL670 a.n0 vdd.t23 0.000147134121219523f
CMODEL671 a.n0 vdd.t22 0.00116301899472502f
CMODEL672 a.n0 vdd.n45 0.00177511623828117f
CMODEL673 a.n0 vdd.n46 0.0293001390067613f
CMODEL674 a.t2 vdd 1.7932497308927e-06f
CMODEL675 a.t2 vdd.n0 0.000601781240046786f
CMODEL676 a.t2 vdd.n1 5.57675236084418e-05f
CMODEL677 a.t2 vdd.t7 4.59727398375361e-06f
CMODEL678 a.t2 vdd.t6 3.63390688899644e-05f
CMODEL679 a.t2 vdd.n2 5.00089824189691e-05f
CMODEL680 a.t2 vdd.t27 4.59727398375361e-06f
CMODEL681 a.t2 vdd.t26 3.63390688899644e-05f
CMODEL682 a.t2 vdd.n3 9.37983192534035e-05f
CMODEL683 a.t2 vdd.n4 5.00089824189691e-05f
CMODEL684 a.t2 vdd.t36 4.59727398375361e-06f
CMODEL685 a.t2 vdd.t35 3.63390688899644e-05f
CMODEL686 a.t2 vdd.n5 7.13549576610577e-05f
CMODEL687 a.t2 vdd.t3 7.32317999339265e-06f
CMODEL688 a.t2 vdd.n6 7.00647075546925e-05f
CMODEL689 a.t2 vdd.t2 9.18246240025765e-05f
CMODEL690 a.t2 vdd.n7 9.39246492246533e-05f
CMODEL691 a.t2 vdd.t25 7.32317999339265e-06f
CMODEL692 a.t2 vdd.n8 4.23196981688944e-05f
CMODEL693 a.t2 vdd.t24 9.18246240025765e-05f
CMODEL694 a.t2 vdd.n9 9.39246492246533e-05f
CMODEL695 a.t2 vdd.t5 7.32317999339265e-06f
CMODEL696 a.t2 vdd.n10 0.000125312593881393f
CMODEL697 a.t2 vdd.t4 9.18751559910765e-05f
CMODEL698 a.t2 vdd.n11 0.000302984749846811f
CMODEL699 a.t2 vdd.n12 0.000747048073986998f
CMODEL700 a.t2 vdd.n13 5.66253041132284e-05f
CMODEL701 a.t2 vdd.t42 4.59727398375361e-06f
CMODEL702 a.t2 vdd.t41 3.63390688899644e-05f
CMODEL703 a.t2 vdd.n14 5.09105573137889e-05f
CMODEL704 a.t2 vdd.t9 4.59727398375361e-06f
CMODEL705 a.t2 vdd.t8 3.63390688899644e-05f
CMODEL706 a.t2 vdd.n15 9.77414987560157e-05f
CMODEL707 a.t2 vdd.t15 7.74225861801885e-06f
CMODEL708 a.t2 vdd.n16 6.08990470406111e-05f
CMODEL709 a.t2 vdd.t14 0.000104438250531971f
CMODEL710 a.t2 vdd.n17 8.5306418585988e-05f
CMODEL711 a.t2 vdd.t32 0.000104438250531971f
CMODEL712 a.t2 vdd.n18 8.42090322357309e-05f
CMODEL713 a.t2 vdd.t34 7.74225861801885e-06f
CMODEL714 a.t2 vdd.n19 8.47994143013719e-05f
CMODEL715 a.t2 vdd.t33 0.000104438250531971f
CMODEL716 a.t2 vdd.n20 0.00016922952398679f
CMODEL717 a.t2 vdd.t48 0.000104637851886546f
CMODEL718 a.t2 vdd.n21 0.000300400880834848f
CMODEL719 a.t2 vdd.n22 0.00131646778639861f
CMODEL720 a.t2 vdd.t47 1.48836497827829e-06f
CMODEL721 a.t2 vdd.t45 1.4730832627561e-06f
CMODEL722 a.t2 vdd.n23 1.68209198918995e-05f
CMODEL723 a.t2 vdd.t46 4.01440434040293e-05f
CMODEL724 a.t2 vdd.n24 4.31311576842226e-05f
CMODEL725 a.t2 vdd.t44 4.01440434040293e-05f
CMODEL726 a.t2 vdd.n25 6.80219519195823e-05f
CMODEL727 a.t2 vdd.t43 4.02310005342396e-05f
CMODEL728 a.t2 vdd.n26 0.000363955804971035f
CMODEL729 a.t2 vdd.n27 0.000243311945727132f
CMODEL730 a.t2 vdd.n28 5.49598539922511e-05f
CMODEL731 a.t2 vdd.t29 4.59727398375361e-06f
CMODEL732 a.t2 vdd.t28 3.63390688899644e-05f
CMODEL733 a.t2 vdd.n29 8.20412099290833e-06f
CMODEL734 a.t2 vdd.n30 2.61729592235649e-06f
CMODEL735 a.t2 vdd.t38 1.2050615957524e-06f
CMODEL736 a.t2 vdd.t40 1.2050615957524e-06f
CMODEL737 a.t2 vdd.t37 2.43506914982761e-05f
CMODEL738 a.t2 vdd.t39 2.43506914982761e-05f
CMODEL739 a.t2 vdd.n31 7.88661166516702e-06f
CMODEL740 a.t2 vdd.n32 9.51748948401228e-05f
CMODEL741 a.t2 vdd.n33 4.82252032249211e-05f
CMODEL742 a.t2 vdd.t17 4.59727398375361e-06f
CMODEL743 a.t2 vdd.t16 3.63390688899644e-05f
CMODEL744 a.t2 vdd.n34 8.20412099290833e-06f
CMODEL745 a.t2 vdd.n35 2.61729592235649e-06f
CMODEL746 a.t2 vdd.t1 1.2050615957524e-06f
CMODEL747 a.t2 vdd.t31 1.2050615957524e-06f
CMODEL748 a.t2 vdd.t0 2.43506914982761e-05f
CMODEL749 a.t2 vdd.t30 2.43506914982761e-05f
CMODEL750 a.t2 vdd.n36 7.88661166516702e-06f
CMODEL751 a.t2 vdd.n37 9.23008879941885e-05f
CMODEL752 a.t2 vdd.n38 5.32434507828697e-05f
CMODEL753 a.t2 vdd.t19 4.59727398375361e-06f
CMODEL754 a.t2 vdd.t18 3.63390688899644e-05f
CMODEL755 a.t2 vdd.n39 4.49300964748206e-05f
CMODEL756 a.t2 vdd.t21 4.59731609374403e-06f
CMODEL757 a.t2 vdd.t20 3.63390688899644e-05f
CMODEL758 a.t2 vdd.n40 4.49300964748206e-05f
CMODEL759 a.t2 vdd.t11 4.59727398375361e-06f
CMODEL760 a.t2 vdd.t10 3.63390688899644e-05f
CMODEL761 a.t2 vdd.n41 0.000193297489009409f
CMODEL762 a.t2 vdd.n42 0.000370260933836115f
CMODEL763 a.t2 vdd.n43 4.49300964748206e-05f
CMODEL764 a.t2 vdd.t13 4.59727398375361e-06f
CMODEL765 a.t2 vdd.t12 3.63390688899644e-05f
CMODEL766 a.t2 vdd.n44 4.49300964748206e-05f
CMODEL767 a.t2 vdd.t23 4.59727398375361e-06f
CMODEL768 a.t2 vdd.t22 3.63390688899644e-05f
CMODEL769 a.t2 vdd.n45 5.54643316774422e-05f
CMODEL770 a.t2 vdd.n46 0.00091549645765156f
CMODEL771 a.t1 vdd 1.10139275235627e-06f
CMODEL772 a.t1 vdd.n0 0.000369606912452484f
CMODEL773 a.t1 vdd.n1 3.42517527040801e-05f
CMODEL774 a.t1 vdd.t7 2.82359124837657e-06f
CMODEL775 a.t1 vdd.t6 2.23190258519419e-05f
CMODEL776 a.t1 vdd.n2 3.07149248875367e-05f
CMODEL777 a.t1 vdd.t27 2.82359124837657e-06f
CMODEL778 a.t1 vdd.t26 2.23190258519419e-05f
CMODEL779 a.t1 vdd.n3 5.76098170986312e-05f
CMODEL780 a.t1 vdd.n4 3.07149248875367e-05f
CMODEL781 a.t1 vdd.t36 2.82359124837657e-06f
CMODEL782 a.t1 vdd.t35 2.23190258519419e-05f
CMODEL783 a.t1 vdd.n5 4.38253701415332e-05f
CMODEL784 a.t1 vdd.t3 4.49781044434224e-06f
CMODEL785 a.t1 vdd.n6 4.30329138029673e-05f
CMODEL786 a.t1 vdd.t2 5.63975968444346e-05f
CMODEL787 a.t1 vdd.n7 5.76874074712062e-05f
CMODEL788 a.t1 vdd.t25 4.49781044434224e-06f
CMODEL789 a.t1 vdd.n8 2.59922575434721e-05f
CMODEL790 a.t1 vdd.t24 5.63975968444346e-05f
CMODEL791 a.t1 vdd.n9 5.76874074712062e-05f
CMODEL792 a.t1 vdd.t5 4.49781044434224e-06f
CMODEL793 a.t1 vdd.n10 7.6965511441189e-05f
CMODEL794 a.t1 vdd.t4 5.64286329934646e-05f
CMODEL795 a.t1 vdd.n11 0.00018608964596896f
CMODEL796 a.t1 vdd.n12 0.000458828081876468f
CMODEL797 a.t1 vdd.n13 3.47785913338643e-05f
CMODEL798 a.t1 vdd.t42 2.82359124837657e-06f
CMODEL799 a.t1 vdd.t41 2.23190258519419e-05f
CMODEL800 a.t1 vdd.n14 3.12686615131469e-05f
CMODEL801 a.t1 vdd.t9 2.82359124837657e-06f
CMODEL802 a.t1 vdd.t8 2.23190258519419e-05f
CMODEL803 a.t1 vdd.n15 6.0031671261272e-05f
CMODEL804 a.t1 vdd.t15 4.75520357363101e-06f
CMODEL805 a.t1 vdd.n16 3.74034736380763e-05f
CMODEL806 a.t1 vdd.t14 6.41447369114724e-05f
CMODEL807 a.t1 vdd.n17 5.23941922541402e-05f
CMODEL808 a.t1 vdd.t32 6.41447369114724e-05f
CMODEL809 a.t1 vdd.n18 5.17201905510388e-05f
CMODEL810 a.t1 vdd.t34 4.75520357363101e-06f
CMODEL811 a.t1 vdd.n19 5.20827962255392e-05f
CMODEL812 a.t1 vdd.t33 6.41447369114724e-05f
CMODEL813 a.t1 vdd.n20 0.000103938769928584f
CMODEL814 a.t1 vdd.t48 6.42673297001409e-05f
CMODEL815 a.t1 vdd.n21 0.000184502664215226f
CMODEL816 a.t1 vdd.n22 0.000808558927220991f
CMODEL817 a.t1 vdd.t47 9.14136147183784e-07f
CMODEL818 a.t1 vdd.t45 9.04750298447962e-07f
CMODEL819 a.t1 vdd.n23 1.03312098352754e-05f
CMODEL820 a.t1 vdd.t46 2.46559961469856e-05f
CMODEL821 a.t1 vdd.n24 2.64906463699788e-05f
CMODEL822 a.t1 vdd.t44 2.46559961469856e-05f
CMODEL823 a.t1 vdd.n25 4.17782774784297e-05f
CMODEL824 a.t1 vdd.t43 2.47094041867747e-05f
CMODEL825 a.t1 vdd.n26 0.000223537346119404f
CMODEL826 a.t1 vdd.n27 0.000149439316214012f
CMODEL827 a.t1 vdd.n28 3.37556915887507e-05f
CMODEL828 a.t1 vdd.t29 2.82359124837657e-06f
CMODEL829 a.t1 vdd.t28 2.23190258519419e-05f
CMODEL830 a.t1 vdd.n29 5.03887397576519e-06f
CMODEL831 a.t1 vdd.n30 1.6075121663172e-06f
CMODEL832 a.t1 vdd.t38 7.40134563992857e-07f
CMODEL833 a.t1 vdd.t40 7.40134563992857e-07f
CMODEL834 a.t1 vdd.t37 1.49559064022352e-05f
CMODEL835 a.t1 vdd.t39 1.49559064022352e-05f
CMODEL836 a.t1 vdd.n31 4.84386350602671e-06f
CMODEL837 a.t1 vdd.n32 5.84552935251234e-05f
CMODEL838 a.t1 vdd.n33 2.96193488267778e-05f
CMODEL839 a.t1 vdd.t17 2.82359124837657e-06f
CMODEL840 a.t1 vdd.t16 2.23190258519419e-05f
CMODEL841 a.t1 vdd.n34 5.03887397576519e-06f
CMODEL842 a.t1 vdd.n35 1.6075121663172e-06f
CMODEL843 a.t1 vdd.t1 7.40134563992857e-07f
CMODEL844 a.t1 vdd.t31 7.40134563992857e-07f
CMODEL845 a.t1 vdd.t0 1.49559064022352e-05f
CMODEL846 a.t1 vdd.t30 1.49559064022352e-05f
CMODEL847 a.t1 vdd.n36 4.84386350602671e-06f
CMODEL848 a.t1 vdd.n37 5.66901125490423e-05f
CMODEL849 a.t1 vdd.n38 3.27014970600318e-05f
CMODEL850 a.t1 vdd.t19 2.82359124837657e-06f
CMODEL851 a.t1 vdd.t18 2.23190258519419e-05f
CMODEL852 a.t1 vdd.n39 2.75955332754467e-05f
CMODEL853 a.t1 vdd.t21 2.82361711183409e-06f
CMODEL854 a.t1 vdd.t20 2.23190258519419e-05f
CMODEL855 a.t1 vdd.n40 2.75955332754467e-05f
CMODEL856 a.t1 vdd.t11 2.82359124837657e-06f
CMODEL857 a.t1 vdd.t10 2.23190258519419e-05f
CMODEL858 a.t1 vdd.n41 0.000118721029076997f
CMODEL859 a.t1 vdd.n42 0.000227409881614622f
CMODEL860 a.t1 vdd.n43 2.75955332754467e-05f
CMODEL861 a.t1 vdd.t13 2.82359124837657e-06f
CMODEL862 a.t1 vdd.t12 2.23190258519419e-05f
CMODEL863 a.t1 vdd.n44 2.75955332754467e-05f
CMODEL864 a.t1 vdd.t23 2.82359124837657e-06f
CMODEL865 a.t1 vdd.t22 2.23190258519419e-05f
CMODEL866 a.t1 vdd.n45 3.40655358099001e-05f
CMODEL867 a.t1 vdd.n46 0.000562287084667963f
CMODEL868 a_9600_169.t1 a_9600_83.t0 0.00038416048346581f
CMODEL869 a_9600_169.t1 a_9600_83.t1 0.00038416048346581f
CMODEL870 a_9600_169.n0 a_9600_83.t0 0.00723322343741683f
CMODEL871 a_9600_169.n0 a_9600_83.t1 0.00723322343741683f
CMODEL872 a_9600_169.t2 a_9600_83.t0 0.000560836163102628f
CMODEL873 a_9600_169.t2 a_9600_83.t1 0.000560836163102628f
CMODEL874 a_9600_169.t3 a_9600_83.t0 0.00117065037934829f
CMODEL875 a_9600_169.t3 a_9600_83.t1 0.00117065037934829f
CMODEL876 a_9600_169.t4 a_9600_83.t0 0.000249325835860499f
CMODEL877 a_9600_169.t4 a_9600_83.t1 0.000249325835860499f
CMODEL878 a_9600_169.t0 a_9600_83.t0 0.000623588863603054f
CMODEL879 a_9600_169.t0 a_9600_83.t1 0.000623588863603054f
CMODEL880 a_9600_169.n1 a_9600_83.t0 0.000563814837202892f
CMODEL881 a_9600_169.n1 a_9600_83.t1 0.000563814837202892f
CMODEL882 a a_6400_83.t1 1.62682333379669e-06f
CMODEL883 a a_6400_83.n0 1.83520970211132e-05f
CMODEL884 a a_6400_83.t0 3.69328221992853e-07f
CMODEL885 a a_6400_83.t3 3.64245196671894e-07f
CMODEL886 a a_6400_83.t2 3.64245196671894e-07f
CMODEL887 a a_6400_83.n1 0.000134134735975497f
CMODEL888 a.t3 a_6400_83.t1 9.15845956236406e-06f
CMODEL889 a.t3 a_6400_83.n0 0.000103316036204243f
CMODEL890 a.t3 a_6400_83.t0 2.07919170821536e-06f
CMODEL891 a.t3 a_6400_83.t3 2.05057601228246e-06f
CMODEL892 a.t3 a_6400_83.t2 2.05057601228246e-06f
CMODEL893 a.t3 a_6400_83.n1 0.000755132736185291f
CMODEL894 a.t0 a_6400_83.t1 9.47625747460298e-06f
CMODEL895 a.t0 a_6400_83.n0 0.000106901095501927f
CMODEL896 a.t0 a_6400_83.t0 2.15133951642655e-06f
CMODEL897 a.t0 a_6400_83.t3 2.12173085782751e-06f
CMODEL898 a.t0 a_6400_83.t2 2.12173085782751e-06f
CMODEL899 a.t0 a_6400_83.n1 0.000781335789808973f
CMODEL900 a.n0 a_6400_83.t1 0.000578566876944473f
CMODEL901 a.n0 a_6400_83.n0 0.00652677843887771f
CMODEL902 a.n0 a_6400_83.t0 0.000131348666770822f
CMODEL903 a.n0 a_6400_83.t3 0.000129540928939503f
CMODEL904 a.n0 a_6400_83.t2 0.000129540928939503f
CMODEL905 a.n0 a_6400_83.n1 0.0477039600249633f
CMODEL906 a.t2 a_6400_83.t1 1.80775909027245e-05f
CMODEL907 a.t2 a_6400_83.n0 0.000203932225007201f
CMODEL908 a.t2 a_6400_83.t0 4.10405012475177e-06f
CMODEL909 a.t2 a_6400_83.t3 4.04756651624215e-06f
CMODEL910 a.t2 a_6400_83.t2 4.04756651624215e-06f
CMODEL911 a.t2 a_6400_83.n1 0.00149053239674827f
CMODEL912 a.t1 a_6400_83.t1 1.11030422909422e-05f
CMODEL913 a.t1 a_6400_83.n0 0.000125252758009899f
CMODEL914 a.t1 a_6400_83.t0 2.52065899402547e-06f
CMODEL915 a.t1 a_6400_83.t3 2.48596743045365e-06f
CMODEL916 a.t1 a_6400_83.t2 2.48596743045365e-06f
CMODEL917 a.t1 a_6400_83.n1 0.000915467349945471f
CMODEL918 a_0_n23917.t1 a_11200_n23917.t0 0.00025463871581311f
CMODEL919 a_0_n23917.t1 a_11200_n23917.t1 0.000254530934816488f
CMODEL920 a_0_n23917.n0 a_11200_n23917.t0 0.000852348386226144f
CMODEL921 a_0_n23917.n0 a_11200_n23917.t1 0.000851987612499166f
CMODEL922 a_0_n23917.t0 a_11200_n23917.t0 5.78091949624515e-05f
CMODEL923 a_0_n23917.t0 a_11200_n23917.t1 5.77847260492029e-05f
CMODEL924 a_0_n23917.t3 a_11200_n23917.t0 0.000167232278329954f
CMODEL925 a_0_n23917.t3 a_11200_n23917.t1 0.000167161493879254f
CMODEL926 a_0_n23917.n1 a_11200_n23917.t0 0.00701246437575203f
CMODEL927 a_0_n23917.n1 a_11200_n23917.t1 0.00700949620810014f
CMODEL928 a_0_n23917.t2 a_11200_n23917.t0 0.000124749438149874f
CMODEL929 a_0_n23917.t2 a_11200_n23917.t1 0.000124696635422178f
CMODEL930 a_0_n11917.t2 a_19896_8041.t1 9.33267210849271e-06f
CMODEL931 a_0_n11917.t2 a_19896_8041.t0 4.41864810475928e-06f
CMODEL932 a_0_n11917.t2 a_19896_8041.n0 1.32380010633476e-05f
CMODEL933 a_0_n11917.t2 a_19896_8041.t3 4.41151492713538e-06f
CMODEL934 a_0_n11917.t2 a_19896_8041.t4 4.12792821946889e-06f
CMODEL935 a_0_n11917.t2 a_19896_8041.t2 4.15114168754394e-06f
CMODEL936 a_0_n11917.t2 a_19896_8041.n1 0.000125377240243109f
CMODEL937 a_0_n11917.t1 a_19896_8041.t1 1.4599671965128e-05f
CMODEL938 a_0_n11917.t1 a_19896_8041.t0 6.91236251620961e-06f
CMODEL939 a_0_n11917.t1 a_19896_8041.n0 2.07090178195604e-05f
CMODEL940 a_0_n11917.t1 a_19896_8041.t3 6.90120364850619e-06f
CMODEL941 a_0_n11917.t1 a_19896_8041.t4 6.45757155070286e-06f
CMODEL942 a_0_n11917.t1 a_19896_8041.t2 6.49388580401946e-06f
CMODEL943 a_0_n11917.t1 a_19896_8041.n1 0.000196135314534056f
CMODEL944 a_0_n11917.n0 a_19896_8041.t1 0.000398106620138865f
CMODEL945 a_0_n11917.n0 a_19896_8041.t0 0.000188487610206293f
CMODEL946 a_0_n11917.n0 a_19896_8041.n0 0.00056469741993059f
CMODEL947 a_0_n11917.n0 a_19896_8041.t3 0.000188183328088408f
CMODEL948 a_0_n11917.n0 a_19896_8041.t4 0.000176086284027182f
CMODEL949 a_0_n11917.n0 a_19896_8041.t2 0.00017707650796408f
CMODEL950 a_0_n11917.n0 a_19896_8041.n1 0.00534825490226977f
CMODEL951 a_0_n11917.t6 a_19896_8041.t1 2.48741320844688e-05f
CMODEL952 a_0_n11917.t6 a_19896_8041.t0 1.17769096904789e-05f
CMODEL953 a_0_n11917.t6 a_19896_8041.n0 3.52829053840217e-05f
CMODEL954 a_0_n11917.t6 a_19896_8041.t3 1.17578978147443e-05f
CMODEL955 a_0_n11917.t6 a_19896_8041.t4 1.10020614217056e-05f
CMODEL956 a_0_n11917.t6 a_19896_8041.t2 1.10639316839761e-05f
CMODEL957 a_0_n11917.t6 a_19896_8041.n1 0.000334164749167101f
CMODEL958 a_0_n11917.n1 a_19896_8041.t1 0.00154338103628218f
CMODEL959 a_0_n11917.n1 a_19896_8041.t0 0.00073072937863999f
CMODEL960 a_0_n11917.n1 a_19896_8041.n0 0.00218922078928087f
CMODEL961 a_0_n11917.n1 a_19896_8041.t3 0.00072954973673838f
CMODEL962 a_0_n11917.n1 a_19896_8041.t4 0.00068265187708296f
CMODEL963 a_0_n11917.n1 a_19896_8041.t2 0.000686490780453492f
CMODEL964 a_0_n11917.n1 a_19896_8041.n1 0.0207341319531112f
CMODEL965 a_0_n11917.t4 a_19896_8041.t1 1.97469247765117e-06f
CMODEL966 a_0_n11917.t4 a_19896_8041.t0 9.34938147662511e-07f
CMODEL967 a_0_n11917.t4 a_19896_8041.n0 2.80101784516168e-06f
CMODEL968 a_0_n11917.t4 a_19896_8041.t3 9.33428844428462e-07f
CMODEL969 a_0_n11917.t4 a_19896_8041.t4 8.73424964309147e-07f
CMODEL970 a_0_n11917.t4 a_19896_8041.t2 8.78336683081124e-07f
CMODEL971 a_0_n11917.t4 a_19896_8041.n1 2.65284679777223e-05f
CMODEL972 a_0_n11917.t5 a_19896_8041.t1 1.99370940714109e-06f
CMODEL973 a_0_n11917.t5 a_19896_8041.t0 9.43941905479363e-07f
CMODEL974 a_0_n11917.t5 a_19896_8041.n0 2.8279925561429e-06f
CMODEL975 a_0_n11917.t5 a_19896_8041.t3 9.42418067165292e-07f
CMODEL976 a_0_n11917.t5 a_19896_8041.t4 8.81836330204842e-07f
CMODEL977 a_0_n11917.t5 a_19896_8041.t2 8.86795350422799e-07f
CMODEL978 a_0_n11917.t5 a_19896_8041.n1 2.6783945734749e-05f
CMODEL979 a_0_n11917.n2 a_19896_8041.t1 0.000501391807066083f
CMODEL980 a_0_n11917.n2 a_19896_8041.t0 0.000237389027738187f
CMODEL981 a_0_n11917.n2 a_19896_8041.n0 0.000711203093597871f
CMODEL982 a_0_n11917.n2 a_19896_8041.t3 0.000237005802357782f
CMODEL983 a_0_n11917.n2 a_19896_8041.t4 0.000221770288866696f
CMODEL984 a_0_n11917.n2 a_19896_8041.t2 0.000223017417510145f
CMODEL985 a_0_n11917.n2 a_19896_8041.n1 0.00673581160032885f
CMODEL986 a_0_n11917.t0 a_19896_8041.t1 3.95181028589187e-06f
CMODEL987 a_0_n11917.t0 a_19896_8041.t0 1.87102459264954e-06f
CMODEL988 a_0_n11917.t0 a_19896_8041.n0 5.60547591928992e-06f
CMODEL989 a_0_n11917.t0 a_19896_8041.t3 1.86800413244506e-06f
CMODEL990 a_0_n11917.t0 a_19896_8041.t4 1.74792267503708e-06f
CMODEL991 a_0_n11917.t0 a_19896_8041.t2 1.75775214518708e-06f
CMODEL992 a_0_n11917.t0 a_19896_8041.n1 5.30895183983351e-05f
CMODEL993 a_0_n11917.t3 a_19896_8041.t1 7.0969263968572e-06f
CMODEL994 a_0_n11917.t3 a_19896_8041.t0 3.36011166025567e-06f
CMODEL995 a_0_n11917.t3 a_19896_8041.n0 1.00666902357581e-05f
CMODEL996 a_0_n11917.t3 a_19896_8041.t3 3.35468731490376e-06f
CMODEL997 a_0_n11917.t3 a_19896_8041.t4 3.13903696653198e-06f
CMODEL998 a_0_n11917.t3 a_19896_8041.t2 3.15668938937821e-06f
CMODEL999 a_0_n11917.t3 a_19896_8041.n1 9.53417237316969e-05f
CMODEL1000 a_0_n11917.n3 a_19896_8041.t1 0.00110033450136193f
CMODEL1001 a_0_n11917.n3 a_19896_8041.t0 0.000520964510755687f
CMODEL1002 a_0_n11917.n3 a_19896_8041.n0 0.00156077799902689f
CMODEL1003 a_0_n11917.n3 a_19896_8041.t3 0.000520123499590538f
CMODEL1004 a_0_n11917.n3 a_19896_8041.t4 0.000486688248148551f
CMODEL1005 a_0_n11917.n3 a_19896_8041.t2 0.000489425147026203f
CMODEL1006 a_0_n11917.n3 a_19896_8041.n1 0.0147821440120559f
CMODEL1007 a_0_n11917.n4 a_19896_8041.t1 0.00200429319918357f
CMODEL1008 a_0_n11917.n4 a_19896_8041.t0 0.000948952908984685f
CMODEL1009 a_0_n11917.n4 a_19896_8041.n0 0.00284300521797049f
CMODEL1010 a_0_n11917.n4 a_19896_8041.t3 0.000947420981233024f
CMODEL1011 a_0_n11917.n4 a_19896_8041.t4 0.000886517640480534f
CMODEL1012 a_0_n11917.n4 a_19896_8041.t2 0.000891502986119103f
CMODEL1013 a_0_n11917.n4 a_19896_8041.n1 0.026926130804809f
CMODEL1014 a_12800_83.t1 a_9600_169.t1 0.000212593104405688f
CMODEL1015 a_12800_83.t1 a_9600_169.n0 0.00400284123850359f
CMODEL1016 a_12800_83.t1 a_9600_169.t2 0.000310364824360113f
CMODEL1017 a_12800_83.t1 a_9600_169.t3 0.000647833936676877f
CMODEL1018 a_12800_83.t1 a_9600_169.t4 0.000137976069209221f
CMODEL1019 a_12800_83.t1 a_9600_169.t0 0.000345091955294738f
CMODEL1020 a_12800_83.t1 a_9600_169.n1 0.000312013212471964f
CMODEL1021 a_12800_83.n0 a_9600_169.t1 0.0029605435730622f
CMODEL1022 a_12800_83.n0 a_9600_169.n0 0.0557430399060633f
CMODEL1023 a_12800_83.n0 a_9600_169.t2 0.00432209966843744f
CMODEL1024 a_12800_83.n0 a_9600_169.t3 0.00902165008127609f
CMODEL1025 a_12800_83.n0 a_9600_169.t4 0.00192143656811296f
CMODEL1026 a_12800_83.n0 a_9600_169.t0 0.00480570512020788f
CMODEL1027 a_12800_83.n0 a_9600_169.n1 0.00434505490418742f
CMODEL1028 a_12800_83.t0 a_9600_169.t1 4.82638879962969e-05f
CMODEL1029 a_12800_83.t0 a_9600_169.n0 0.000908743873617978f
CMODEL1030 a_12800_83.t0 a_9600_169.t2 7.04604844206136e-05f
CMODEL1031 a_12800_83.t0 a_9600_169.t3 0.000147074311969718f
CMODEL1032 a_12800_83.t0 a_9600_169.t4 3.13239771774319e-05f
CMODEL1033 a_12800_83.t0 a_9600_169.t0 7.83444012698782e-05f
CMODEL1034 a_12800_83.t0 a_9600_169.n1 7.08347092546092e-05f
CMODEL1035 a_12800_83.t2 a_9600_169.t1 4.75995170246976e-05f
CMODEL1036 a_12800_83.t2 a_9600_169.n0 0.000896234664863457f
CMODEL1037 a_12800_83.t2 a_9600_169.t2 6.94905687665438e-05f
CMODEL1038 a_12800_83.t2 a_9600_169.t3 0.000145049777527981f
CMODEL1039 a_12800_83.t2 a_9600_169.t4 3.08927905901987e-05f
CMODEL1040 a_12800_83.t2 a_9600_169.t0 7.72659604696877e-05f
CMODEL1041 a_12800_83.t2 a_9600_169.n1 6.9859642251842e-05f
CMODEL1042 a_12800_83.t3 a_9600_169.t1 4.75995170246976e-05f
CMODEL1043 a_12800_83.t3 a_9600_169.n0 0.000896234664863457f
CMODEL1044 a_12800_83.t3 a_9600_169.t2 6.94905687665438e-05f
CMODEL1045 a_12800_83.t3 a_9600_169.t3 0.000145049777527981f
CMODEL1046 a_12800_83.t3 a_9600_169.t4 3.08927905901987e-05f
CMODEL1047 a_12800_83.t3 a_9600_169.t0 7.72659604696877e-05f
CMODEL1048 a_12800_83.t3 a_9600_169.n1 6.9859642251842e-05f
CMODEL1049 a_12800_83.n1 a_9600_169.t1 0.0200020514500106f
CMODEL1050 a_12800_83.n1 a_9600_169.n0 0.376611633865538f
CMODEL1051 a_12800_83.n1 a_9600_169.t2 0.0292010091412842f
CMODEL1052 a_12800_83.n1 a_9600_169.t3 0.060952154439338f
CMODEL1053 a_12800_83.n1 a_9600_169.t4 0.0129816272400189f
CMODEL1054 a_12800_83.n1 a_9600_169.t0 0.0324683486987334f
CMODEL1055 a_12800_83.n1 a_9600_169.n1 0.0293560995141117f
CMODEL1056 a_0_83.t1 en 8.19008561082211e-05f
CMODEL1057 a_0_83.t1 en.t3 0.000621011368148179f
CMODEL1058 a_0_83.t1 en.t1 0.000558975092482771f
CMODEL1059 a_0_83.t1 en.n0 0.0223380091693704f
CMODEL1060 a_0_83.t1 en.t0 0.000764448386322415f
CMODEL1061 a_0_83.t1 en.t2 0.000558975092482771f
CMODEL1062 a_0_83.n0 en 0.000809130770217757f
CMODEL1063 a_0_83.n0 en.t3 0.00613521555818366f
CMODEL1064 a_0_83.n0 en.t1 0.00552233479117108f
CMODEL1065 a_0_83.n0 en.n0 0.220685978428127f
CMODEL1066 a_0_83.n0 en.t0 0.00755228627646407f
CMODEL1067 a_0_83.n0 en.t2 0.00552233479117108f
CMODEL1068 a_0_83.t0 en 1.85935134114147e-05f
CMODEL1069 a_0_83.t0 en.t3 0.000140984890158494f
CMODEL1070 a_0_83.t0 en.t1 0.000126901126222561f
CMODEL1071 a_0_83.t0 en.n0 0.00507127877303473f
CMODEL1072 a_0_83.t0 en.t0 0.000173548629389643f
CMODEL1073 a_0_83.t0 en.t2 0.000126901126222561f
CMODEL1074 a_0_83.t2 en 8.52565852099074e-05f
CMODEL1075 a_0_83.t2 en.t3 0.000646456107307184f
CMODEL1076 a_0_83.t2 en.t1 0.000581878015285966f
CMODEL1077 a_0_83.t2 en.n0 0.0232532658712581f
CMODEL1078 a_0_83.t2 en.t0 0.000795770179751895f
CMODEL1079 a_0_83.t2 en.t2 0.000581878015285966f
CMODEL1080 a_0_83.t3 en 3.66358485651313e-05f
CMODEL1081 a_0_83.t3 en.t3 0.000277790483784918f
CMODEL1082 a_0_83.t3 en.t1 0.00025004044906221f
CMODEL1083 a_0_83.t3 en.n0 0.00999222670022154f
CMODEL1084 a_0_83.t3 en.t0 0.000341952656516319f
CMODEL1085 a_0_83.t3 en.t2 0.00025004044906221f
CMODEL1086 a_0_n11917.t2 a_11200_n23917.t0 0.000380623564112681f
CMODEL1087 a_0_n11917.t2 a_11200_n23917.t1 0.000380462457475982f
CMODEL1088 a_0_n11917.t1 a_11200_n23917.t0 0.000595432809986558f
CMODEL1089 a_0_n11917.t1 a_11200_n23917.t1 0.000595180780983518f
CMODEL1090 a_0_n11917.n0 a_11200_n23917.t0 0.0162363746301787f
CMODEL1091 a_0_n11917.n0 a_11200_n23917.t1 0.0162295022555927f
CMODEL1092 a_0_n11917.t6 a_11200_n23917.t0 0.00101446624269426f
CMODEL1093 a_0_n11917.t6 a_11200_n23917.t1 0.00101403684929928f
CMODEL1094 a_0_n11917.n1 a_11200_n23917.t0 0.0629452298317722f
CMODEL1095 a_0_n11917.n1 a_11200_n23917.t1 0.0629185869876854f
CMODEL1096 a_0_n11917.t4 a_11200_n23917.t0 8.0535829410113e-05f
CMODEL1097 a_0_n11917.t4 a_11200_n23917.t1 8.05017409882881e-05f
CMODEL1098 a_0_n11917.t5 a_11200_n23917.t0 8.13114155870178e-05f
CMODEL1099 a_0_n11917.t5 a_11200_n23917.t1 8.12769988826265e-05f
CMODEL1100 a_0_n11917.n2 a_11200_n23917.t0 0.0204487561979944f
CMODEL1101 a_0_n11917.n2 a_11200_n23917.t1 0.0204401008475476f
CMODEL1102 a_0_n11917.t0 a_11200_n23917.t0 0.000161170573467865f
CMODEL1103 a_0_n11917.t0 a_11200_n23917.t1 0.000161102354756586f
CMODEL1104 a_0_n11917.t3 a_11200_n23917.t0 0.000289440943388444f
CMODEL1105 a_0_n11917.t3 a_11200_n23917.t1 0.000289318431643748f
CMODEL1106 a_0_n11917.n3 a_11200_n23917.t0 0.0448760263679905f
CMODEL1107 a_0_n11917.n3 a_11200_n23917.t1 0.0448570316804351f
CMODEL1108 a_0_n11917.n4 a_11200_n23917.t0 0.0817430648083989f
CMODEL1109 a_0_n11917.n4 a_11200_n23917.t1 0.0817084653997275f
CMODEL1110 a_0_n23917.t1 din 2.82700805574191e-05f
CMODEL1111 a_0_n23917.t1 din.t0 0.000159150390559353f
CMODEL1112 a_0_n23917.t1 din.t1 0.000164672961935347f
CMODEL1113 a_0_n23917.t1 din.n0 0.00927038981164379f
CMODEL1114 a_0_n23917.t1 din.t2 0.000280496226024692f
CMODEL1115 a_0_n23917.t1 din.n1 0.0122200442055763f
CMODEL1116 a_0_n23917.t1 din.t3 0.000206519965569261f
CMODEL1117 a_0_n23917.n0 din 9.46280201918873e-05f
CMODEL1118 a_0_n23917.n0 din.t0 0.000532721735292149f
CMODEL1119 a_0_n23917.n0 din.t1 0.000551207356322388f
CMODEL1120 a_0_n23917.n0 din.n0 0.0310306379389738f
CMODEL1121 a_0_n23917.n0 din.t2 0.000938900845581315f
CMODEL1122 a_0_n23917.n0 din.n1 0.0409039722218816f
CMODEL1123 a_0_n23917.n0 din.t3 0.000691281209200063f
CMODEL1124 a_0_n23917.t0 din 6.41799733135439e-06f
CMODEL1125 a_0_n23917.t0 din.t0 3.61310177316022e-05f
CMODEL1126 a_0_n23917.t0 din.t1 3.73847760391302e-05f
CMODEL1127 a_0_n23917.t0 din.n0 0.00210460444040477f
CMODEL1128 a_0_n23917.t0 din.t2 6.36794800221749e-05f
CMODEL1129 a_0_n23917.t0 din.n1 0.00277424788164739f
CMODEL1130 a_0_n23917.t0 din.t3 4.68850658279101e-05f
CMODEL1131 a_0_n23917.t3 din 1.8566186862403e-05f
CMODEL1132 a_0_n23917.t3 din.t0 0.000104520957566706f
CMODEL1133 a_0_n23917.t3 din.t1 0.000108147869485808f
CMODEL1134 a_0_n23917.t3 din.n0 0.00608826668111938f
CMODEL1135 a_0_n23917.t3 din.t2 0.000184214025708057f
CMODEL1136 a_0_n23917.t3 din.n1 0.00802543253199228f
CMODEL1137 a_0_n23917.t3 din.t3 0.000135630610029149f
CMODEL1138 a_0_n23917.n1 din 0.000778526282523512f
CMODEL1139 a_0_n23917.n1 din.t0 0.00438282309357696f
CMODEL1140 a_0_n23917.n1 din.t1 0.00453490850962632f
CMODEL1141 a_0_n23917.n1 din.n0 0.255296128461466f
CMODEL1142 a_0_n23917.n1 din.t2 0.00772455117930565f
CMODEL1143 a_0_n23917.n1 din.n1 0.336526299184653f
CMODEL1144 a_0_n23917.n1 din.t3 0.00568732801220565f
CMODEL1145 a_0_n23917.t2 din 1.38497268756966e-05f
CMODEL1146 a_0_n23917.t2 din.t0 7.79689833897208e-05f
CMODEL1147 a_0_n23917.t2 din.t1 8.06745329920191e-05f
CMODEL1148 a_0_n23917.t2 din.n0 0.00454163427874677f
CMODEL1149 a_0_n23917.t2 din.t2 0.00013741722851533f
CMODEL1150 a_0_n23917.t2 din.n1 0.00598669233759061f
CMODEL1151 a_0_n23917.t2 din.t3 0.000101175697455234f
CMODEL1152 a_9600_169.t1 vdd 4.78384113445614e-06f
CMODEL1153 a_9600_169.t1 vdd.n0 0.00160536806474061f
CMODEL1154 a_9600_169.t1 vdd.n1 0.000148770675276783f
CMODEL1155 a_9600_169.t1 vdd.t7 1.22641191636467e-05f
CMODEL1156 a_9600_169.t1 vdd.t6 9.69415076711635e-05f
CMODEL1157 a_9600_169.t1 vdd.n2 0.000133408650823588f
CMODEL1158 a_9600_169.t1 vdd.t27 1.22641191636467e-05f
CMODEL1159 a_9600_169.t1 vdd.t26 9.69415076711635e-05f
CMODEL1160 a_9600_169.t1 vdd.n3 0.000250225191872135f
CMODEL1161 a_9600_169.t1 vdd.n4 0.000133408650823588f
CMODEL1162 a_9600_169.t1 vdd.t36 1.22641191636467e-05f
CMODEL1163 a_9600_169.t1 vdd.t35 9.69415076711635e-05f
CMODEL1164 a_9600_169.t1 vdd.n5 0.000190353175983144f
CMODEL1165 a_9600_169.t1 vdd.t3 1.95360016421015e-05f
CMODEL1166 a_9600_169.t1 vdd.n6 0.000186911183813155f
CMODEL1167 a_9600_169.t1 vdd.t2 0.000244959977348396f
CMODEL1168 a_9600_169.t1 vdd.n7 0.000250562201549353f
CMODEL1169 a_9600_169.t1 vdd.t25 1.95360016421015e-05f
CMODEL1170 a_9600_169.t1 vdd.n8 0.000112895995136908f
CMODEL1171 a_9600_169.t1 vdd.t24 0.000244959977348396f
CMODEL1172 a_9600_169.t1 vdd.n9 0.000250562201549353f
CMODEL1173 a_9600_169.t1 vdd.t5 1.95360016421015e-05f
CMODEL1174 a_9600_169.t1 vdd.n10 0.000334295625950981f
CMODEL1175 a_9600_169.t1 vdd.t4 0.000245094781219283f
CMODEL1176 a_9600_169.t1 vdd.n11 0.000808270529452991f
CMODEL1177 a_9600_169.t1 vdd.n12 0.00199289549257379f
CMODEL1178 a_9600_169.t1 vdd.n13 0.000151058970985095f
CMODEL1179 a_9600_169.t1 vdd.t42 1.22641191636467e-05f
CMODEL1180 a_9600_169.t1 vdd.t41 9.69415076711635e-05f
CMODEL1181 a_9600_169.t1 vdd.n14 0.000135813776553335f
CMODEL1182 a_9600_169.t1 vdd.t9 1.22641191636467e-05f
CMODEL1183 a_9600_169.t1 vdd.t8 9.69415076711635e-05f
CMODEL1184 a_9600_169.t1 vdd.n15 0.000260744387263705f
CMODEL1185 a_9600_169.t1 vdd.t15 2.06539750779933e-05f
CMODEL1186 a_9600_169.t1 vdd.n16 0.000162460008365386f
CMODEL1187 a_9600_169.t1 vdd.t14 0.00027860927025304f
CMODEL1188 a_9600_169.t1 vdd.n17 0.000227571401369529f
CMODEL1189 a_9600_169.t1 vdd.t32 0.00027860927025304f
CMODEL1190 a_9600_169.t1 vdd.n18 0.000224643910640093f
CMODEL1191 a_9600_169.t1 vdd.t34 2.06539750779933e-05f
CMODEL1192 a_9600_169.t1 vdd.n19 0.000226218869198293f
CMODEL1193 a_9600_169.t1 vdd.t33 0.00027860927025304f
CMODEL1194 a_9600_169.t1 vdd.n20 0.000451452546773518f
CMODEL1195 a_9600_169.t1 vdd.t48 0.000279141745543045f
CMODEL1196 a_9600_169.t1 vdd.n21 0.000801377558188288f
CMODEL1197 a_9600_169.t1 vdd.n22 0.00351193291166701f
CMODEL1198 a_9600_169.t1 vdd.t47 3.97050197945778e-06f
CMODEL1199 a_9600_169.t1 vdd.t45 3.92973504217029e-06f
CMODEL1200 a_9600_169.t1 vdd.n23 4.48730631947186e-05f
CMODEL1201 a_9600_169.t1 vdd.t46 0.000107092014475857f
CMODEL1202 a_9600_169.t1 vdd.n24 0.00011506072063024f
CMODEL1203 a_9600_169.t1 vdd.t44 0.000107092014475857f
CMODEL1204 a_9600_169.t1 vdd.n25 0.000181461737332537f
CMODEL1205 a_9600_169.t1 vdd.t43 0.000107323989470342f
CMODEL1206 a_9600_169.t1 vdd.n26 0.000970922633334391f
CMODEL1207 a_9600_169.t1 vdd.n27 0.000649081761687803f
CMODEL1208 a_9600_169.t1 vdd.n28 0.000146616060073769f
CMODEL1209 a_9600_169.t1 vdd.t29 1.22641191636467e-05f
CMODEL1210 a_9600_169.t1 vdd.t28 9.69415076711635e-05f
CMODEL1211 a_9600_169.t1 vdd.n29 2.18860824579029e-05f
CMODEL1212 a_9600_169.t1 vdd.n30 6.98214402529441e-06f
CMODEL1213 a_9600_169.t1 vdd.t38 3.2147353109842e-06f
CMODEL1214 a_9600_169.t1 vdd.t40 3.2147353109842e-06f
CMODEL1215 a_9600_169.t1 vdd.t37 6.49601879956309e-05f
CMODEL1216 a_9600_169.t1 vdd.t39 6.49601879956309e-05f
CMODEL1217 a_9600_169.t1 vdd.n31 2.10390648024946e-05f
CMODEL1218 a_9600_169.t1 vdd.n32 0.000253897473988222f
CMODEL1219 a_9600_169.t1 vdd.n33 0.000128650074181267f
CMODEL1220 a_9600_169.t1 vdd.t17 1.22641191636467e-05f
CMODEL1221 a_9600_169.t1 vdd.t16 9.69415076711635e-05f
CMODEL1222 a_9600_169.t1 vdd.n34 2.18860824579029e-05f
CMODEL1223 a_9600_169.t1 vdd.n35 6.98214402529441e-06f
CMODEL1224 a_9600_169.t1 vdd.t1 3.2147353109842e-06f
CMODEL1225 a_9600_169.t1 vdd.t31 3.2147353109842e-06f
CMODEL1226 a_9600_169.t1 vdd.t0 6.49601879956309e-05f
CMODEL1227 a_9600_169.t1 vdd.t30 6.49601879956309e-05f
CMODEL1228 a_9600_169.t1 vdd.n36 2.10390648024946e-05f
CMODEL1229 a_9600_169.t1 vdd.n37 0.000246230503831508f
CMODEL1230 a_9600_169.t1 vdd.n38 0.000142037221925964f
CMODEL1231 a_9600_169.t1 vdd.t19 1.22641191636467e-05f
CMODEL1232 a_9600_169.t1 vdd.t18 9.69415076711635e-05f
CMODEL1233 a_9600_169.t1 vdd.n39 0.000119859738433827f
CMODEL1234 a_9600_169.t1 vdd.t21 1.22642315002058e-05f
CMODEL1235 a_9600_169.t1 vdd.t20 9.69415076711635e-05f
CMODEL1236 a_9600_169.t1 vdd.n40 0.000119859738433827f
CMODEL1237 a_9600_169.t1 vdd.t11 1.22641191636467e-05f
CMODEL1238 a_9600_169.t1 vdd.t10 9.69415076711635e-05f
CMODEL1239 a_9600_169.t1 vdd.n41 0.000515658507111535f
CMODEL1240 a_9600_169.t1 vdd.n42 0.00098774278632435f
CMODEL1241 a_9600_169.t1 vdd.n43 0.000119859738433827f
CMODEL1242 a_9600_169.t1 vdd.t13 1.22641191636467e-05f
CMODEL1243 a_9600_169.t1 vdd.t12 9.69415076711635e-05f
CMODEL1244 a_9600_169.t1 vdd.n44 0.000119859738433827f
CMODEL1245 a_9600_169.t1 vdd.t23 1.22641191636467e-05f
CMODEL1246 a_9600_169.t1 vdd.t22 9.69415076711635e-05f
CMODEL1247 a_9600_169.t1 vdd.n45 0.00014796185205146f
CMODEL1248 a_9600_169.t1 vdd.n46 0.00244226419617651f
CMODEL1249 a_9600_169.n0 vdd 9.00732722492692e-05f
CMODEL1250 a_9600_169.n0 vdd.n0 0.0302269140407194f
CMODEL1251 a_9600_169.n0 vdd.n1 0.00280115103329759f
CMODEL1252 a_9600_169.n0 vdd.t7 0.000230916812092302f
CMODEL1253 a_9600_169.n0 vdd.t6 0.00182527775636764f
CMODEL1254 a_9600_169.n0 vdd.n2 0.00251190484556233f
CMODEL1255 a_9600_169.n0 vdd.t27 0.000230916812092302f
CMODEL1256 a_9600_169.n0 vdd.t26 0.00182527775636764f
CMODEL1257 a_9600_169.n0 vdd.n3 0.0047114026569126f
CMODEL1258 a_9600_169.n0 vdd.n4 0.00251190484556233f
CMODEL1259 a_9600_169.n0 vdd.t36 0.000230916812092302f
CMODEL1260 a_9600_169.n0 vdd.t35 0.00182527775636764f
CMODEL1261 a_9600_169.n0 vdd.n5 0.00358409340150298f
CMODEL1262 a_9600_169.n0 vdd.t3 0.000367836544967381f
CMODEL1263 a_9600_169.n0 vdd.n6 0.0035192853342839f
CMODEL1264 a_9600_169.n0 vdd.t2 0.00461226577340874f
CMODEL1265 a_9600_169.n0 vdd.n7 0.0047177480943035f
CMODEL1266 a_9600_169.n0 vdd.t25 0.000367836544967381f
CMODEL1267 a_9600_169.n0 vdd.n8 0.00212567922303611f
CMODEL1268 a_9600_169.n0 vdd.t24 0.00461226577340874f
CMODEL1269 a_9600_169.n0 vdd.n9 0.0047177480943035f
CMODEL1270 a_9600_169.n0 vdd.t5 0.000367836544967381f
CMODEL1271 a_9600_169.n0 vdd.n10 0.00629433546844692f
CMODEL1272 a_9600_169.n0 vdd.t4 0.0046148039483651f
CMODEL1273 a_9600_169.n0 vdd.n11 0.0152186432208429f
CMODEL1274 a_9600_169.n0 vdd.n12 0.0375235324965172f
CMODEL1275 a_9600_169.n0 vdd.n13 0.00284423655318182f
CMODEL1276 a_9600_169.n0 vdd.t42 0.000230916812092302f
CMODEL1277 a_9600_169.n0 vdd.t41 0.00182527775636764f
CMODEL1278 a_9600_169.n0 vdd.n14 0.0025571901170754f
CMODEL1279 a_9600_169.n0 vdd.t9 0.000230916812092302f
CMODEL1280 a_9600_169.n0 vdd.t8 0.00182527775636764f
CMODEL1281 a_9600_169.n0 vdd.n15 0.00490946490934061f
CMODEL1282 a_9600_169.n0 vdd.t15 0.000388886475938799f
CMODEL1283 a_9600_169.n0 vdd.n16 0.00305890270011602f
CMODEL1284 a_9600_169.n0 vdd.t14 0.0052458365454323f
CMODEL1285 a_9600_169.n0 vdd.n17 0.00428486235549619f
CMODEL1286 a_9600_169.n0 vdd.t32 0.0052458365454323f
CMODEL1287 a_9600_169.n0 vdd.n18 0.00422974165602722f
CMODEL1288 a_9600_169.n0 vdd.t34 0.000388886475938799f
CMODEL1289 a_9600_169.n0 vdd.n19 0.0042593960001007f
CMODEL1290 a_9600_169.n0 vdd.t33 0.0052458365454323f
CMODEL1291 a_9600_169.n0 vdd.n20 0.008500242171562f
CMODEL1292 a_9600_169.n0 vdd.t48 0.00525586233650993f
CMODEL1293 a_9600_169.n0 vdd.n21 0.015088857874741f
CMODEL1294 a_9600_169.n0 vdd.n22 0.0661249569922673f
CMODEL1295 a_9600_169.n0 vdd.t47 7.47591936500672e-05f
CMODEL1296 a_9600_169.n0 vdd.t45 7.39916072403478e-05f
CMODEL1297 a_9600_169.n0 vdd.n23 0.000844899218890149f
CMODEL1298 a_9600_169.n0 vdd.t46 0.00201639810029001f
CMODEL1299 a_9600_169.n0 vdd.n24 0.00216643808254367f
CMODEL1300 a_9600_169.n0 vdd.t44 0.00201639810029001f
CMODEL1301 a_9600_169.n0 vdd.n25 0.00341667961167302f
CMODEL1302 a_9600_169.n0 vdd.t43 0.00202076587636074f
CMODEL1303 a_9600_169.n0 vdd.n26 0.0182811628202717f
CMODEL1304 a_9600_169.n0 vdd.n27 0.0122213335663345f
CMODEL1305 a_9600_169.n0 vdd.n28 0.00276058253691176f
CMODEL1306 a_9600_169.n0 vdd.t29 0.000230916812092302f
CMODEL1307 a_9600_169.n0 vdd.t28 0.00182527775636764f
CMODEL1308 a_9600_169.n0 vdd.n29 0.000412085395039935f
CMODEL1309 a_9600_169.n0 vdd.n30 0.000131464348835541f
CMODEL1310 a_9600_169.n0 vdd.t38 6.05291272718108e-05f
CMODEL1311 a_9600_169.n0 vdd.t40 6.05291272718108e-05f
CMODEL1312 a_9600_169.n0 vdd.t37 0.00122311266913745f
CMODEL1313 a_9600_169.n0 vdd.t39 0.00122311266913745f
CMODEL1314 a_9600_169.n0 vdd.n31 0.000396137195730802f
CMODEL1315 a_9600_169.n0 vdd.n32 0.00478054677301545f
CMODEL1316 a_9600_169.n0 vdd.n33 0.0024223072696028f
CMODEL1317 a_9600_169.n0 vdd.t17 0.000230916812092302f
CMODEL1318 a_9600_169.n0 vdd.t16 0.00182527775636764f
CMODEL1319 a_9600_169.n0 vdd.n34 0.000412085395039935f
CMODEL1320 a_9600_169.n0 vdd.n35 0.000131464348835541f
CMODEL1321 a_9600_169.n0 vdd.t1 6.05291272718108e-05f
CMODEL1322 a_9600_169.n0 vdd.t31 6.05291272718108e-05f
CMODEL1323 a_9600_169.n0 vdd.t0 0.00122311266913745f
CMODEL1324 a_9600_169.n0 vdd.t30 0.00122311266913745f
CMODEL1325 a_9600_169.n0 vdd.n36 0.000396137195730802f
CMODEL1326 a_9600_169.n0 vdd.n37 0.00463618807237244f
CMODEL1327 a_9600_169.n0 vdd.n38 0.00267436919422738f
CMODEL1328 a_9600_169.n0 vdd.t19 0.000230916812092302f
CMODEL1329 a_9600_169.n0 vdd.t18 0.00182527775636764f
CMODEL1330 a_9600_169.n0 vdd.n39 0.00225679711099011f
CMODEL1331 a_9600_169.n0 vdd.t21 0.000230918927238099f
CMODEL1332 a_9600_169.n0 vdd.t20 0.00182527775636764f
CMODEL1333 a_9600_169.n0 vdd.n40 0.00225679711099011f
CMODEL1334 a_9600_169.n0 vdd.t11 0.000230916812092302f
CMODEL1335 a_9600_169.n0 vdd.t10 0.00182527775636764f
CMODEL1336 a_9600_169.n0 vdd.n41 0.00970915375181862f
CMODEL1337 a_9600_169.n0 vdd.n42 0.0185978636004516f
CMODEL1338 a_9600_169.n0 vdd.n43 0.00225679711099011f
CMODEL1339 a_9600_169.n0 vdd.t13 0.000230916812092302f
CMODEL1340 a_9600_169.n0 vdd.t12 0.00182527775636764f
CMODEL1341 a_9600_169.n0 vdd.n44 0.00225679711099011f
CMODEL1342 a_9600_169.n0 vdd.t23 0.000230916812092302f
CMODEL1343 a_9600_169.n0 vdd.t22 0.00182527775636764f
CMODEL1344 a_9600_169.n0 vdd.n45 0.00278592198355943f
CMODEL1345 a_9600_169.n0 vdd.n46 0.0459845387135455f
CMODEL1346 a_9600_169.t2 vdd 6.98393307540618e-06f
CMODEL1347 a_9600_169.t2 vdd.n0 0.00234367797976999f
CMODEL1348 a_9600_169.t2 vdd.n1 0.000217190414671695f
CMODEL1349 a_9600_169.t2 vdd.t7 1.79043962916742e-05f
CMODEL1350 a_9600_169.t2 vdd.t6 0.000141524976013099f
CMODEL1351 a_9600_169.t2 vdd.n2 0.000194763384243966f
CMODEL1352 a_9600_169.t2 vdd.t27 1.79043962916742e-05f
CMODEL1353 a_9600_169.t2 vdd.t26 0.000141524976013099f
CMODEL1354 a_9600_169.t2 vdd.n3 0.00036530393562376f
CMODEL1355 a_9600_169.t2 vdd.n4 0.000194763384243966f
CMODEL1356 a_9600_169.t2 vdd.t36 1.79043962916742e-05f
CMODEL1357 a_9600_169.t2 vdd.t35 0.000141524976013099f
CMODEL1358 a_9600_169.t2 vdd.n5 0.000277896737034606f
CMODEL1359 a_9600_169.t2 vdd.t3 2.8520622695171e-05f
CMODEL1360 a_9600_169.t2 vdd.n6 0.000272871770217015f
CMODEL1361 a_9600_169.t2 vdd.t2 0.000357617245194892f
CMODEL1362 a_9600_169.t2 vdd.n7 0.000365795936291278f
CMODEL1363 a_9600_169.t2 vdd.t25 2.8520622695171e-05f
CMODEL1364 a_9600_169.t2 vdd.n8 0.000164816943614326f
CMODEL1365 a_9600_169.t2 vdd.t24 0.000357617245194892f
CMODEL1366 a_9600_169.t2 vdd.n9 0.000365795936291278f
CMODEL1367 a_9600_169.t2 vdd.t5 2.8520622695171e-05f
CMODEL1368 a_9600_169.t2 vdd.n10 0.000488038422142983f
CMODEL1369 a_9600_169.t2 vdd.t4 0.0003578140454619f
CMODEL1370 a_9600_169.t2 vdd.n11 0.00117999472095023f
CMODEL1371 a_9600_169.t2 vdd.n12 0.00290942954734978f
CMODEL1372 a_9600_169.t2 vdd.n13 0.000220531099204147f
CMODEL1373 a_9600_169.t2 vdd.t42 1.79043962916742e-05f
CMODEL1374 a_9600_169.t2 vdd.t41 0.000141524976013099f
CMODEL1375 a_9600_169.t2 vdd.n14 0.000198274629007825f
CMODEL1376 a_9600_169.t2 vdd.t9 1.79043962916742e-05f
CMODEL1377 a_9600_169.t2 vdd.t8 0.000141524976013099f
CMODEL1378 a_9600_169.t2 vdd.n15 0.000380660916459244f
CMODEL1379 a_9600_169.t2 vdd.t15 3.01527529095531e-05f
CMODEL1380 a_9600_169.t2 vdd.n16 0.000237175481786306f
CMODEL1381 a_9600_169.t2 vdd.t14 0.000406741871844413f
CMODEL1382 a_9600_169.t2 vdd.n17 0.00033223165075315f
CMODEL1383 a_9600_169.t2 vdd.t32 0.000406741871844413f
CMODEL1384 a_9600_169.t2 vdd.n18 0.000327957804954638f
CMODEL1385 a_9600_169.t2 vdd.t34 3.01527529095531e-05f
CMODEL1386 a_9600_169.t2 vdd.n19 0.000330257088074175f
CMODEL1387 a_9600_169.t2 vdd.t33 0.000406741871844413f
CMODEL1388 a_9600_169.t2 vdd.n20 0.000659075894196971f
CMODEL1389 a_9600_169.t2 vdd.t48 0.000407519232899092f
CMODEL1390 a_9600_169.t2 vdd.n21 0.00116993166729725f
CMODEL1391 a_9600_169.t2 vdd.n22 0.00512707335612372f
CMODEL1392 a_9600_169.t2 vdd.t47 5.79653866441646e-06f
CMODEL1393 a_9600_169.t2 vdd.t45 5.73702298366895e-06f
CMODEL1394 a_9600_169.t2 vdd.n23 6.55102168805644e-05f
CMODEL1395 a_9600_169.t2 vdd.t46 0.000156343708118318f
CMODEL1396 a_9600_169.t2 vdd.n24 0.000167977227902021f
CMODEL1397 a_9600_169.t2 vdd.t44 0.000156343708118318f
CMODEL1398 a_9600_169.t2 vdd.n25 0.000264916119423237f
CMODEL1399 a_9600_169.t2 vdd.t43 0.000156682368577794f
CMODEL1400 a_9600_169.t2 vdd.n26 0.00141745064311702f
CMODEL1401 a_9600_169.t2 vdd.n27 0.000947594925643307f
CMODEL1402 a_9600_169.t2 vdd.n28 0.000214044890404025f
CMODEL1403 a_9600_169.t2 vdd.t29 1.79043962916742e-05f
CMODEL1404 a_9600_169.t2 vdd.t28 0.000141524976013099f
CMODEL1405 a_9600_169.t2 vdd.n29 3.19515073500016e-05f
CMODEL1406 a_9600_169.t2 vdd.n30 1.01932370296086e-05f
CMODEL1407 a_9600_169.t2 vdd.t38 4.6931943674612e-06f
CMODEL1408 a_9600_169.t2 vdd.t40 4.6931943674612e-06f
CMODEL1409 a_9600_169.t2 vdd.t37 9.4835424667351e-05f
CMODEL1410 a_9600_169.t2 vdd.t39 9.4835424667351e-05f
CMODEL1411 a_9600_169.t2 vdd.n31 3.07149456723045e-05f
CMODEL1412 a_9600_169.t2 vdd.n32 0.000370665102897489f
CMODEL1413 a_9600_169.t2 vdd.n33 0.000187816334818601f
CMODEL1414 a_9600_169.t2 vdd.t17 1.79043962916742e-05f
CMODEL1415 a_9600_169.t2 vdd.t16 0.000141524976013099f
CMODEL1416 a_9600_169.t2 vdd.n34 3.19515073500016e-05f
CMODEL1417 a_9600_169.t2 vdd.n35 1.01932370296086e-05f
CMODEL1418 a_9600_169.t2 vdd.t1 4.6931943674612e-06f
CMODEL1419 a_9600_169.t2 vdd.t31 4.6931943674612e-06f
CMODEL1420 a_9600_169.t2 vdd.t0 9.4835424667351e-05f
CMODEL1421 a_9600_169.t2 vdd.t30 9.4835424667351e-05f
CMODEL1422 a_9600_169.t2 vdd.n36 3.07149456723045e-05f
CMODEL1423 a_9600_169.t2 vdd.n37 0.000359472087711438f
CMODEL1424 a_9600_169.t2 vdd.n38 0.000207360241334671f
CMODEL1425 a_9600_169.t2 vdd.t19 1.79043962916742e-05f
CMODEL1426 a_9600_169.t2 vdd.t18 0.000141524976013099f
CMODEL1427 a_9600_169.t2 vdd.n39 0.000174983317407488f
CMODEL1428 a_9600_169.t2 vdd.t21 1.79045602918968e-05f
CMODEL1429 a_9600_169.t2 vdd.t20 0.000141524976013099f
CMODEL1430 a_9600_169.t2 vdd.n40 0.000174983317407488f
CMODEL1431 a_9600_169.t2 vdd.t11 1.79043962916742e-05f
CMODEL1432 a_9600_169.t2 vdd.t10 0.000141524976013099f
CMODEL1433 a_9600_169.t2 vdd.n41 0.000752810221370415f
CMODEL1434 a_9600_169.t2 vdd.n42 0.00144200639643288f
CMODEL1435 a_9600_169.t2 vdd.n43 0.000174983317407488f
CMODEL1436 a_9600_169.t2 vdd.t13 1.79043962916742e-05f
CMODEL1437 a_9600_169.t2 vdd.t12 0.000141524976013099f
CMODEL1438 a_9600_169.t2 vdd.n44 0.000174983317407488f
CMODEL1439 a_9600_169.t2 vdd.t23 1.79043962916742e-05f
CMODEL1440 a_9600_169.t2 vdd.t22 0.000141524976013099f
CMODEL1441 a_9600_169.t2 vdd.n45 0.00021600961306965f
CMODEL1442 a_9600_169.t2 vdd.n46 0.00356546323741926f
CMODEL1443 a_9600_169.t3 vdd 1.45777759031049e-05f
CMODEL1444 a_9600_169.t3 vdd.n0 0.00489203032291965f
CMODEL1445 a_9600_169.t3 vdd.n1 0.000453348157721608f
CMODEL1446 a_9600_169.t3 vdd.t7 3.7372390886668e-05f
CMODEL1447 a_9600_169.t3 vdd.t6 0.0002954093864783f
CMODEL1448 a_9600_169.t3 vdd.n2 0.000406535535060768f
CMODEL1449 a_9600_169.t3 vdd.t27 3.7372390886668e-05f
CMODEL1450 a_9600_169.t3 vdd.t26 0.0002954093864783f
CMODEL1451 a_9600_169.t3 vdd.n3 0.000762510014421309f
CMODEL1452 a_9600_169.t3 vdd.n4 0.000406535535060768f
CMODEL1453 a_9600_169.t3 vdd.t36 3.7372390886668e-05f
CMODEL1454 a_9600_169.t3 vdd.t35 0.0002954093864783f
CMODEL1455 a_9600_169.t3 vdd.n5 0.000580062310585494f
CMODEL1456 a_9600_169.t3 vdd.t3 5.95319631185081e-05f
CMODEL1457 a_9600_169.t3 vdd.n6 0.00056957354452825f
CMODEL1458 a_9600_169.t3 vdd.t2 0.000746465351722124f
CMODEL1459 a_9600_169.t3 vdd.n7 0.000763536982377305f
CMODEL1460 a_9600_169.t3 vdd.t25 5.95319631185081e-05f
CMODEL1461 a_9600_169.t3 vdd.n8 0.000344027418805782f
CMODEL1462 a_9600_169.t3 vdd.t24 0.000746465351722124f
CMODEL1463 a_9600_169.t3 vdd.n9 0.000763536982377305f
CMODEL1464 a_9600_169.t3 vdd.t5 5.95319631185081e-05f
CMODEL1465 a_9600_169.t3 vdd.n10 0.00101869744072419f
CMODEL1466 a_9600_169.t3 vdd.t4 0.000746876138904522f
CMODEL1467 a_9600_169.t3 vdd.n11 0.00246303886694373f
CMODEL1468 a_9600_169.t3 vdd.n12 0.00607294077552f
CMODEL1469 a_9600_169.t3 vdd.n13 0.000460321270142824f
CMODEL1470 a_9600_169.t3 vdd.t42 3.7372390886668e-05f
CMODEL1471 a_9600_169.t3 vdd.t41 0.0002954093864783f
CMODEL1472 a_9600_169.t3 vdd.n14 0.000413864663040063f
CMODEL1473 a_9600_169.t3 vdd.t9 3.7372390886668e-05f
CMODEL1474 a_9600_169.t3 vdd.t8 0.0002954093864783f
CMODEL1475 a_9600_169.t3 vdd.n15 0.000794565107554479f
CMODEL1476 a_9600_169.t3 vdd.t15 6.29387581512005e-05f
CMODEL1477 a_9600_169.t3 vdd.n16 0.000495063596094185f
CMODEL1478 a_9600_169.t3 vdd.t14 0.000849004678901853f
CMODEL1479 a_9600_169.t3 vdd.n17 0.000693477228419225f
CMODEL1480 a_9600_169.t3 vdd.t32 0.000849004678901853f
CMODEL1481 a_9600_169.t3 vdd.n18 0.000684556300108136f
CMODEL1482 a_9600_169.t3 vdd.t34 6.29387581512005e-05f
CMODEL1483 a_9600_169.t3 vdd.n19 0.000689355663689159f
CMODEL1484 a_9600_169.t3 vdd.t33 0.000849004678901853f
CMODEL1485 a_9600_169.t3 vdd.n20 0.00137570915772029f
CMODEL1486 a_9600_169.t3 vdd.t48 0.000850627288272327f
CMODEL1487 a_9600_169.t3 vdd.n21 0.00244203394901708f
CMODEL1488 a_9600_169.t3 vdd.n22 0.0107018961403786f
CMODEL1489 a_9600_169.t3 vdd.t47 1.2099291438103e-05f
CMODEL1490 a_9600_169.t3 vdd.t45 1.19750625476926e-05f
CMODEL1491 a_9600_169.t3 vdd.n23 0.000136741467986236f
CMODEL1492 a_9600_169.t3 vdd.t46 0.00032634097666761f
CMODEL1493 a_9600_169.t3 vdd.n24 0.000350623976309799f
CMODEL1494 a_9600_169.t3 vdd.t44 0.00032634097666761f
CMODEL1495 a_9600_169.t3 vdd.n25 0.000552967472679786f
CMODEL1496 a_9600_169.t3 vdd.t43 0.000327047872943988f
CMODEL1497 a_9600_169.t3 vdd.n26 0.00295868783477283f
CMODEL1498 a_9600_169.t3 vdd.n27 0.00197794370647575f
CMODEL1499 a_9600_169.t3 vdd.n28 0.00044678240925627f
CMODEL1500 a_9600_169.t3 vdd.t29 3.7372390886668e-05f
CMODEL1501 a_9600_169.t3 vdd.t28 0.0002954093864783f
CMODEL1502 a_9600_169.t3 vdd.n29 6.66933529983236e-05f
CMODEL1503 a_9600_169.t3 vdd.n30 2.12766536478047e-05f
CMODEL1504 a_9600_169.t3 vdd.t38 9.79624733225045e-06f
CMODEL1505 a_9600_169.t3 vdd.t40 9.79624733225045e-06f
CMODEL1506 a_9600_169.t3 vdd.t37 0.00019795286603545f
CMODEL1507 a_9600_169.t3 vdd.t39 0.00019795286603545f
CMODEL1508 a_9600_169.t3 vdd.n31 6.41122402022525e-05f
CMODEL1509 a_9600_169.t3 vdd.n32 0.000773700541915151f
CMODEL1510 a_9600_169.t3 vdd.n33 0.000392034747522098f
CMODEL1511 a_9600_169.t3 vdd.t17 3.7372390886668e-05f
CMODEL1512 a_9600_169.t3 vdd.t16 0.0002954093864783f
CMODEL1513 a_9600_169.t3 vdd.n34 6.66933529983236e-05f
CMODEL1514 a_9600_169.t3 vdd.n35 2.12766536478047e-05f
CMODEL1515 a_9600_169.t3 vdd.t1 9.79624733225045e-06f
CMODEL1516 a_9600_169.t3 vdd.t31 9.79624733225045e-06f
CMODEL1517 a_9600_169.t3 vdd.t0 0.00019795286603545f
CMODEL1518 a_9600_169.t3 vdd.t30 0.00019795286603545f
CMODEL1519 a_9600_169.t3 vdd.n36 6.41122402022525e-05f
CMODEL1520 a_9600_169.t3 vdd.n37 0.000750337020916231f
CMODEL1521 a_9600_169.t3 vdd.n38 0.000432829337960798f
CMODEL1522 a_9600_169.t3 vdd.t19 3.7372390886668e-05f
CMODEL1523 a_9600_169.t3 vdd.t18 0.0002954093864783f
CMODEL1524 a_9600_169.t3 vdd.n39 0.000365248000003189f
CMODEL1525 a_9600_169.t3 vdd.t21 3.737273320932e-05f
CMODEL1526 a_9600_169.t3 vdd.t20 0.0002954093864783f
CMODEL1527 a_9600_169.t3 vdd.n40 0.000365248000003189f
CMODEL1528 a_9600_169.t3 vdd.t11 3.7372390886668e-05f
CMODEL1529 a_9600_169.t3 vdd.t10 0.0002954093864783f
CMODEL1530 a_9600_169.t3 vdd.n41 0.00157136366947022f
CMODEL1531 a_9600_169.t3 vdd.n42 0.00300994380545661f
CMODEL1532 a_9600_169.t3 vdd.n43 0.000365248000003189f
CMODEL1533 a_9600_169.t3 vdd.t13 3.7372390886668e-05f
CMODEL1534 a_9600_169.t3 vdd.t12 0.0002954093864783f
CMODEL1535 a_9600_169.t3 vdd.n44 0.000365248000003189f
CMODEL1536 a_9600_169.t3 vdd.t23 3.7372390886668e-05f
CMODEL1537 a_9600_169.t3 vdd.t22 0.0002954093864783f
CMODEL1538 a_9600_169.t3 vdd.n45 0.000450883434627216f
CMODEL1539 a_9600_169.t3 vdd.n46 0.00744229984804571f
CMODEL1540 a_9600_169.t4 vdd 3.10478365372597e-06f
CMODEL1541 a_9600_169.t4 vdd.n0 0.00104190761890486f
CMODEL1542 a_9600_169.t4 vdd.n1 9.65543687114191e-05f
CMODEL1543 a_9600_169.t4 vdd.t7 7.95959473494655e-06f
CMODEL1544 a_9600_169.t4 vdd.t6 6.29164723337321e-05f
CMODEL1545 a_9600_169.t4 vdd.n2 8.65841876226523e-05f
CMODEL1546 a_9600_169.t4 vdd.t27 7.95959473494655e-06f
CMODEL1547 a_9600_169.t4 vdd.t26 6.29164723337321e-05f
CMODEL1548 a_9600_169.t4 vdd.n3 0.000162399850588552f
CMODEL1549 a_9600_169.t4 vdd.n4 8.65841876226523e-05f
CMODEL1550 a_9600_169.t4 vdd.t36 7.95959473494655e-06f
CMODEL1551 a_9600_169.t4 vdd.t35 6.29164723337321e-05f
CMODEL1552 a_9600_169.t4 vdd.n5 0.000123542026713744f
CMODEL1553 a_9600_169.t4 vdd.t3 1.26791540213754e-05f
CMODEL1554 a_9600_169.t4 vdd.n6 0.000121308122885153f
CMODEL1555 a_9600_169.t4 vdd.t2 0.000158982648485222f
CMODEL1556 a_9600_169.t4 vdd.n7 0.000162618574853754f
CMODEL1557 a_9600_169.t4 vdd.t25 1.26791540213754e-05f
CMODEL1558 a_9600_169.t4 vdd.n8 7.32711706807231e-05f
CMODEL1559 a_9600_169.t4 vdd.t24 0.000158982648485222f
CMODEL1560 a_9600_169.t4 vdd.n9 0.000162618574853754f
CMODEL1561 a_9600_169.t4 vdd.t5 1.26791540213754e-05f
CMODEL1562 a_9600_169.t4 vdd.n10 0.00021696280578571f
CMODEL1563 a_9600_169.t4 vdd.t4 0.000159070138191302f
CMODEL1564 a_9600_169.t4 vdd.n11 0.000524579528688588f
CMODEL1565 a_9600_169.t4 vdd.n12 0.00129341865146003f
CMODEL1566 a_9600_169.t4 vdd.n13 9.80395064721371e-05f
CMODEL1567 a_9600_169.t4 vdd.t42 7.95959473494655e-06f
CMODEL1568 a_9600_169.t4 vdd.t41 6.29164723337321e-05f
CMODEL1569 a_9600_169.t4 vdd.n14 8.81451497953068e-05f
CMODEL1570 a_9600_169.t4 vdd.t9 7.95959473494655e-06f
CMODEL1571 a_9600_169.t4 vdd.t8 6.29164723337321e-05f
CMODEL1572 a_9600_169.t4 vdd.n15 0.000169226963986374f
CMODEL1573 a_9600_169.t4 vdd.t15 1.3404735317137e-05f
CMODEL1574 a_9600_169.t4 vdd.n16 0.000105438948363903f
CMODEL1575 a_9600_169.t4 vdd.t14 0.000180821537284704f
CMODEL1576 a_9600_169.t4 vdd.n17 0.00014769720548171f
CMODEL1577 a_9600_169.t4 vdd.t32 0.000180821537284704f
CMODEL1578 a_9600_169.t4 vdd.n18 0.000145797220697993f
CMODEL1579 a_9600_169.t4 vdd.t34 1.3404735317137e-05f
CMODEL1580 a_9600_169.t4 vdd.n19 0.000146819392097368f
CMODEL1581 a_9600_169.t4 vdd.t33 0.000180821537284704f
CMODEL1582 a_9600_169.t4 vdd.n20 0.000292999380259464f
CMODEL1583 a_9600_169.t4 vdd.t48 0.000181167121623722f
CMODEL1584 a_9600_169.t4 vdd.n21 0.000520105888384334f
CMODEL1585 a_9600_169.t4 vdd.n22 0.00227929640442912f
CMODEL1586 a_9600_169.t4 vdd.t47 2.57691451208875e-06f
CMODEL1587 a_9600_169.t4 vdd.t45 2.55045616680821e-06f
CMODEL1588 a_9600_169.t4 vdd.n23 2.9123281727752e-05f
CMODEL1589 a_9600_169.t4 vdd.t46 6.95043013854234e-05f
CMODEL1590 a_9600_169.t4 vdd.n24 7.46761095442005e-05f
CMODEL1591 a_9600_169.t4 vdd.t44 6.95043013854234e-05f
CMODEL1592 a_9600_169.t4 vdd.n25 0.000117771351516845f
CMODEL1593 a_9600_169.t4 vdd.t43 6.96548565879705e-05f
CMODEL1594 a_9600_169.t4 vdd.n26 0.000630143149883655f
CMODEL1595 a_9600_169.t4 vdd.n27 0.000421263663858908f
CMODEL1596 a_9600_169.t4 vdd.n28 9.51559915758978e-05f
CMODEL1597 a_9600_169.t4 vdd.t29 7.95959473494655e-06f
CMODEL1598 a_9600_169.t4 vdd.t28 6.29164723337321e-05f
CMODEL1599 a_9600_169.t4 vdd.n29 1.42043912307136e-05f
CMODEL1600 a_9600_169.t4 vdd.n30 4.53151474482629e-06f
CMODEL1601 a_9600_169.t4 vdd.t38 2.08641076575678e-06f
CMODEL1602 a_9600_169.t4 vdd.t40 2.08641076575678e-06f
CMODEL1603 a_9600_169.t4 vdd.t37 4.21601228308202e-05f
CMODEL1604 a_9600_169.t4 vdd.t39 4.21601228308202e-05f
CMODEL1605 a_9600_169.t4 vdd.n31 1.36546642441739e-05f
CMODEL1606 a_9600_169.t4 vdd.n32 0.000164783215998364f
CMODEL1607 a_9600_169.t4 vdd.n33 8.34958009980076e-05f
CMODEL1608 a_9600_169.t4 vdd.t17 7.95959473494655e-06f
CMODEL1609 a_9600_169.t4 vdd.t16 6.29164723337321e-05f
CMODEL1610 a_9600_169.t4 vdd.n34 1.42043912307136e-05f
CMODEL1611 a_9600_169.t4 vdd.n35 4.53151474482629e-06f
CMODEL1612 a_9600_169.t4 vdd.t1 2.08641076575678e-06f
CMODEL1613 a_9600_169.t4 vdd.t31 2.08641076575678e-06f
CMODEL1614 a_9600_169.t4 vdd.t0 4.21601228308202e-05f
CMODEL1615 a_9600_169.t4 vdd.t30 4.21601228308202e-05f
CMODEL1616 a_9600_169.t4 vdd.n36 1.36546642441739e-05f
CMODEL1617 a_9600_169.t4 vdd.n37 0.000159807238965031f
CMODEL1618 a_9600_169.t4 vdd.n38 9.21842578926939e-05f
CMODEL1619 a_9600_169.t4 vdd.t19 7.95959473494655e-06f
CMODEL1620 a_9600_169.t4 vdd.t18 6.29164723337321e-05f
CMODEL1621 a_9600_169.t4 vdd.n39 7.77907430806694e-05f
CMODEL1622 a_9600_169.t4 vdd.t21 7.95966764303495e-06f
CMODEL1623 a_9600_169.t4 vdd.t20 6.29164723337321e-05f
CMODEL1624 a_9600_169.t4 vdd.n40 7.77907430806694e-05f
CMODEL1625 a_9600_169.t4 vdd.t11 7.95959473494655e-06f
CMODEL1626 a_9600_169.t4 vdd.t10 6.29164723337321e-05f
CMODEL1627 a_9600_169.t4 vdd.n41 0.000334669998184763f
CMODEL1628 a_9600_169.t4 vdd.n42 0.000641059677959861f
CMODEL1629 a_9600_169.t4 vdd.n43 7.77907430806694e-05f
CMODEL1630 a_9600_169.t4 vdd.t13 7.95959473494655e-06f
CMODEL1631 a_9600_169.t4 vdd.t12 6.29164723337321e-05f
CMODEL1632 a_9600_169.t4 vdd.n44 7.77907430806694e-05f
CMODEL1633 a_9600_169.t4 vdd.t23 7.95959473494655e-06f
CMODEL1634 a_9600_169.t4 vdd.t22 6.29164723337321e-05f
CMODEL1635 a_9600_169.t4 vdd.n45 9.60294304749356e-05f
CMODEL1636 a_9600_169.t4 vdd.n46 0.00158506558667966f
CMODEL1637 a_9600_169.t0 vdd 7.76537458975408e-06f
CMODEL1638 a_9600_169.t0 vdd.n0 0.00260591521055113f
CMODEL1639 a_9600_169.t0 vdd.n1 0.00024149213759922f
CMODEL1640 a_9600_169.t0 vdd.t7 1.99077428874371e-05f
CMODEL1641 a_9600_169.t0 vdd.t6 0.000157360392873432f
CMODEL1642 a_9600_169.t0 vdd.n2 0.000216555717056988f
CMODEL1643 a_9600_169.t0 vdd.t27 1.99077428874371e-05f
CMODEL1644 a_9600_169.t0 vdd.t26 0.000157360392873432f
CMODEL1645 a_9600_169.t0 vdd.n3 0.000406178276424123f
CMODEL1646 a_9600_169.t0 vdd.n4 0.000216555717056988f
CMODEL1647 a_9600_169.t0 vdd.t36 1.99077428874371e-05f
CMODEL1648 a_9600_169.t0 vdd.t35 0.000157360392873432f
CMODEL1649 a_9600_169.t0 vdd.n5 0.000308990970710096f
CMODEL1650 a_9600_169.t0 vdd.t3 3.17118329127407e-05f
CMODEL1651 a_9600_169.t0 vdd.n6 0.000303403753705241f
CMODEL1652 a_9600_169.t0 vdd.t2 0.000397631512030599f
CMODEL1653 a_9600_169.t0 vdd.n7 0.000406725327697444f
CMODEL1654 a_9600_169.t0 vdd.t25 3.17118329127407e-05f
CMODEL1655 a_9600_169.t0 vdd.n8 0.000183258529554162f
CMODEL1656 a_9600_169.t0 vdd.t24 0.000397631512030599f
CMODEL1657 a_9600_169.t0 vdd.n9 0.000406725327697444f
CMODEL1658 a_9600_169.t0 vdd.t5 3.17118329127407e-05f
CMODEL1659 a_9600_169.t0 vdd.n10 0.000542645687066866f
CMODEL1660 a_9600_169.t0 vdd.t4 0.000397850332539927f
CMODEL1661 a_9600_169.t0 vdd.n11 0.00131202589188299f
CMODEL1662 a_9600_169.t0 vdd.n12 0.00323496946974334f
CMODEL1663 a_9600_169.t0 vdd.n13 0.000245206615745072f
CMODEL1664 a_9600_169.t0 vdd.t42 1.99077428874371e-05f
CMODEL1665 a_9600_169.t0 vdd.t41 0.000157360392873432f
CMODEL1666 a_9600_169.t0 vdd.n14 0.000220459839644258f
CMODEL1667 a_9600_169.t0 vdd.t9 1.99077428874371e-05f
CMODEL1668 a_9600_169.t0 vdd.t8 0.000157360392873432f
CMODEL1669 a_9600_169.t0 vdd.n15 0.000423253570168726f
CMODEL1670 a_9600_169.t0 vdd.t15 3.35265843367721e-05f
CMODEL1671 a_9600_169.t0 vdd.n16 0.000263713360321533f
CMODEL1672 a_9600_169.t0 vdd.t14 0.000452252758167491f
CMODEL1673 a_9600_169.t0 vdd.n17 0.000369405489831462f
CMODEL1674 a_9600_169.t0 vdd.t32 0.000452252758167491f
CMODEL1675 a_9600_169.t0 vdd.n18 0.000364653437770544f
CMODEL1676 a_9600_169.t0 vdd.t34 3.35265843367721e-05f
CMODEL1677 a_9600_169.t0 vdd.n19 0.000367209990721199f
CMODEL1678 a_9600_169.t0 vdd.t33 0.000452252758167491f
CMODEL1679 a_9600_169.t0 vdd.n20 0.000732820768220055f
CMODEL1680 a_9600_169.t0 vdd.t48 0.000453117099179339f
CMODEL1681 a_9600_169.t0 vdd.n21 0.00130083686983932f
CMODEL1682 a_9600_169.t0 vdd.n22 0.00570074837911198f
CMODEL1683 a_9600_169.t0 vdd.t47 6.44512104672034e-06f
CMODEL1684 a_9600_169.t0 vdd.t45 6.3789460776909e-06f
CMODEL1685 a_9600_169.t0 vdd.n23 7.28402417435862e-05f
CMODEL1686 a_9600_169.t0 vdd.t46 0.000173837212525022f
CMODEL1687 a_9600_169.t0 vdd.n24 0.00018677242223313f
CMODEL1688 a_9600_169.t0 vdd.t44 0.000173837212525022f
CMODEL1689 a_9600_169.t0 vdd.n25 0.000294557934615635f
CMODEL1690 a_9600_169.t0 vdd.t43 0.000174213766151492f
CMODEL1691 a_9600_169.t0 vdd.n26 0.00157605107143031f
CMODEL1692 a_9600_169.t0 vdd.n27 0.00105362257592116f
CMODEL1693 a_9600_169.t0 vdd.n28 0.000237994656458452f
CMODEL1694 a_9600_169.t0 vdd.t29 1.99077428874371e-05f
CMODEL1695 a_9600_169.t0 vdd.t28 0.000157360392873432f
CMODEL1696 a_9600_169.t0 vdd.n29 3.55266037920349e-05f
CMODEL1697 a_9600_169.t0 vdd.n30 1.13337718105868e-05f
CMODEL1698 a_9600_169.t0 vdd.t38 5.21832209621233e-06f
CMODEL1699 a_9600_169.t0 vdd.t40 5.21832209621233e-06f
CMODEL1700 a_9600_169.t0 vdd.t37 0.000105446685838632f
CMODEL1701 a_9600_169.t0 vdd.t39 0.000105446685838632f
CMODEL1702 a_9600_169.t0 vdd.n31 3.41516815917539e-05f
CMODEL1703 a_9600_169.t0 vdd.n32 0.000412139311799081f
CMODEL1704 a_9600_169.t0 vdd.n33 0.000208831353077691f
CMODEL1705 a_9600_169.t0 vdd.t17 1.99077428874371e-05f
CMODEL1706 a_9600_169.t0 vdd.t16 0.000157360392873432f
CMODEL1707 a_9600_169.t0 vdd.n34 3.55266037920349e-05f
CMODEL1708 a_9600_169.t0 vdd.n35 1.13337718105868e-05f
CMODEL1709 a_9600_169.t0 vdd.t1 5.21832209621233e-06f
CMODEL1710 a_9600_169.t0 vdd.t31 5.21832209621233e-06f
CMODEL1711 a_9600_169.t0 vdd.t0 0.000105446685838632f
CMODEL1712 a_9600_169.t0 vdd.t30 0.000105446685838632f
CMODEL1713 a_9600_169.t0 vdd.n36 3.41516815917539e-05f
CMODEL1714 a_9600_169.t0 vdd.n37 0.00039969389533102f
CMODEL1715 a_9600_169.t0 vdd.n38 0.000230562053158259f
CMODEL1716 a_9600_169.t0 vdd.t19 1.99077428874371e-05f
CMODEL1717 a_9600_169.t0 vdd.t18 0.000157360392873432f
CMODEL1718 a_9600_169.t0 vdd.n39 0.000194562432365226f
CMODEL1719 a_9600_169.t0 vdd.t21 1.99079252378616e-05f
CMODEL1720 a_9600_169.t0 vdd.t20 0.000157360392873432f
CMODEL1721 a_9600_169.t0 vdd.n40 0.000194562432365226f
CMODEL1722 a_9600_169.t0 vdd.t11 1.99077428874371e-05f
CMODEL1723 a_9600_169.t0 vdd.t10 0.000157360392873432f
CMODEL1724 a_9600_169.t0 vdd.n41 0.000837043153308993f
CMODEL1725 a_9600_169.t0 vdd.n42 0.00160335440048178f
CMODEL1726 a_9600_169.t0 vdd.n43 0.000194562432365226f
CMODEL1727 a_9600_169.t0 vdd.t13 1.99077428874371e-05f
CMODEL1728 a_9600_169.t0 vdd.t12 0.000157360392873432f
CMODEL1729 a_9600_169.t0 vdd.n44 0.000194562432365226f
CMODEL1730 a_9600_169.t0 vdd.t23 1.99077428874371e-05f
CMODEL1731 a_9600_169.t0 vdd.t22 0.000157360392873432f
CMODEL1732 a_9600_169.t0 vdd.n45 0.000240179214543249f
CMODEL1733 a_9600_169.t0 vdd.n46 0.00396440763759003f
CMODEL1734 a_9600_169.n1 vdd 7.02102565598195e-06f
CMODEL1735 a_9600_169.n1 vdd.n0 0.0023561255595749f
CMODEL1736 a_9600_169.n1 vdd.n1 0.000218343941326305f
CMODEL1737 a_9600_169.n1 vdd.t7 1.79994888784644e-05f
CMODEL1738 a_9600_169.n1 vdd.t6 0.000142276633642055f
CMODEL1739 a_9600_169.n1 vdd.n2 0.000195797798011291f
CMODEL1740 a_9600_169.n1 vdd.t27 1.79994888784644e-05f
CMODEL1741 a_9600_169.n1 vdd.t26 0.000142276633642055f
CMODEL1742 a_9600_169.n1 vdd.n3 0.000367244112529877f
CMODEL1743 a_9600_169.n1 vdd.n4 0.000195797798011291f
CMODEL1744 a_9600_169.n1 vdd.t36 1.79994888784644e-05f
CMODEL1745 a_9600_169.n1 vdd.t35 0.000142276633642055f
CMODEL1746 a_9600_169.n1 vdd.n5 0.000279372682894755f
CMODEL1747 a_9600_169.n1 vdd.t3 2.86720994467334e-05f
CMODEL1748 a_9600_169.n1 vdd.n6 0.000274321027822199f
CMODEL1749 a_9600_169.n1 vdd.t2 0.000359516597084358f
CMODEL1750 a_9600_169.n1 vdd.n7 0.00036773872627719f
CMODEL1751 a_9600_169.n1 vdd.t25 2.86720994467334e-05f
CMODEL1752 a_9600_169.n1 vdd.n8 0.000165692307924845f
CMODEL1753 a_9600_169.n1 vdd.t24 0.000359516597084358f
CMODEL1754 a_9600_169.n1 vdd.n9 0.00036773872627719f
CMODEL1755 a_9600_169.n1 vdd.t5 2.86720994467334e-05f
CMODEL1756 a_9600_169.n1 vdd.n10 0.000490630457934557f
CMODEL1757 a_9600_169.n1 vdd.t4 0.000359714442583283f
CMODEL1758 a_9600_169.n1 vdd.n11 0.00118626182700541f
CMODEL1759 a_9600_169.n1 vdd.n12 0.00292488190761003f
CMODEL1760 a_9600_169.n1 vdd.n13 0.00022170236867056f
CMODEL1761 a_9600_169.n1 vdd.t42 1.79994888784644e-05f
CMODEL1762 a_9600_169.n1 vdd.t41 0.000142276633642055f
CMODEL1763 a_9600_169.n1 vdd.n14 0.000199327691454615f
CMODEL1764 a_9600_169.n1 vdd.t9 1.79994888784644e-05f
CMODEL1765 a_9600_169.n1 vdd.t8 0.000142276633642055f
CMODEL1766 a_9600_169.n1 vdd.n15 0.000382682656296004f
CMODEL1767 a_9600_169.n1 vdd.t15 3.03128981178195e-05f
CMODEL1768 a_9600_169.n1 vdd.n16 0.000238435151742156f
CMODEL1769 a_9600_169.n1 vdd.t14 0.000408902131041062f
CMODEL1770 a_9600_169.n1 vdd.n17 0.000333996176435503f
CMODEL1771 a_9600_169.n1 vdd.t32 0.000408902131041062f
CMODEL1772 a_9600_169.n1 vdd.n18 0.000329699631683845f
CMODEL1773 a_9600_169.n1 vdd.t34 3.03128981178195e-05f
CMODEL1774 a_9600_169.n1 vdd.n19 0.000332011126596287f
CMODEL1775 a_9600_169.n1 vdd.t33 0.000408902131041062f
CMODEL1776 a_9600_169.n1 vdd.n20 0.000662576332337929f
CMODEL1777 a_9600_169.n1 vdd.t48 0.000409683620761816f
CMODEL1778 a_9600_169.n1 vdd.n21 0.00117614532716037f
CMODEL1779 a_9600_169.n1 vdd.n22 0.00515430391224827f
CMODEL1780 a_9600_169.n1 vdd.t47 5.82732483821696e-06f
CMODEL1781 a_9600_169.n1 vdd.t45 5.76749306191701e-06f
CMODEL1782 a_9600_169.n1 vdd.n23 6.58581501972132e-05f
CMODEL1783 a_9600_169.n1 vdd.t46 0.000157174069968622f
CMODEL1784 a_9600_169.n1 vdd.n24 0.000168869376895085f
CMODEL1785 a_9600_169.n1 vdd.t44 0.000157174069968622f
CMODEL1786 a_9600_169.n1 vdd.n25 0.000266323123528149f
CMODEL1787 a_9600_169.n1 vdd.t43 0.000157514529098023f
CMODEL1788 a_9600_169.n1 vdd.n26 0.00142497890858353f
CMODEL1789 a_9600_169.n1 vdd.n27 0.00095262772603717f
CMODEL1790 a_9600_169.n1 vdd.n28 0.000215181710768485f
CMODEL1791 a_9600_169.n1 vdd.t29 1.79994888784644e-05f
CMODEL1792 a_9600_169.n1 vdd.t28 0.000142276633642055f
CMODEL1793 a_9600_169.n1 vdd.n29 3.21212059779955e-05f
CMODEL1794 a_9600_169.n1 vdd.n30 1.02473746425792e-05f
CMODEL1795 a_9600_169.n1 vdd.t38 4.71812053561792e-06f
CMODEL1796 a_9600_169.n1 vdd.t40 4.71812053561792e-06f
CMODEL1797 a_9600_169.n1 vdd.t37 9.53391079920523e-05f
CMODEL1798 a_9600_169.n1 vdd.t39 9.53391079920523e-05f
CMODEL1799 a_9600_169.n1 vdd.n31 3.0878076759749e-05f
CMODEL1800 a_9600_169.n1 vdd.n32 0.000372633753663097f
CMODEL1801 a_9600_169.n1 vdd.n33 0.000188813851899233f
CMODEL1802 a_9600_169.n1 vdd.t17 1.79994888784644e-05f
CMODEL1803 a_9600_169.n1 vdd.t16 0.000142276633642055f
CMODEL1804 a_9600_169.n1 vdd.n34 3.21212059779955e-05f
CMODEL1805 a_9600_169.n1 vdd.n35 1.02473746425792e-05f
CMODEL1806 a_9600_169.n1 vdd.t1 4.71812053561792e-06f
CMODEL1807 a_9600_169.n1 vdd.t31 4.71812053561792e-06f
CMODEL1808 a_9600_169.n1 vdd.t0 9.53391079920523e-05f
CMODEL1809 a_9600_169.n1 vdd.t30 9.53391079920523e-05f
CMODEL1810 a_9600_169.n1 vdd.n36 3.0878076759749e-05f
CMODEL1811 a_9600_169.n1 vdd.n37 0.000361381290911728f
CMODEL1812 a_9600_169.n1 vdd.n38 0.000208461558654993f
CMODEL1813 a_9600_169.n1 vdd.t19 1.79994888784644e-05f
CMODEL1814 a_9600_169.n1 vdd.t18 0.000142276633642055f
CMODEL1815 a_9600_169.n1 vdd.n39 0.000175912676656821f
CMODEL1816 a_9600_169.n1 vdd.t21 1.79996537497135e-05f
CMODEL1817 a_9600_169.n1 vdd.t20 0.000142276633642055f
CMODEL1818 a_9600_169.n1 vdd.n40 0.000175912676656821f
CMODEL1819 a_9600_169.n1 vdd.t11 1.79994888784644e-05f
CMODEL1820 a_9600_169.n1 vdd.t10 0.000142276633642055f
CMODEL1821 a_9600_169.n1 vdd.n41 0.000756808494763495f
CMODEL1822 a_9600_169.n1 vdd.n42 0.00144966508071192f
CMODEL1823 a_9600_169.n1 vdd.n43 0.000175912676656821f
CMODEL1824 a_9600_169.n1 vdd.t13 1.79994888784644e-05f
CMODEL1825 a_9600_169.n1 vdd.t12 0.000142276633642055f
CMODEL1826 a_9600_169.n1 vdd.n44 0.000175912676656821f
CMODEL1827 a_9600_169.n1 vdd.t23 1.79994888784644e-05f
CMODEL1828 a_9600_169.n1 vdd.t22 0.000142276633642055f
CMODEL1829 a_9600_169.n1 vdd.n45 0.000217156868332754f
CMODEL1830 a_9600_169.n1 vdd.n46 0.00358439987827707f
CMODEL1831 a_11200_n23917.t0 we 0.000397080510673764f
CMODEL1832 a_11200_n23917.t0 we.t1 0.00227024912136307f
CMODEL1833 a_11200_n23917.t0 we.t3 0.00231299941279586f
CMODEL1834 a_11200_n23917.t0 we.n0 0.0790329920464195f
CMODEL1835 a_11200_n23917.t0 we.t0 0.00280345135438403f
CMODEL1836 a_11200_n23917.t0 we.n1 0.215827931599823f
CMODEL1837 a_11200_n23917.t0 we.t2 0.0042187390399174f
CMODEL1838 a_11200_n23917.t1 we 0.00039691243830094f
CMODEL1839 a_11200_n23917.t1 we.t1 0.00226928819241675f
CMODEL1840 a_11200_n23917.t1 we.t3 0.00231202038892236f
CMODEL1841 a_11200_n23917.t1 we.n0 0.0789995397309632f
CMODEL1842 a_11200_n23917.t1 we.t0 0.00280226473678744f
CMODEL1843 a_11200_n23917.t1 we.n1 0.215736578054105f
CMODEL1844 a_11200_n23917.t1 we.t2 0.00421695337312765f
CMODEL1845 a_0_83.t1 a_3200_83.t0 0.000118735956524431f
CMODEL1846 a_0_83.t1 a_3200_83.t1 0.000118735956524431f
CMODEL1847 a_0_83.n0 a_3200_83.t0 0.00117303921497728f
CMODEL1848 a_0_83.n0 a_3200_83.t1 0.00117303921497728f
CMODEL1849 a_0_83.t0 a_3200_83.t0 2.69559892895009e-05f
CMODEL1850 a_0_83.t0 a_3200_83.t1 2.69559892895009e-05f
CMODEL1851 a_0_83.t2 a_3200_83.t0 0.000123600932590116f
CMODEL1852 a_0_83.t2 a_3200_83.t1 0.000123600932590116f
CMODEL1853 a_0_83.t3 a_3200_83.t0 5.311290661867e-05f
CMODEL1854 a_0_83.t3 a_3200_83.t1 5.311290661867e-05f
CMODEL1855 a_11200_n23917.t0 a_6400_n24000.t0 0.000147731076951052f
CMODEL1856 a_11200_n23917.t0 a_6400_n24000.t1 0.000147698946421031f
CMODEL1857 a_11200_n23917.t1 a_6400_n24000.t0 0.00014766854677902f
CMODEL1858 a_11200_n23917.t1 a_6400_n24000.t1 0.000147636429848897f
CMODEL1859 a_0_n11917.t2 a_9600_n36000.t1 6.04233998089373e-06f
CMODEL1860 a_0_n11917.t2 a_9600_n36000.t2 7.90678668650108e-06f
CMODEL1861 a_0_n11917.t2 a_9600_n36000.t0 2.44143028502989e-06f
CMODEL1862 a_0_n11917.t2 a_9600_n36000.n0 0.000125333275390779f
CMODEL1863 a_0_n11917.t2 a_9600_n36000.t3 2.61251732420356e-06f
CMODEL1864 a_0_n11917.t2 a_9600_n36000.n1 6.26867387646724e-05f
CMODEL1865 a_0_n11917.t1 a_9600_n36000.t1 9.45240340572445e-06f
CMODEL1866 a_0_n11917.t1 a_9600_n36000.t2 1.23690718562918e-05f
CMODEL1867 a_0_n11917.t1 a_9600_n36000.t0 3.81927928816112e-06f
CMODEL1868 a_0_n11917.t1 a_9600_n36000.n0 0.000196066537616304f
CMODEL1869 a_0_n11917.t1 a_9600_n36000.t3 4.08692124754675e-06f
CMODEL1870 a_0_n11917.t1 a_9600_n36000.n1 9.80647141449502e-05f
CMODEL1871 a_0_n11917.n0 a_9600_n36000.t1 0.000257749926233296f
CMODEL1872 a_0_n11917.n0 a_9600_n36000.t2 0.00033728219392359f
CMODEL1873 a_0_n11917.n0 a_9600_n36000.t0 0.00010414483095291f
CMODEL1874 a_0_n11917.n0 a_9600_n36000.n0 0.00534637948025104f
CMODEL1875 a_0_n11917.n0 a_9600_n36000.t3 0.000111442942589449f
CMODEL1876 a_0_n11917.n0 a_9600_n36000.n1 0.00267404719752468f
CMODEL1877 a_0_n11917.t6 a_9600_n36000.t1 1.61044940866664e-05f
CMODEL1878 a_0_n11917.t6 a_9600_n36000.t2 2.10737561673011e-05f
CMODEL1879 a_0_n11917.t6 a_9600_n36000.t0 6.50708164595143e-06f
CMODEL1880 a_0_n11917.t6 a_9600_n36000.n0 0.000334047570771545f
CMODEL1881 a_0_n11917.t6 a_9600_n36000.t3 6.96307555218477e-06f
CMODEL1882 a_0_n11917.t6 a_9600_n36000.n1 0.000167077360251209f
CMODEL1883 a_0_n11917.n1 a_9600_n36000.t1 0.000999245750077803f
CMODEL1884 a_0_n11917.n1 a_9600_n36000.t2 0.00130757670343623f
CMODEL1885 a_0_n11917.n1 a_9600_n36000.t0 0.000403749018450052f
CMODEL1886 a_0_n11917.n1 a_9600_n36000.n0 0.0207268613109457f
CMODEL1887 a_0_n11917.n1 a_9600_n36000.t3 0.000432042361315278f
CMODEL1888 a_0_n11917.n1 a_9600_n36000.n1 0.0103667548490992f
CMODEL1889 a_0_n11917.t4 a_9600_n36000.t1 1.27849378709276e-06f
CMODEL1890 a_0_n11917.t4 a_9600_n36000.t2 1.67299054447846e-06f
CMODEL1891 a_0_n11917.t4 a_9600_n36000.t0 5.16580242240709e-07f
CMODEL1892 a_0_n11917.t4 a_9600_n36000.n0 2.65191654904853e-05f
CMODEL1893 a_0_n11917.t4 a_9600_n36000.t3 5.5278040928316e-07f
CMODEL1894 a_0_n11917.t4 a_9600_n36000.n1 1.32638359140933e-05f
CMODEL1895 a_0_n11917.t5 a_9600_n36000.t1 1.29080609722591e-06f
CMODEL1896 a_0_n11917.t5 a_9600_n36000.t2 1.68910198642788e-06f
CMODEL1897 a_0_n11917.t5 a_9600_n36000.t0 5.21555077641034e-07f
CMODEL1898 a_0_n11917.t5 a_9600_n36000.n0 2.67745536615406e-05f
CMODEL1899 a_0_n11917.t5 a_9600_n36000.t3 5.58103864041669e-07f
CMODEL1900 a_0_n11917.t5 a_9600_n36000.n1 1.33915709590175e-05f
CMODEL1901 a_0_n11917.n2 a_9600_n36000.t1 0.000324620829566169f
CMODEL1902 a_0_n11917.n2 a_9600_n36000.t2 0.000424787029775023f
CMODEL1903 a_0_n11917.n2 a_9600_n36000.t0 0.000131164271947694f
CMODEL1904 a_0_n11917.n2 a_9600_n36000.n0 0.00673344961691181f
CMODEL1905 a_0_n11917.n2 a_9600_n36000.t3 0.000140355813099002f
CMODEL1906 a_0_n11917.n2 a_9600_n36000.n1 0.00336780472547586f
CMODEL1907 a_0_n11917.t0 a_9600_n36000.t1 2.5585578288583e-06f
CMODEL1908 a_0_n11917.t0 a_9600_n36000.t2 3.34803586720184e-06f
CMODEL1909 a_0_n11917.t0 a_9600_n36000.t0 1.03379495181121e-06f
CMODEL1910 a_0_n11917.t0 a_9600_n36000.n0 5.30709019984838e-05f
CMODEL1911 a_0_n11917.t0 a_9600_n36000.t3 1.10623974718488e-06f
CMODEL1912 a_0_n11917.t0 a_9600_n36000.n1 2.65439625607138e-05f
CMODEL1913 a_0_n11917.t3 a_9600_n36000.t1 4.59483003481584e-06f
CMODEL1914 a_0_n11917.t3 a_9600_n36000.t2 6.01262773377467e-06f
CMODEL1915 a_0_n11917.t3 a_9600_n36000.t0 1.85655842554974e-06f
CMODEL1916 a_0_n11917.t3 a_9600_n36000.n0 9.53082911501807e-05f
CMODEL1917 a_0_n11917.t3 a_9600_n36000.t3 1.98665965597515e-06f
CMODEL1918 a_0_n11917.t3 a_9600_n36000.n1 4.76694312089945e-05f
CMODEL1919 a_0_n11917.n3 a_9600_n36000.t1 0.000712399950694268f
CMODEL1920 a_0_n11917.n3 a_9600_n36000.t2 0.000932220706452256f
CMODEL1921 a_0_n11917.n3 a_9600_n36000.t0 0.000287847890085378f
CMODEL1922 a_0_n11917.n3 a_9600_n36000.n0 0.0147769604972701f
CMODEL1923 a_0_n11917.n3 a_9600_n36000.t3 0.000308019280417129f
CMODEL1924 a_0_n11917.n3 a_9600_n36000.n1 0.0073908501915398f
CMODEL1925 a_0_n11917.n4 a_9600_n36000.t1 0.00129765846159319f
CMODEL1926 a_0_n11917.n4 a_9600_n36000.t2 0.00169806874161239f
CMODEL1927 a_0_n11917.n4 a_9600_n36000.t0 0.000524323801338019f
CMODEL1928 a_0_n11917.n4 a_9600_n36000.n0 0.0269166888729054f
CMODEL1929 a_0_n11917.n4 a_9600_n36000.t3 0.000561066610374693f
CMODEL1930 a_0_n11917.n4 a_9600_n36000.n1 0.0134626613604795f
CMODEL1931 a_6400_83.t1 a_9600_169.t1 7.380823091371e-05f
CMODEL1932 a_6400_83.t1 a_9600_169.n0 0.00138970937589117f
CMODEL1933 a_6400_83.t1 a_9600_169.t2 0.000107752688817932f
CMODEL1934 a_6400_83.t1 a_9600_169.t3 0.000224915464335754f
CMODEL1935 a_6400_83.t1 a_9600_169.t4 4.79026335554454e-05f
CMODEL1936 a_6400_83.t1 a_9600_169.t0 0.000119809279769736f
CMODEL1937 a_6400_83.t1 a_9600_169.n1 0.000108324977419367f
CMODEL1938 a_6400_83.n0 a_9600_169.t1 0.000832626251754026f
CMODEL1939 a_6400_83.n0 a_9600_169.n0 0.0156772286010821f
CMODEL1940 a_6400_83.n0 a_9600_169.t2 0.00121555165726412f
CMODEL1941 a_6400_83.n0 a_9600_169.t3 0.00253725794146638f
CMODEL1942 a_6400_83.n0 a_9600_169.t4 0.000540386752705767f
CMODEL1943 a_6400_83.n0 a_9600_169.t0 0.0013515613408571f
CMODEL1944 a_6400_83.n0 a_9600_169.n1 0.00122200761085134f
CMODEL1945 a_6400_83.t0 a_9600_169.t1 1.67562525847107e-05f
CMODEL1946 a_6400_83.t0 a_9600_169.n0 0.000315497621789598f
CMODEL1947 a_6400_83.t0 a_9600_169.t2 2.44624650687789e-05f
CMODEL1948 a_6400_83.t0 a_9600_169.t3 5.10612472885775e-05f
CMODEL1949 a_6400_83.t0 a_9600_169.t4 1.08750557680523e-05f
CMODEL1950 a_6400_83.t0 a_9600_169.t0 2.71996026589637e-05f
CMODEL1951 a_6400_83.t0 a_9600_169.n1 2.45923884152441e-05f
CMODEL1952 a_6400_83.t3 a_9600_169.t1 1.65256380497236e-05f
CMODEL1953 a_6400_83.t3 a_9600_169.n0 0.000311155461335123f
CMODEL1954 a_6400_83.t3 a_9600_169.t2 2.41257907450927e-05f
CMODEL1955 a_6400_83.t3 a_9600_169.t3 5.03584967338349e-05f
CMODEL1956 a_6400_83.t3 a_9600_169.t4 1.07253835238421e-05f
CMODEL1957 a_6400_83.t3 a_9600_169.t0 2.68252573996453e-05f
CMODEL1958 a_6400_83.t3 a_9600_169.n1 2.42539259702595e-05f
CMODEL1959 a_6400_83.t2 a_9600_169.t1 1.65256380497236e-05f
CMODEL1960 a_6400_83.t2 a_9600_169.n0 0.000311155461335123f
CMODEL1961 a_6400_83.t2 a_9600_169.t2 2.41257907450927e-05f
CMODEL1962 a_6400_83.t2 a_9600_169.t3 5.03584967338349e-05f
CMODEL1963 a_6400_83.t2 a_9600_169.t4 1.07253835238421e-05f
CMODEL1964 a_6400_83.t2 a_9600_169.t0 2.68252573996453e-05f
CMODEL1965 a_6400_83.t2 a_9600_169.n1 2.42539259702595e-05f
CMODEL1966 a_6400_83.n1 a_9600_169.t1 0.006085631648351f
CMODEL1967 a_6400_83.n1 a_9600_169.n0 0.114584230718399f
CMODEL1968 a_6400_83.n1 a_9600_169.t2 0.00888441797273209f
CMODEL1969 a_6400_83.n1 a_9600_169.t3 0.0185447158266867f
CMODEL1970 a_6400_83.n1 a_9600_169.t4 0.00394966495193735f
CMODEL1971 a_6400_83.n1 a_9600_169.t0 0.0098785072573445f
CMODEL1972 a_6400_83.n1 a_9600_169.n1 0.00893160427677657f
CMODEL1973 a_0_n11917.t2 din 2.48261004481337e-07f
CMODEL1974 a_0_n11917.t2 din.t0 1.3976202064091e-06f
CMODEL1975 a_0_n11917.t2 din.t1 1.44611809145543e-06f
CMODEL1976 a_0_n11917.t2 din.n0 8.14103193621159e-05f
CMODEL1977 a_0_n11917.t2 din.t2 2.46324996084381e-06f
CMODEL1978 a_0_n11917.t2 din.n1 0.000107313470264821f
CMODEL1979 a_0_n11917.t2 din.t3 1.81360834800382e-06f
CMODEL1980 a_0_n11917.t1 din 3.88369931465005e-07f
CMODEL1981 a_0_n11917.t1 din.t0 2.18638309673806e-06f
CMODEL1982 a_0_n11917.t1 din.t1 2.262251315877e-06f
CMODEL1983 a_0_n11917.t1 din.n0 0.000127355160820619f
CMODEL1984 a_0_n11917.t1 din.t2 3.85341314667082e-06f
CMODEL1985 a_0_n11917.t1 din.n1 0.000167877050119459f
CMODEL1986 a_0_n11917.t1 din.t3 2.83713888651229e-06f
CMODEL1987 a_0_n11917.n0 din 1.05901448435551e-05f
CMODEL1988 a_0_n11917.n0 din.t0 5.96187083552398e-05f
CMODEL1989 a_0_n11917.n0 din.t1 6.16874973232043e-05f
CMODEL1990 a_0_n11917.n0 din.n0 0.00347274464471805f
CMODEL1991 a_0_n11917.n0 din.t2 0.000105075599471275f
CMODEL1992 a_0_n11917.n0 din.n1 0.00457770319645361f
CMODEL1993 a_0_n11917.n0 din.t3 7.73636404757435e-05f
CMODEL1994 a_0_n11917.t6 din 6.61683700563334e-07f
CMODEL1995 a_0_n11917.t6 din.t0 3.72504136157389e-06f
CMODEL1996 a_0_n11917.t6 din.t1 3.8543015331985e-06f
CMODEL1997 a_0_n11917.t6 din.n0 0.000216980840354319f
CMODEL1998 a_0_n11917.t6 din.t2 6.56523706938496e-06f
CMODEL1999 a_0_n11917.t6 din.n1 0.000286019845418205f
CMODEL2000 a_0_n11917.t6 din.t3 4.83376390741194e-06f
CMODEL2001 a_0_n11917.n1 din 4.10559078804647e-05f
CMODEL2002 a_0_n11917.n1 din.t0 0.000231130001935207f
CMODEL2003 a_0_n11917.n1 din.t1 0.000239150289716688f
CMODEL2004 a_0_n11917.n1 din.n0 0.0134631477030921f
CMODEL2005 a_0_n11917.n1 din.t2 0.000407357424861158f
CMODEL2006 a_0_n11917.n1 din.n1 0.0177468546005851f
CMODEL2007 a_0_n11917.n1 din.t3 0.00029992361233874f
CMODEL2008 a_0_n11917.t4 din 5.25293434018005e-08f
CMODEL2009 a_0_n11917.t4 din.t0 2.95721319266949e-07f
CMODEL2010 a_0_n11917.t4 din.t1 3.05982947198336e-07f
CMODEL2011 a_0_n11917.t4 din.n0 1.72255430576264e-05f
CMODEL2012 a_0_n11917.t4 din.t2 5.21197049645239e-07f
CMODEL2013 a_0_n11917.t4 din.n1 2.27063696248094e-05f
CMODEL2014 a_0_n11917.t4 din.t3 3.83739910775341e-07f
CMODEL2015 a_0_n11917.t5 din 5.30352180283205e-08f
CMODEL2016 a_0_n11917.t5 din.t0 2.98569211554386e-07f
CMODEL2017 a_0_n11917.t5 din.t1 3.08929662293392e-07f
CMODEL2018 a_0_n11917.t5 din.n0 1.73914306282024e-05f
CMODEL2019 a_0_n11917.t5 din.t2 5.26216346399356e-07f
CMODEL2020 a_0_n11917.t5 din.n1 2.2925039334151e-05f
CMODEL2021 a_0_n11917.t5 din.t3 3.87435450667386e-07f
CMODEL2022 a_0_n11917.n2 din 1.33376628058823e-05f
CMODEL2023 a_0_n11917.n2 din.t0 7.50862467616153e-05f
CMODEL2024 a_0_n11917.n2 din.t1 7.76917644461097e-05f
CMODEL2025 a_0_n11917.n2 din.n0 0.00437371705169557f
CMODEL2026 a_0_n11917.n2 din.t2 0.00013233651999828f
CMODEL2027 a_0_n11917.n2 din.n1 0.00576534717529052f
CMODEL2028 a_0_n11917.n2 din.t3 9.74349421414131e-05f
CMODEL2029 a_0_n11917.t0 din 1.05123203696657e-07f
CMODEL2030 a_0_n11917.t0 din.t0 5.91805845448245e-07f
CMODEL2031 a_0_n11917.t0 din.t1 6.12341704711499e-07f
CMODEL2032 a_0_n11917.t0 din.n0 3.44722426431535e-05f
CMODEL2033 a_0_n11917.t0 din.t2 1.04303423701419e-06f
CMODEL2034 a_0_n11917.t0 din.n1 4.54406273655921e-05f
CMODEL2035 a_0_n11917.t0 din.t3 7.67951133491431e-07f
CMODEL2036 a_0_n11917.t3 din 1.88787311450765e-07f
CMODEL2037 a_0_n11917.t3 din.t0 1.0628046951976e-06f
CMODEL2038 a_0_n11917.t3 din.t1 1.09968437087632e-06f
CMODEL2039 a_0_n11917.t3 din.n0 6.19075692085885e-05f
CMODEL2040 a_0_n11917.t3 din.t2 1.87315095461907e-06f
CMODEL2041 a_0_n11917.t3 din.n1 8.16053313571051e-05f
CMODEL2042 a_0_n11917.t3 din.t3 1.37913823703248e-06f
CMODEL2043 a_0_n11917.n3 din 2.92703038741713e-05f
CMODEL2044 a_0_n11917.n3 din.t0 0.000164781288256455f
CMODEL2045 a_0_n11917.n3 din.t1 0.00017049925365149f
CMODEL2046 a_0_n11917.n3 din.n0 0.00959838534126933f
CMODEL2047 a_0_n11917.n3 din.t2 0.000290420458994634f
CMODEL2048 a_0_n11917.n3 din.n1 0.0126524014152182f
CMODEL2049 a_0_n11917.n3 din.t3 0.000213826845523765f
CMODEL2050 a_0_n11917.n4 din 5.33167604218754e-05f
CMODEL2051 a_0_n11917.n4 din.t0 0.000300154194016756f
CMODEL2052 a_0_n11917.n4 din.t1 0.000310569644173276f
CMODEL2053 a_0_n11917.n4 din.n0 0.0174837546571862f
CMODEL2054 a_0_n11917.n4 din.t2 0.000529009814875603f
CMODEL2055 a_0_n11917.n4 din.n1 0.0230467390402412f
CMODEL2056 a_0_n11917.n4 din.t3 0.000389492187835331f
CMODEL2057 a_0_83.t1 a_3200_169.t2 0.000125028678217223f
CMODEL2058 a_0_83.t1 a_3200_169.n0 0.00224676689970331f
CMODEL2059 a_0_83.t1 a_3200_169.t1 0.000182529732972751f
CMODEL2060 a_0_83.t1 a_3200_169.t3 0.000362046151901529f
CMODEL2061 a_0_83.t1 a_3200_169.t4 8.11451057794812e-05f
CMODEL2062 a_0_83.t1 a_3200_169.t0 0.000202953093896506f
CMODEL2063 a_0_83.t1 a_3200_169.n1 0.000183498548106585f
CMODEL2064 a_0_83.n0 a_3200_169.t2 0.00123520748759372f
CMODEL2065 a_0_83.n0 a_3200_169.n0 0.0221966938862587f
CMODEL2066 a_0_83.n0 a_3200_169.t1 0.00180328302347329f
CMODEL2067 a_0_83.n0 a_3200_169.t3 0.00357679633232862f
CMODEL2068 a_0_83.n0 a_3200_169.t4 0.000801664415473215f
CMODEL2069 a_0_83.n0 a_3200_169.t0 0.00200505343882569f
CMODEL2070 a_0_83.n0 a_3200_169.n1 0.00181285432922865f
CMODEL2071 a_0_83.t0 a_3200_169.t2 2.83845922461615e-05f
CMODEL2072 a_0_83.t0 a_3200_169.n0 0.000510071475037523f
CMODEL2073 a_0_83.t0 a_3200_169.t1 4.14387492302431e-05f
CMODEL2074 a_0_83.t0 a_3200_169.t3 8.21934018862649e-05f
CMODEL2075 a_0_83.t0 a_3200_169.t4 1.84219394555267e-05f
CMODEL2076 a_0_83.t0 a_3200_169.t0 4.60753556503301e-05f
CMODEL2077 a_0_83.t0 a_3200_169.n1 4.16586941495041e-05f
CMODEL2078 a_0_83.t2 a_3200_169.t2 0.000130151486377916f
CMODEL2079 a_0_83.t2 a_3200_169.n0 0.00233882382594689f
CMODEL2080 a_0_83.t2 a_3200_169.t1 0.000190008535588078f
CMODEL2081 a_0_83.t2 a_3200_169.t3 0.000376880292419964f
CMODEL2082 a_0_83.t2 a_3200_169.t4 8.44698694738168e-05f
CMODEL2083 a_0_83.t2 a_3200_169.t0 0.000211268704206682f
CMODEL2084 a_0_83.t2 a_3200_169.n1 0.000191017046047374f
CMODEL2085 a_0_83.t3 a_3200_169.t2 5.59277636293834e-05f
CMODEL2086 a_0_83.t3 a_3200_169.n0 0.0010050226067224f
CMODEL2087 a_0_83.t3 a_3200_169.t1 8.16491056819652e-05f
CMODEL2088 a_0_83.t3 a_3200_169.t3 0.000161950297285373f
CMODEL2089 a_0_83.t3 a_3200_169.t4 3.6297786719231e-05f
CMODEL2090 a_0_83.t3 a_3200_169.t0 9.07848729199172e-05f
CMODEL2091 a_0_83.t3 a_3200_169.n1 8.2082475566205e-05f
CMODEL2092 a_16000_n24000.t0 a_3200_n23917.t1 0.010010997350871f
CMODEL2093 a_16000_n24000.t0 a_3200_n23917.n0 0.0142946018964262f
CMODEL2094 a_16000_n24000.t0 a_3200_n23917.t0 0.00227274136242714f
CMODEL2095 a_16000_n24000.t0 a_3200_n23917.t3 0.00661182579513517f
CMODEL2096 a_16000_n24000.t0 a_3200_n23917.n1 0.337848747373082f
CMODEL2097 a_16000_n24000.t0 a_3200_n23917.t2 0.00846693554617671f
CMODEL2098 a_16000_n24000.t1 a_3200_n23917.t1 0.0100090268727586f
CMODEL2099 a_16000_n24000.t1 a_3200_n23917.n0 0.014291788270653f
CMODEL2100 a_16000_n24000.t1 a_3200_n23917.t0 0.00227229401567908f
CMODEL2101 a_16000_n24000.t1 a_3200_n23917.t3 0.00661052438054525f
CMODEL2102 a_16000_n24000.t1 a_3200_n23917.n1 0.337782248148414f
CMODEL2103 a_16000_n24000.t1 a_3200_n23917.t2 0.00846526898783215f
CMODEL2104 din we 5.03893445771694e-06f
CMODEL2105 din we.t1 2.88093628816667e-05f
CMODEL2106 din we.t3 2.93518622257232e-05f
CMODEL2107 din we.n0 0.00100292524113923f
CMODEL2108 din we.t0 3.55756760919072e-05f
CMODEL2109 din we.n1 0.00273884709080984f
CMODEL2110 din we.t2 5.35356154354821e-05f
CMODEL2111 din.t0 we 2.83673895205144e-05f
CMODEL2112 din.t0 we.t1 0.000162186356175066f
CMODEL2113 din.t0 we.t3 0.000165240432455797f
CMODEL2114 din.t0 we.n0 0.005646108560071f
CMODEL2115 din.t0 we.t0 0.000200278267086656f
CMODEL2116 din.t0 we.n1 0.0154187245168758f
CMODEL2117 din.t0 we.t2 0.000301386269065875f
CMODEL2118 din.t1 we 2.93517473522928e-05f
CMODEL2119 din.t1 we.t1 0.000167814276565593f
CMODEL2120 din.t1 we.t3 0.000170974330306943f
CMODEL2121 din.t1 we.n0 0.00584203040110462f
CMODEL2122 din.t1 we.t0 0.000207227989428896f
CMODEL2123 din.t1 we.n1 0.0159537593752382f
CMODEL2124 din.t1 we.t2 0.000311844472635538f
CMODEL2125 din.n0 we 0.00165237897230189f
CMODEL2126 din.n0 we.t1 0.00944723251126577f
CMODEL2127 din.n0 we.t3 0.00962513014341964f
CMODEL2128 din.n0 we.n0 0.32888155088251f
CMODEL2129 din.n0 we.t0 0.0116660574954819f
CMODEL2130 din.n0 we.n1 0.8981290348545f
CMODEL2131 din.n0 we.t2 0.0175555220964139f
CMODEL2132 din.t2 we 4.99963944462284e-05f
CMODEL2133 din.t2 we.t1 0.000285846994530853f
CMODEL2134 din.t2 we.t3 0.000291229682362945f
CMODEL2135 din.t2 we.n0 0.00995104151023118f
CMODEL2136 din.t2 we.t0 0.000352982470700389f
CMODEL2137 din.t2 we.n1 0.0271748879905209f
CMODEL2138 din.t2 we.t2 0.000531181298088698f
CMODEL2139 din.n1 we 0.00217813322806902f
CMODEL2140 din.n1 we.t1 0.0124531547490077f
CMODEL2141 din.n1 we.t3 0.0126876558836048f
CMODEL2142 din.n1 we.n0 0.433525145311028f
CMODEL2143 din.n1 we.t0 0.0153779658888265f
CMODEL2144 din.n1 we.n1 1.18389590203084f
CMODEL2145 din.n1 we.t2 0.0231413414569359f
CMODEL2146 din.t3 we 3.68106687421646e-05f
CMODEL2147 din.t3 we.t1 0.000210459556997362f
CMODEL2148 din.t3 we.t3 0.000214422649554821f
CMODEL2149 din.t3 we.n0 0.00732661818376951f
CMODEL2150 din.t3 we.t0 0.000259889156901455f
CMODEL2151 din.t3 we.n1 0.0200079587939157f
CMODEL2152 din.t3 we.t2 0.000391090978110545f
CMODEL2153 a_3200_n23917.t1 vdd 3.07559371556611e-06f
CMODEL2154 a_3200_n23917.t1 vdd.n0 0.00103211201883862f
CMODEL2155 a_3200_n23917.t1 vdd.n1 9.5646603029141e-05f
CMODEL2156 a_3200_n23917.t1 vdd.t7 7.88476179841913e-06f
CMODEL2157 a_3200_n23917.t1 vdd.t6 6.23249567431195e-05f
CMODEL2158 a_3200_n23917.t1 vdd.n2 8.57701576082602e-05f
CMODEL2159 a_3200_n23917.t1 vdd.t27 7.88476179841913e-06f
CMODEL2160 a_3200_n23917.t1 vdd.t26 6.23249567431195e-05f
CMODEL2161 a_3200_n23917.t1 vdd.n3 0.000160873031935613f
CMODEL2162 a_3200_n23917.t1 vdd.n4 8.57701576082602e-05f
CMODEL2163 a_3200_n23917.t1 vdd.t36 7.88476179841913e-06f
CMODEL2164 a_3200_n23917.t1 vdd.t35 6.23249567431195e-05f
CMODEL2165 a_3200_n23917.t1 vdd.n5 0.000122380533829823f
CMODEL2166 a_3200_n23917.t1 vdd.t3 1.25599496699356e-05f
CMODEL2167 a_3200_n23917.t1 vdd.n6 0.00012016763227446f
CMODEL2168 a_3200_n23917.t1 vdd.t2 0.000157487957004156f
CMODEL2169 a_3200_n23917.t1 vdd.n7 0.00016108969984247f
CMODEL2170 a_3200_n23917.t1 vdd.t25 1.25599496699356e-05f
CMODEL2171 a_3200_n23917.t1 vdd.n8 7.25823043442542e-05f
CMODEL2172 a_3200_n23917.t1 vdd.t24 0.000157487957004156f
CMODEL2173 a_3200_n23917.t1 vdd.n9 0.00016108969984247f
CMODEL2174 a_3200_n23917.t1 vdd.t5 1.25599496699356e-05f
CMODEL2175 a_3200_n23917.t1 vdd.n10 0.000214923007980065f
CMODEL2176 a_3200_n23917.t1 vdd.t4 0.000157574624166899f
CMODEL2177 a_3200_n23917.t1 vdd.n11 0.000519647641088635f
CMODEL2178 a_3200_n23917.t1 vdd.n12 0.00128125844493304f
CMODEL2179 a_3200_n23917.t1 vdd.n13 9.71177781166974e-05f
CMODEL2180 a_3200_n23917.t1 vdd.t42 7.88476179841913e-06f
CMODEL2181 a_3200_n23917.t1 vdd.t41 6.23249567431195e-05f
CMODEL2182 a_3200_n23917.t1 vdd.n14 8.73164442368603e-05f
CMODEL2183 a_3200_n23917.t1 vdd.t9 7.88476179841913e-06f
CMODEL2184 a_3200_n23917.t1 vdd.t8 6.23249567431195e-05f
CMODEL2185 a_3200_n23917.t1 vdd.n15 0.000167635959534964f
CMODEL2186 a_3200_n23917.t1 vdd.t15 1.32787093396146e-05f
CMODEL2187 a_3200_n23917.t1 vdd.n16 0.000104447653405657f
CMODEL2188 a_3200_n23917.t1 vdd.t14 0.000179121525277433f
CMODEL2189 a_3200_n23917.t1 vdd.n17 0.000146308615236711f
CMODEL2190 a_3200_n23917.t1 vdd.t32 0.000179121525277433f
CMODEL2191 a_3200_n23917.t1 vdd.n18 0.000144426493352483f
CMODEL2192 a_3200_n23917.t1 vdd.t34 1.32787093396146e-05f
CMODEL2193 a_3200_n23917.t1 vdd.n19 0.00014543905470386f
CMODEL2194 a_3200_n23917.t1 vdd.t33 0.000179121525277433f
CMODEL2195 a_3200_n23917.t1 vdd.n20 0.000290244716893343f
CMODEL2196 a_3200_n23917.t1 vdd.t48 0.000179463860570267f
CMODEL2197 a_3200_n23917.t1 vdd.n21 0.000515216060167061f
CMODEL2198 a_3200_n23917.t1 vdd.n22 0.00225786736829855f
CMODEL2199 a_3200_n23917.t1 vdd.t47 2.55268738915835e-06f
CMODEL2200 a_3200_n23917.t1 vdd.t45 2.52647779469226e-06f
CMODEL2201 a_3200_n23917.t1 vdd.n23 2.88494762432297e-05f
CMODEL2202 a_3200_n23917.t1 vdd.t46 6.88508496523695e-05f
CMODEL2203 a_3200_n23917.t1 vdd.n24 7.39740345326298e-05f
CMODEL2204 a_3200_n23917.t1 vdd.t44 6.88508496523695e-05f
CMODEL2205 a_3200_n23917.t1 vdd.n25 0.000116664112220589f
CMODEL2206 a_3200_n23917.t1 vdd.t43 6.89999893949225e-05f
CMODEL2207 a_3200_n23917.t1 vdd.n26 0.0006242187952012f
CMODEL2208 a_3200_n23917.t1 vdd.n27 0.0004173031108322f
CMODEL2209 a_3200_n23917.t1 vdd.n28 9.4261372877971e-05f
CMODEL2210 a_3200_n23917.t1 vdd.t29 7.88476179841913e-06f
CMODEL2211 a_3200_n23917.t1 vdd.t28 6.23249567431195e-05f
CMODEL2212 a_3200_n23917.t1 vdd.n29 1.40708472070824e-05f
CMODEL2213 a_3200_n23917.t1 vdd.n30 4.48891124972826e-06f
CMODEL2214 a_3200_n23917.t1 vdd.t38 2.06679516350527e-06f
CMODEL2215 a_3200_n23917.t1 vdd.t40 2.06679516350527e-06f
CMODEL2216 a_3200_n23917.t1 vdd.t37 4.17637501635115e-05f
CMODEL2217 a_3200_n23917.t1 vdd.t39 4.17637501635115e-05f
CMODEL2218 a_3200_n23917.t1 vdd.n31 1.35262885345161e-05f
CMODEL2219 a_3200_n23917.t1 vdd.n32 0.000163233989893994f
CMODEL2220 a_3200_n23917.t1 vdd.n33 8.27108067634448e-05f
CMODEL2221 a_3200_n23917.t1 vdd.t17 7.88476179841913e-06f
CMODEL2222 a_3200_n23917.t1 vdd.t16 6.23249567431195e-05f
CMODEL2223 a_3200_n23917.t1 vdd.n34 1.40708472070824e-05f
CMODEL2224 a_3200_n23917.t1 vdd.n35 4.48891124972826e-06f
CMODEL2225 a_3200_n23917.t1 vdd.t1 2.06679516350527e-06f
CMODEL2226 a_3200_n23917.t1 vdd.t31 2.06679516350527e-06f
CMODEL2227 a_3200_n23917.t1 vdd.t0 4.17637501635115e-05f
CMODEL2228 a_3200_n23917.t1 vdd.t30 4.17637501635115e-05f
CMODEL2229 a_3200_n23917.t1 vdd.n36 1.35262885345161e-05f
CMODEL2230 a_3200_n23917.t1 vdd.n37 0.000158304795013006f
CMODEL2231 a_3200_n23917.t1 vdd.n38 9.13175782501458e-05f
CMODEL2232 a_3200_n23917.t1 vdd.t19 7.88476179841913e-06f
CMODEL2233 a_3200_n23917.t1 vdd.t18 6.23249567431195e-05f
CMODEL2234 a_3200_n23917.t1 vdd.n39 7.70593855262681e-05f
CMODEL2235 a_3200_n23917.t1 vdd.t21 7.88483402105475e-06f
CMODEL2236 a_3200_n23917.t1 vdd.t20 6.23249567431195e-05f
CMODEL2237 a_3200_n23917.t1 vdd.n40 7.70593855262681e-05f
CMODEL2238 a_3200_n23917.t1 vdd.t11 7.88476179841913e-06f
CMODEL2239 a_3200_n23917.t1 vdd.t10 6.23249567431195e-05f
CMODEL2240 a_3200_n23917.t1 vdd.n41 0.000331523564281309f
CMODEL2241 a_3200_n23917.t1 vdd.n42 0.000635032690432413f
CMODEL2242 a_3200_n23917.t1 vdd.n43 7.70593855262681e-05f
CMODEL2243 a_3200_n23917.t1 vdd.t13 7.88476179841913e-06f
CMODEL2244 a_3200_n23917.t1 vdd.t12 6.23249567431195e-05f
CMODEL2245 a_3200_n23917.t1 vdd.n44 7.70593855262681e-05f
CMODEL2246 a_3200_n23917.t1 vdd.t23 7.88476179841913e-06f
CMODEL2247 a_3200_n23917.t1 vdd.t22 6.23249567431195e-05f
CMODEL2248 a_3200_n23917.t1 vdd.n45 9.51266000526851e-05f
CMODEL2249 a_3200_n23917.t1 vdd.n46 0.00157016343193565f
CMODEL2250 a_3200_n23917.n0 vdd 4.39160916922457e-06f
CMODEL2251 a_3200_n23917.n0 vdd.n0 0.00147374231604718f
CMODEL2252 a_3200_n23917.n0 vdd.n1 0.000136572817385486f
CMODEL2253 a_3200_n23917.n0 vdd.t7 1.12585716493817e-05f
CMODEL2254 a_3200_n23917.n0 vdd.t6 8.89931755678036e-05f
CMODEL2255 a_3200_n23917.n0 vdd.n2 0.000122470340829442f
CMODEL2256 a_3200_n23917.n0 vdd.t27 1.12585716493817e-05f
CMODEL2257 a_3200_n23917.n0 vdd.t26 8.89931755678036e-05f
CMODEL2258 a_3200_n23917.n0 vdd.n3 0.000229708975718646f
CMODEL2259 a_3200_n23917.n0 vdd.n4 0.000122470340829442f
CMODEL2260 a_3200_n23917.n0 vdd.t36 1.12585716493817e-05f
CMODEL2261 a_3200_n23917.n0 vdd.t35 8.89931755678036e-05f
CMODEL2262 a_3200_n23917.n0 vdd.n5 0.000174745926869838f
CMODEL2263 a_3200_n23917.n0 vdd.t3 1.79342251404411e-05f
CMODEL2264 a_3200_n23917.n0 vdd.n6 0.000171586147113515f
CMODEL2265 a_3200_n23917.n0 vdd.t2 0.000224875461450406f
CMODEL2266 a_3200_n23917.n0 vdd.n7 0.000230018353632124f
CMODEL2267 a_3200_n23917.n0 vdd.t25 1.79342251404411e-05f
CMODEL2268 a_3200_n23917.n0 vdd.n8 0.000103639538495742f
CMODEL2269 a_3200_n23917.n0 vdd.t24 0.000224875461450406f
CMODEL2270 a_3200_n23917.n0 vdd.n9 0.000230018353632124f
CMODEL2271 a_3200_n23917.n0 vdd.t5 1.79342251404411e-05f
CMODEL2272 a_3200_n23917.n0 vdd.n10 0.000306886390014894f
CMODEL2273 a_3200_n23917.n0 vdd.t4 0.000224999212615798f
CMODEL2274 a_3200_n23917.n0 vdd.n11 0.000741999612569346f
CMODEL2275 a_3200_n23917.n0 vdd.n12 0.00182949597875565f
CMODEL2276 a_3200_n23917.n0 vdd.n13 0.000138673493418002f
CMODEL2277 a_3200_n23917.n0 vdd.t42 1.12585716493817e-05f
CMODEL2278 a_3200_n23917.n0 vdd.t41 8.89931755678036e-05f
CMODEL2279 a_3200_n23917.n0 vdd.n14 0.000124678267871964f
CMODEL2280 a_3200_n23917.n0 vdd.t9 1.12585716493817e-05f
CMODEL2281 a_3200_n23917.n0 vdd.t8 8.89931755678036e-05f
CMODEL2282 a_3200_n23917.n0 vdd.n15 0.000239365691658009f
CMODEL2283 a_3200_n23917.n0 vdd.t15 1.89605348054191e-05f
CMODEL2284 a_3200_n23917.n0 vdd.n16 0.000149139748230967f
CMODEL2285 a_3200_n23917.n0 vdd.t14 0.000255765814851484f
CMODEL2286 a_3200_n23917.n0 vdd.n17 0.000208912592374648f
CMODEL2287 a_3200_n23917.n0 vdd.t32 0.000255765814851484f
CMODEL2288 a_3200_n23917.n0 vdd.n18 0.000206225129566235f
CMODEL2289 a_3200_n23917.n0 vdd.t34 1.89605348054191e-05f
CMODEL2290 a_3200_n23917.n0 vdd.n19 0.000207670955681889f
CMODEL2291 a_3200_n23917.n0 vdd.t33 0.000255765814851484f
CMODEL2292 a_3200_n23917.n0 vdd.n20 0.00041443749659671f
CMODEL2293 a_3200_n23917.n0 vdd.t48 0.000256254631954779f
CMODEL2294 a_3200_n23917.n0 vdd.n21 0.000735671802979007f
CMODEL2295 a_3200_n23917.n0 vdd.n22 0.00322398598596686f
CMODEL2296 a_3200_n23917.n0 vdd.t47 3.64495651283652e-06f
CMODEL2297 a_3200_n23917.n0 vdd.t45 3.60753209790278e-06f
CMODEL2298 a_3200_n23917.n0 vdd.n23 4.11938754315519e-05f
CMODEL2299 a_3200_n23917.n0 vdd.t46 9.83114320698218e-05f
CMODEL2300 a_3200_n23917.n0 vdd.n24 0.000105626775959983f
CMODEL2301 a_3200_n23917.n0 vdd.t44 9.83114320698218e-05f
CMODEL2302 a_3200_n23917.n0 vdd.n25 0.000166583506252574f
CMODEL2303 a_3200_n23917.n0 vdd.t43 9.85243872002659e-05f
CMODEL2304 a_3200_n23917.n0 vdd.n26 0.000891315706210995f
CMODEL2305 a_3200_n23917.n0 vdd.n27 0.00059586289261854f
CMODEL2306 a_3200_n23917.n0 vdd.n28 0.000134594861258649f
CMODEL2307 a_3200_n23917.n0 vdd.t29 1.12585716493817e-05f
CMODEL2308 a_3200_n23917.n0 vdd.t28 8.89931755678036e-05f
CMODEL2309 a_3200_n23917.n0 vdd.n29 2.0091620457095e-05f
CMODEL2310 a_3200_n23917.n0 vdd.n30 6.40967098624513e-06f
CMODEL2311 a_3200_n23917.n0 vdd.t38 2.95115591666764e-06f
CMODEL2312 a_3200_n23917.n0 vdd.t40 2.95115591666764e-06f
CMODEL2313 a_3200_n23917.n0 vdd.t37 5.96340365865008e-05f
CMODEL2314 a_3200_n23917.n0 vdd.t39 5.96340365865008e-05f
CMODEL2315 a_3200_n23917.n0 vdd.n31 1.93140506345534e-05f
CMODEL2316 a_3200_n23917.n0 vdd.n32 0.000233080163715846f
CMODEL2317 a_3200_n23917.n0 vdd.n33 0.000118101924691131f
CMODEL2318 a_3200_n23917.n0 vdd.t17 1.12585716493817e-05f
CMODEL2319 a_3200_n23917.n0 vdd.t16 8.89931755678036e-05f
CMODEL2320 a_3200_n23917.n0 vdd.n34 2.0091620457095e-05f
CMODEL2321 a_3200_n23917.n0 vdd.n35 6.40967098624513e-06f
CMODEL2322 a_3200_n23917.n0 vdd.t1 2.95115591666764e-06f
CMODEL2323 a_3200_n23917.n0 vdd.t31 2.95115591666764e-06f
CMODEL2324 a_3200_n23917.n0 vdd.t0 5.96340365865008e-05f
CMODEL2325 a_3200_n23917.n0 vdd.t30 5.96340365865008e-05f
CMODEL2326 a_3200_n23917.n0 vdd.n36 1.93140506345534e-05f
CMODEL2327 a_3200_n23917.n0 vdd.n37 0.000226041816184219f
CMODEL2328 a_3200_n23917.n0 vdd.n38 0.000130391446674193f
CMODEL2329 a_3200_n23917.n0 vdd.t19 1.12585716493817e-05f
CMODEL2330 a_3200_n23917.n0 vdd.t18 8.89931755678036e-05f
CMODEL2331 a_3200_n23917.n0 vdd.n39 0.000110032317447911f
CMODEL2332 a_3200_n23917.n0 vdd.t21 1.12586747753529e-05f
CMODEL2333 a_3200_n23917.n0 vdd.t20 8.89931755678036e-05f
CMODEL2334 a_3200_n23917.n0 vdd.n40 0.000110032317447911f
CMODEL2335 a_3200_n23917.n0 vdd.t11 1.12585716493817e-05f
CMODEL2336 a_3200_n23917.n0 vdd.t10 8.89931755678036e-05f
CMODEL2337 a_3200_n23917.n0 vdd.n41 0.000473379145412847f
CMODEL2338 a_3200_n23917.n0 vdd.n42 0.000906756757872687f
CMODEL2339 a_3200_n23917.n0 vdd.n43 0.000110032317447911f
CMODEL2340 a_3200_n23917.n0 vdd.t13 1.12585716493817e-05f
CMODEL2341 a_3200_n23917.n0 vdd.t12 8.89931755678036e-05f
CMODEL2342 a_3200_n23917.n0 vdd.n44 0.000110032317447911f
CMODEL2343 a_3200_n23917.n0 vdd.t23 1.12585716493817e-05f
CMODEL2344 a_3200_n23917.n0 vdd.t22 8.89931755678036e-05f
CMODEL2345 a_3200_n23917.n0 vdd.n45 0.000135830310393138f
CMODEL2346 a_3200_n23917.n0 vdd.n46 0.00224202048858736f
CMODEL2347 a_3200_n23917.t0 vdd 6.98235031575544e-07f
CMODEL2348 a_3200_n23917.t0 vdd.n0 0.000234314683508395f
CMODEL2349 a_3200_n23917.t0 vdd.n1 2.17141193091082e-05f
CMODEL2350 a_3200_n23917.t0 vdd.t7 1.79003386416774e-06f
CMODEL2351 a_3200_n23917.t0 vdd.t6 1.41492902392234e-05f
CMODEL2352 a_3200_n23917.t0 vdd.n2 1.9471924527203e-05f
CMODEL2353 a_3200_n23917.t0 vdd.t27 1.79003386416774e-06f
CMODEL2354 a_3200_n23917.t0 vdd.t26 1.41492902392234e-05f
CMODEL2355 a_3200_n23917.t0 vdd.n3 3.65221147268929e-05f
CMODEL2356 a_3200_n23917.t0 vdd.n4 1.9471924527203e-05f
CMODEL2357 a_3200_n23917.t0 vdd.t36 1.79003386416774e-06f
CMODEL2358 a_3200_n23917.t0 vdd.t35 1.41492902392234e-05f
CMODEL2359 a_3200_n23917.t0 vdd.n5 2.77833757659275e-05f
CMODEL2360 a_3200_n23917.t0 vdd.t3 2.85141591036205e-06f
CMODEL2361 a_3200_n23917.t0 vdd.n6 2.72809929643364e-05f
CMODEL2362 a_3200_n23917.t0 vdd.t2 3.57536198864695e-05f
CMODEL2363 a_3200_n23917.t0 vdd.n7 3.65713036434978e-05f
CMODEL2364 a_3200_n23917.t0 vdd.t25 2.85141591036205e-06f
CMODEL2365 a_3200_n23917.t0 vdd.n8 1.647795913652e-05f
CMODEL2366 a_3200_n23917.t0 vdd.t24 3.57536198864695e-05f
CMODEL2367 a_3200_n23917.t0 vdd.n9 3.65713036434978e-05f
CMODEL2368 a_3200_n23917.t0 vdd.t5 2.85141591036205e-06f
CMODEL2369 a_3200_n23917.t0 vdd.n10 4.87927818631432e-05f
CMODEL2370 a_3200_n23917.t0 vdd.t4 3.57732954531115e-05f
CMODEL2371 a_3200_n23917.t0 vdd.n11 0.000117972730028451f
CMODEL2372 a_3200_n23917.t0 vdd.n12 0.000290877018712332f
CMODEL2373 a_3200_n23917.t0 vdd.n13 2.20481120528552e-05f
CMODEL2374 a_3200_n23917.t0 vdd.t42 1.79003386416774e-06f
CMODEL2375 a_3200_n23917.t0 vdd.t41 1.41492902392234e-05f
CMODEL2376 a_3200_n23917.t0 vdd.n14 1.98229694287064e-05f
CMODEL2377 a_3200_n23917.t0 vdd.t9 1.79003386416774e-06f
CMODEL2378 a_3200_n23917.t0 vdd.t8 1.41492902392234e-05f
CMODEL2379 a_3200_n23917.t0 vdd.n15 3.80574647771862e-05f
CMODEL2380 a_3200_n23917.t0 vdd.t15 3.01459194304593e-06f
CMODEL2381 a_3200_n23917.t0 vdd.n16 2.37121731015979e-05f
CMODEL2382 a_3200_n23917.t0 vdd.t14 4.06649692464102e-05f
CMODEL2383 a_3200_n23917.t0 vdd.n17 3.32156357527137e-05f
CMODEL2384 a_3200_n23917.t0 vdd.t32 4.06649692464102e-05f
CMODEL2385 a_3200_n23917.t0 vdd.n18 3.27883480304728e-05f
CMODEL2386 a_3200_n23917.t0 vdd.t34 3.01459194304593e-06f
CMODEL2387 a_3200_n23917.t0 vdd.n19 3.30182242340728e-05f
CMODEL2388 a_3200_n23917.t0 vdd.t33 4.06649692464102e-05f
CMODEL2389 a_3200_n23917.t0 vdd.n20 6.58926528686041e-05f
CMODEL2390 a_3200_n23917.t0 vdd.t48 4.07426877346459e-05f
CMODEL2391 a_3200_n23917.t0 vdd.n21 0.000116966652720826f
CMODEL2392 a_3200_n23917.t0 vdd.n22 0.000512591141417113f
CMODEL2393 a_3200_n23917.t0 vdd.t47 5.79522500241357e-07f
CMODEL2394 a_3200_n23917.t0 vdd.t45 5.73572280962721e-07f
CMODEL2395 a_3200_n23917.t0 vdd.n23 6.54953703854921e-06f
CMODEL2396 a_3200_n23917.t0 vdd.t46 1.5630827614751e-05f
CMODEL2397 a_3200_n23917.t0 vdd.n24 1.67939159441786e-05f
CMODEL2398 a_3200_n23917.t0 vdd.t44 1.5630827614751e-05f
CMODEL2399 a_3200_n23917.t0 vdd.n25 2.64856081828357e-05f
CMODEL2400 a_3200_n23917.t0 vdd.t43 1.56646859856807e-05f
CMODEL2401 a_3200_n23917.t0 vdd.n26 0.000141712940812513f
CMODEL2402 a_3200_n23917.t0 vdd.n27 9.47380173440307e-05f
CMODEL2403 a_3200_n23917.t0 vdd.n28 2.13996381689477e-05f
CMODEL2404 a_3200_n23917.t0 vdd.t29 1.79003386416774e-06f
CMODEL2405 a_3200_n23917.t0 vdd.t28 1.41492902392234e-05f
CMODEL2406 a_3200_n23917.t0 vdd.n29 3.19442662215332e-06f
CMODEL2407 a_3200_n23917.t0 vdd.n30 1.01909269495854e-06f
CMODEL2408 a_3200_n23917.t0 vdd.t38 4.69213075493834e-07f
CMODEL2409 a_3200_n23917.t0 vdd.t40 4.69213075493834e-07f
CMODEL2410 a_3200_n23917.t0 vdd.t37 9.48139322386575e-06f
CMODEL2411 a_3200_n23917.t0 vdd.t39 9.48139322386575e-06f
CMODEL2412 a_3200_n23917.t0 vdd.n31 3.07079847841976e-06f
CMODEL2413 a_3200_n23917.t0 vdd.n32 3.70581099548306e-05f
CMODEL2414 a_3200_n23917.t0 vdd.n33 1.87773770247422e-05f
CMODEL2415 a_3200_n23917.t0 vdd.t17 1.79003386416774e-06f
CMODEL2416 a_3200_n23917.t0 vdd.t16 1.41492902392234e-05f
CMODEL2417 a_3200_n23917.t0 vdd.n34 3.19442662215332e-06f
CMODEL2418 a_3200_n23917.t0 vdd.n35 1.01909269495854e-06f
CMODEL2419 a_3200_n23917.t0 vdd.t1 4.69213075493834e-07f
CMODEL2420 a_3200_n23917.t0 vdd.t31 4.69213075493834e-07f
CMODEL2421 a_3200_n23917.t0 vdd.t0 9.48139322386575e-06f
CMODEL2422 a_3200_n23917.t0 vdd.t30 9.48139322386575e-06f
CMODEL2423 a_3200_n23917.t0 vdd.n36 3.07079847841976e-06f
CMODEL2424 a_3200_n23917.t0 vdd.n37 3.59390621020699e-05f
CMODEL2425 a_3200_n23917.t0 vdd.n38 2.07313247553429e-05f
CMODEL2426 a_3200_n23917.t0 vdd.t19 1.79003386416774e-06f
CMODEL2427 a_3200_n23917.t0 vdd.t18 1.41492902392234e-05f
CMODEL2428 a_3200_n23917.t0 vdd.n39 1.74943661166319e-05f
CMODEL2429 a_3200_n23917.t0 vdd.t21 1.79005026047328e-06f
CMODEL2430 a_3200_n23917.t0 vdd.t20 1.41492902392234e-05f
CMODEL2431 a_3200_n23917.t0 vdd.n40 1.74943661166319e-05f
CMODEL2432 a_3200_n23917.t0 vdd.t11 1.79003386416774e-06f
CMODEL2433 a_3200_n23917.t0 vdd.t10 1.41492902392234e-05f
CMODEL2434 a_3200_n23917.t0 vdd.n41 7.52639612971082e-05f
CMODEL2435 a_3200_n23917.t0 vdd.n42 0.000144167959640262f
CMODEL2436 a_3200_n23917.t0 vdd.n43 1.74943661166319e-05f
CMODEL2437 a_3200_n23917.t0 vdd.t13 1.79003386416774e-06f
CMODEL2438 a_3200_n23917.t0 vdd.t12 1.41492902392234e-05f
CMODEL2439 a_3200_n23917.t0 vdd.n44 1.74943661166319e-05f
CMODEL2440 a_3200_n23917.t0 vdd.t23 1.79003386416774e-06f
CMODEL2441 a_3200_n23917.t0 vdd.t22 1.41492902392234e-05f
CMODEL2442 a_3200_n23917.t0 vdd.n45 2.15960659092565e-05f
CMODEL2443 a_3200_n23917.t0 vdd.n46 0.000356465520113263f
CMODEL2444 a_3200_n23917.t3 vdd 2.03129509989996e-06f
CMODEL2445 a_3200_n23917.t3 vdd.n0 0.000681664836224584f
CMODEL2446 a_3200_n23917.t3 vdd.n1 6.31703970104546e-05f
CMODEL2447 a_3200_n23917.t3 vdd.t7 5.20754023001998e-06f
CMODEL2448 a_3200_n23917.t3 vdd.t6 4.11629073739581e-05f
CMODEL2449 a_3200_n23917.t3 vdd.n2 5.66474368787807e-05f
CMODEL2450 a_3200_n23917.t3 vdd.t27 5.20754023001998e-06f
CMODEL2451 a_3200_n23917.t3 vdd.t26 4.11629073739581e-05f
CMODEL2452 a_3200_n23917.t3 vdd.n3 0.000106249599816441f
CMODEL2453 a_3200_n23917.t3 vdd.n4 5.66474368787807e-05f
CMODEL2454 a_3200_n23917.t3 vdd.t36 5.20754023001998e-06f
CMODEL2455 a_3200_n23917.t3 vdd.t35 4.11629073739581e-05f
CMODEL2456 a_3200_n23917.t3 vdd.n5 8.0826988764315e-05f
CMODEL2457 a_3200_n23917.t3 vdd.t3 8.29529729183823e-06f
CMODEL2458 a_3200_n23917.t3 vdd.n6 7.93654640956898e-05f
CMODEL2459 a_3200_n23917.t3 vdd.t2 0.000104013905912444f
CMODEL2460 a_3200_n23917.t3 vdd.n7 0.000106392699490262f
CMODEL2461 a_3200_n23917.t3 vdd.t25 8.29529729183823e-06f
CMODEL2462 a_3200_n23917.t3 vdd.n8 4.79374367322093e-05f
CMODEL2463 a_3200_n23917.t3 vdd.t24 0.000104013905912444f
CMODEL2464 a_3200_n23917.t3 vdd.n9 0.000106392699490262f
CMODEL2465 a_3200_n23917.t3 vdd.t5 8.29529729183823e-06f
CMODEL2466 a_3200_n23917.t3 vdd.n10 0.000141947244447827f
CMODEL2467 a_3200_n23917.t3 vdd.t4 0.000104071145781973f
CMODEL2468 a_3200_n23917.t3 vdd.n11 0.000343204533705332f
CMODEL2469 a_3200_n23917.t3 vdd.n12 0.000846215151151352f
CMODEL2470 a_3200_n23917.t3 vdd.n13 6.41420437956992e-05f
CMODEL2471 a_3200_n23917.t3 vdd.t42 5.20754023001998e-06f
CMODEL2472 a_3200_n23917.t3 vdd.t41 4.11629073739581e-05f
CMODEL2473 a_3200_n23917.t3 vdd.n14 5.76686915509499e-05f
CMODEL2474 a_3200_n23917.t3 vdd.t9 5.20754023001998e-06f
CMODEL2475 a_3200_n23917.t3 vdd.t8 4.11629073739581e-05f
CMODEL2476 a_3200_n23917.t3 vdd.n15 0.000110716217635307f
CMODEL2477 a_3200_n23917.t3 vdd.t15 8.77000660979376e-06f
CMODEL2478 a_3200_n23917.t3 vdd.n16 6.89831057610636e-05f
CMODEL2479 a_3200_n23917.t3 vdd.t14 0.000118301931344558f
CMODEL2480 a_3200_n23917.t3 vdd.n17 9.66304397421934e-05f
CMODEL2481 a_3200_n23917.t3 vdd.t32 0.000118301931344558f
CMODEL2482 a_3200_n23917.t3 vdd.n18 9.53873805756017e-05f
CMODEL2483 a_3200_n23917.t3 vdd.t34 8.77000660979376e-06f
CMODEL2484 a_3200_n23917.t3 vdd.n19 9.60561330512585e-05f
CMODEL2485 a_3200_n23917.t3 vdd.t33 0.000118301931344558f
CMODEL2486 a_3200_n23917.t3 vdd.n20 0.000191693938056047f
CMODEL2487 a_3200_n23917.t3 vdd.t48 0.000118528028829195f
CMODEL2488 a_3200_n23917.t3 vdd.n21 0.00034027766837678f
CMODEL2489 a_3200_n23917.t3 vdd.n22 0.00149122262093212f
CMODEL2490 a_3200_n23917.t3 vdd.t47 1.68593834710036e-06f
CMODEL2491 a_3200_n23917.t3 vdd.t45 1.66862805655714e-06f
CMODEL2492 a_3200_n23917.t3 vdd.n23 1.90538169690486e-05f
CMODEL2493 a_3200_n23917.t3 vdd.t46 4.5472974149664e-05f
CMODEL2494 a_3200_n23917.t3 vdd.n24 4.88566136370528e-05f
CMODEL2495 a_3200_n23917.t3 vdd.t44 4.5472974149664e-05f
CMODEL2496 a_3200_n23917.t3 vdd.n25 7.70515423700043e-05f
CMODEL2497 a_3200_n23917.t3 vdd.t43 4.55714744251441e-05f
CMODEL2498 a_3200_n23917.t3 vdd.n26 0.000412269206280473f
CMODEL2499 a_3200_n23917.t3 vdd.n27 0.000275610448778157f
CMODEL2500 a_3200_n23917.t3 vdd.n28 6.22555130958257e-05f
CMODEL2501 a_3200_n23917.t3 vdd.t29 5.20754023001998e-06f
CMODEL2502 a_3200_n23917.t3 vdd.t28 4.11629073739581e-05f
CMODEL2503 a_3200_n23917.t3 vdd.n29 9.29317901728333e-06f
CMODEL2504 a_3200_n23917.t3 vdd.n30 2.96472950224521e-06f
CMODEL2505 a_3200_n23917.t3 vdd.t38 1.36502778857851e-06f
CMODEL2506 a_3200_n23917.t3 vdd.t40 1.36502778857851e-06f
CMODEL2507 a_3200_n23917.t3 vdd.t37 2.75831299274754e-05f
CMODEL2508 a_3200_n23917.t3 vdd.t39 2.75831299274754e-05f
CMODEL2509 a_3200_n23917.t3 vdd.n31 8.93352183707989e-06f
CMODEL2510 a_3200_n23917.t3 vdd.n32 0.000107808909262177f
CMODEL2511 a_3200_n23917.t3 vdd.n33 5.46268694844282e-05f
CMODEL2512 a_3200_n23917.t3 vdd.t17 5.20754023001998e-06f
CMODEL2513 a_3200_n23917.t3 vdd.t16 4.11629073739581e-05f
CMODEL2514 a_3200_n23917.t3 vdd.n34 9.29317901728333e-06f
CMODEL2515 a_3200_n23917.t3 vdd.n35 2.96472950224521e-06f
CMODEL2516 a_3200_n23917.t3 vdd.t1 1.36502778857851e-06f
CMODEL2517 a_3200_n23917.t3 vdd.t31 1.36502778857851e-06f
CMODEL2518 a_3200_n23917.t3 vdd.t0 2.75831299274754e-05f
CMODEL2519 a_3200_n23917.t3 vdd.t30 2.75831299274754e-05f
CMODEL2520 a_3200_n23917.t3 vdd.n36 8.93352183707989e-06f
CMODEL2521 a_3200_n23917.t3 vdd.n37 0.000104553391682749f
CMODEL2522 a_3200_n23917.t3 vdd.n38 6.03112655275111e-05f
CMODEL2523 a_3200_n23917.t3 vdd.t19 5.20754023001998e-06f
CMODEL2524 a_3200_n23917.t3 vdd.t18 4.11629073739581e-05f
CMODEL2525 a_3200_n23917.t3 vdd.n39 5.08943529922638e-05f
CMODEL2526 a_3200_n23917.t3 vdd.t21 5.20758792991126e-06f
CMODEL2527 a_3200_n23917.t3 vdd.t20 4.11629073739581e-05f
CMODEL2528 a_3200_n23917.t3 vdd.n40 5.08943529922638e-05f
CMODEL2529 a_3200_n23917.t3 vdd.t11 5.20754023001998e-06f
CMODEL2530 a_3200_n23917.t3 vdd.t10 4.11629073739581e-05f
CMODEL2531 a_3200_n23917.t3 vdd.n41 0.000218956810913511f
CMODEL2532 a_3200_n23917.t3 vdd.n42 0.000419411311000879f
CMODEL2533 a_3200_n23917.t3 vdd.n43 5.08943529922638e-05f
CMODEL2534 a_3200_n23917.t3 vdd.t13 5.20754023001998e-06f
CMODEL2535 a_3200_n23917.t3 vdd.t12 4.11629073739581e-05f
CMODEL2536 a_3200_n23917.t3 vdd.n44 5.08943529922638e-05f
CMODEL2537 a_3200_n23917.t3 vdd.t23 5.20754023001998e-06f
CMODEL2538 a_3200_n23917.t3 vdd.t22 4.11629073739581e-05f
CMODEL2539 a_3200_n23917.t3 vdd.n45 6.28269577932842e-05f
CMODEL2540 a_3200_n23917.t3 vdd.n46 0.00103702425622427f
CMODEL2541 a_3200_n23917.n1 vdd 0.000103794402077445f
CMODEL2542 a_3200_n23917.n1 vdd.n0 0.0348314698817688f
CMODEL2543 a_3200_n23917.n1 vdd.n1 0.0032278587129058f
CMODEL2544 a_3200_n23917.n1 vdd.t7 0.000266093057820985f
CMODEL2545 a_3200_n23917.n1 vdd.t6 0.00210332775324454f
CMODEL2546 a_3200_n23917.n1 vdd.n2 0.00289455079192699f
CMODEL2547 a_3200_n23917.n1 vdd.t27 0.000266093057820985f
CMODEL2548 a_3200_n23917.n1 vdd.t26 0.00210332775324454f
CMODEL2549 a_3200_n23917.n1 vdd.n3 0.00542910465567431f
CMODEL2550 a_3200_n23917.n1 vdd.n4 0.00289455079192699f
CMODEL2551 a_3200_n23917.n1 vdd.t36 0.000266093057820985f
CMODEL2552 a_3200_n23917.n1 vdd.t35 0.00210332775324454f
CMODEL2553 a_3200_n23917.n1 vdd.n5 0.00413006902390775f
CMODEL2554 a_3200_n23917.n1 vdd.t3 0.000423870181394816f
CMODEL2555 a_3200_n23917.n1 vdd.n6 0.00405538855079045f
CMODEL2556 a_3200_n23917.n1 vdd.t2 0.00531486595544559f
CMODEL2557 a_3200_n23917.n1 vdd.n7 0.00543641671244167f
CMODEL2558 a_3200_n23917.n1 vdd.t25 0.000423870181394816f
CMODEL2559 a_3200_n23917.n1 vdd.n8 0.00244949027002037f
CMODEL2560 a_3200_n23917.n1 vdd.t24 0.00531486595544559f
CMODEL2561 a_3200_n23917.n1 vdd.n9 0.00543641671244167f
CMODEL2562 a_3200_n23917.n1 vdd.t5 0.000423870181394816f
CMODEL2563 a_3200_n23917.n1 vdd.n10 0.00725317033685985f
CMODEL2564 a_3200_n23917.n1 vdd.t4 0.00531779077815254f
CMODEL2565 a_3200_n23917.n1 vdd.n11 0.0175369444685647f
CMODEL2566 a_3200_n23917.n1 vdd.n12 0.0432396039585557f
CMODEL2567 a_3200_n23917.n1 vdd.n13 0.00327750757835617f
CMODEL2568 a_3200_n23917.n1 vdd.t42 0.000266093057820985f
CMODEL2569 a_3200_n23917.n1 vdd.t41 0.00210332775324454f
CMODEL2570 a_3200_n23917.n1 vdd.n14 0.00294673450372338f
CMODEL2571 a_3200_n23917.n1 vdd.t9 0.000266093057820985f
CMODEL2572 a_3200_n23917.n1 vdd.t8 0.00210332775324454f
CMODEL2573 a_3200_n23917.n1 vdd.n15 0.00565733832090616f
CMODEL2574 a_3200_n23917.n1 vdd.t15 0.000448126711044404f
CMODEL2575 a_3200_n23917.n1 vdd.n16 0.00352487445879595f
CMODEL2576 a_3200_n23917.n1 vdd.t14 0.0060449504501439f
CMODEL2577 a_3200_n23917.n1 vdd.n17 0.00493758819977239f
CMODEL2578 a_3200_n23917.n1 vdd.t32 0.0060449504501439f
CMODEL2579 a_3200_n23917.n1 vdd.n18 0.0048740707999866f
CMODEL2580 a_3200_n23917.n1 vdd.t34 0.000448126711044404f
CMODEL2581 a_3200_n23917.n1 vdd.n19 0.00490824247861272f
CMODEL2582 a_3200_n23917.n1 vdd.t33 0.0060449504501439f
CMODEL2583 a_3200_n23917.n1 vdd.n20 0.0097951093779422f
CMODEL2584 a_3200_n23917.n1 vdd.t48 0.00605650349983632f
CMODEL2585 a_3200_n23917.n1 vdd.n21 0.0173873885341496f
CMODEL2586 a_3200_n23917.n1 vdd.n22 0.0761979686317526f
CMODEL2587 a_3200_n23917.n1 vdd.t47 8.61474842750989e-05f
CMODEL2588 a_3200_n23917.n1 vdd.t45 8.52629691414739e-05f
CMODEL2589 a_3200_n23917.n1 vdd.n23 0.000973605233278449f
CMODEL2590 a_3200_n23917.n1 vdd.t46 0.0023235620283729f
CMODEL2591 a_3200_n23917.n1 vdd.n24 0.00249645804798937f
CMODEL2592 a_3200_n23917.n1 vdd.t44 0.0023235620283729f
CMODEL2593 a_3200_n23917.n1 vdd.n25 0.00393715259286224f
CMODEL2594 a_3200_n23917.n1 vdd.t43 0.0023285951607811f
CMODEL2595 a_3200_n23917.n1 vdd.n26 0.021065986799718f
CMODEL2596 a_3200_n23917.n1 vdd.n27 0.0140830457074572f
CMODEL2597 a_3200_n23917.n1 vdd.n28 0.00318111029663982f
CMODEL2598 a_3200_n23917.n1 vdd.t29 0.000266093057820985f
CMODEL2599 a_3200_n23917.n1 vdd.t28 0.00210332775324454f
CMODEL2600 a_3200_n23917.n1 vdd.n29 0.00047485959058587f
CMODEL2601 a_3200_n23917.n1 vdd.n30 0.000151490704635706f
CMODEL2602 a_3200_n23917.n1 vdd.t38 6.97497095038437e-05f
CMODEL2603 a_3200_n23917.n1 vdd.t40 6.97497095038437e-05f
CMODEL2604 a_3200_n23917.n1 vdd.t37 0.00140943306484015f
CMODEL2605 a_3200_n23917.n1 vdd.t39 0.00140943306484015f
CMODEL2606 a_3200_n23917.n1 vdd.n31 0.00045648195457724f
CMODEL2607 a_3200_n23917.n1 vdd.n32 0.00550878170091597f
CMODEL2608 a_3200_n23917.n1 vdd.n33 0.00279130455037187f
CMODEL2609 a_3200_n23917.n1 vdd.t17 0.000266093057820985f
CMODEL2610 a_3200_n23917.n1 vdd.t16 0.00210332775324454f
CMODEL2611 a_3200_n23917.n1 vdd.n34 0.00047485959058587f
CMODEL2612 a_3200_n23917.n1 vdd.n35 0.000151490704635706f
CMODEL2613 a_3200_n23917.n1 vdd.t1 6.97497095038437e-05f
CMODEL2614 a_3200_n23917.n1 vdd.t31 6.97497095038437e-05f
CMODEL2615 a_3200_n23917.n1 vdd.t0 0.00140943306484015f
CMODEL2616 a_3200_n23917.n1 vdd.t30 0.00140943306484015f
CMODEL2617 a_3200_n23917.n1 vdd.n36 0.00045648195457724f
CMODEL2618 a_3200_n23917.n1 vdd.n37 0.00534243240945854f
CMODEL2619 a_3200_n23917.n1 vdd.n38 0.00308176381869396f
CMODEL2620 a_3200_n23917.n1 vdd.t19 0.000266093057820985f
CMODEL2621 a_3200_n23917.n1 vdd.t18 0.00210332775324454f
CMODEL2622 a_3200_n23917.n1 vdd.n39 0.00260058173635658f
CMODEL2623 a_3200_n23917.n1 vdd.t21 0.000266095495173241f
CMODEL2624 a_3200_n23917.n1 vdd.t20 0.00210332775324454f
CMODEL2625 a_3200_n23917.n1 vdd.n40 0.00260058173635658f
CMODEL2626 a_3200_n23917.n1 vdd.t11 0.000266093057820985f
CMODEL2627 a_3200_n23917.n1 vdd.t10 0.00210332775324454f
CMODEL2628 a_3200_n23917.n1 vdd.n41 0.011188178059737f
CMODEL2629 a_3200_n23917.n1 vdd.n42 0.021430931552977f
CMODEL2630 a_3200_n23917.n1 vdd.n43 0.00260058173635658f
CMODEL2631 a_3200_n23917.n1 vdd.t13 0.000266093057820985f
CMODEL2632 a_3200_n23917.n1 vdd.t12 0.00210332775324454f
CMODEL2633 a_3200_n23917.n1 vdd.n44 0.00260058173635658f
CMODEL2634 a_3200_n23917.n1 vdd.t23 0.000266093057820985f
CMODEL2635 a_3200_n23917.n1 vdd.t22 0.00210332775324454f
CMODEL2636 a_3200_n23917.n1 vdd.n45 0.00321030977666414f
CMODEL2637 a_3200_n23917.n1 vdd.n46 0.0529895004521531f
CMODEL2638 a_3200_n23917.t2 vdd 2.60122471750119e-06f
CMODEL2639 a_3200_n23917.t2 vdd.n0 0.000872922610371145f
CMODEL2640 a_3200_n23917.t2 vdd.n1 8.08943998959336e-05f
CMODEL2641 a_3200_n23917.t2 vdd.t7 6.66864325344798e-06f
CMODEL2642 a_3200_n23917.t2 vdd.t6 5.27121697436404e-05f
CMODEL2643 a_3200_n23917.t2 vdd.n2 7.25412634527745e-05f
CMODEL2644 a_3200_n23917.t2 vdd.t27 6.66864325344798e-06f
CMODEL2645 a_3200_n23917.t2 vdd.t26 5.27121697436404e-05f
CMODEL2646 a_3200_n23917.t2 vdd.n3 0.000136060528714291f
CMODEL2647 a_3200_n23917.t2 vdd.n4 7.25412634527745e-05f
CMODEL2648 a_3200_n23917.t2 vdd.t36 6.66864325344798e-06f
CMODEL2649 a_3200_n23917.t2 vdd.t35 5.27121697436404e-05f
CMODEL2650 a_3200_n23917.t2 vdd.n5 0.000103504981144927f
CMODEL2651 a_3200_n23917.t2 vdd.t3 1.06227462251117e-05f
CMODEL2652 a_3200_n23917.t2 vdd.n6 0.000101633389915542f
CMODEL2653 a_3200_n23917.t2 vdd.t2 0.000133197556099366f
CMODEL2654 a_3200_n23917.t2 vdd.n7 0.00013624377850829f
CMODEL2655 a_3200_n23917.t2 vdd.t25 1.06227462251117e-05f
CMODEL2656 a_3200_n23917.t2 vdd.n8 6.13874593246513e-05f
CMODEL2657 a_3200_n23917.t2 vdd.t24 0.000133197556099366f
CMODEL2658 a_3200_n23917.t2 vdd.n9 0.00013624377850829f
CMODEL2659 a_3200_n23917.t2 vdd.t5 1.06227462251117e-05f
CMODEL2660 a_3200_n23917.t2 vdd.n10 0.000181774022325489f
CMODEL2661 a_3200_n23917.t2 vdd.t4 0.000133270856016966f
CMODEL2662 a_3200_n23917.t2 vdd.n11 0.000439498975937443f
CMODEL2663 a_3200_n23917.t2 vdd.n12 0.00108364154849156f
CMODEL2664 a_3200_n23917.t2 vdd.n13 8.21386659971925e-05f
CMODEL2665 a_3200_n23917.t2 vdd.t42 6.66864325344798e-06f
CMODEL2666 a_3200_n23917.t2 vdd.t41 5.27121697436404e-05f
CMODEL2667 a_3200_n23917.t2 vdd.n14 7.38490561492867e-05f
CMODEL2668 a_3200_n23917.t2 vdd.t9 6.66864325344798e-06f
CMODEL2669 a_3200_n23917.t2 vdd.t8 5.27121697436404e-05f
CMODEL2670 a_3200_n23917.t2 vdd.n15 0.000141780365617672f
CMODEL2671 a_3200_n23917.t2 vdd.t15 1.12306468750739e-05f
CMODEL2672 a_3200_n23917.t2 vdd.n16 8.83380065282069e-05f
CMODEL2673 a_3200_n23917.t2 vdd.t14 0.000151494437197603f
CMODEL2674 a_3200_n23917.t2 vdd.n17 0.000123742477561622f
CMODEL2675 a_3200_n23917.t2 vdd.t32 0.000151494437197603f
CMODEL2676 a_3200_n23917.t2 vdd.n18 0.00012215064768441f
CMODEL2677 a_3200_n23917.t2 vdd.t34 1.12306468750739e-05f
CMODEL2678 a_3200_n23917.t2 vdd.n19 0.000123007035055036f
CMODEL2679 a_3200_n23917.t2 vdd.t33 0.000151494437197603f
CMODEL2680 a_3200_n23917.t2 vdd.n20 0.000245478369878945f
CMODEL2681 a_3200_n23917.t2 vdd.t48 0.000151783971872123f
CMODEL2682 a_3200_n23917.t2 vdd.n21 0.0004357509068175f
CMODEL2683 a_3200_n23917.t2 vdd.n22 0.00190962166996641f
CMODEL2684 a_3200_n23917.t2 vdd.t47 2.15896966466198e-06f
CMODEL2685 a_3200_n23917.t2 vdd.t45 2.13680254791447e-06f
CMODEL2686 a_3200_n23917.t2 vdd.n23 2.43998322376073e-05f
CMODEL2687 a_3200_n23917.t2 vdd.t46 5.82315313723861e-05f
CMODEL2688 a_3200_n23917.t2 vdd.n24 6.25645338347769e-05f
CMODEL2689 a_3200_n23917.t2 vdd.t44 5.82315313723861e-05f
CMODEL2690 a_3200_n23917.t2 vdd.n25 9.86702407465643e-05f
CMODEL2691 a_3200_n23917.t2 vdd.t43 5.83576683139227e-05f
CMODEL2692 a_3200_n23917.t2 vdd.n26 0.00052794143484823f
CMODEL2693 a_3200_n23917.t2 vdd.n27 0.000352939714076328f
CMODEL2694 a_3200_n23917.t2 vdd.n28 7.97228228796281e-05f
CMODEL2695 a_3200_n23917.t2 vdd.t29 6.66864325344798e-06f
CMODEL2696 a_3200_n23917.t2 vdd.t28 5.27121697436404e-05f
CMODEL2697 a_3200_n23917.t2 vdd.n29 1.19006081219373e-05f
CMODEL2698 a_3200_n23917.t2 vdd.n30 3.79655701543564e-06f
CMODEL2699 a_3200_n23917.t2 vdd.t38 1.74801978496442e-06f
CMODEL2700 a_3200_n23917.t2 vdd.t40 1.74801978496442e-06f
CMODEL2701 a_3200_n23917.t2 vdd.t37 3.53222529591734e-05f
CMODEL2702 a_3200_n23917.t2 vdd.t39 3.53222529591734e-05f
CMODEL2703 a_3200_n23917.t2 vdd.n31 1.1440040306351e-05f
CMODEL2704 a_3200_n23917.t2 vdd.n32 0.000138057340636242f
CMODEL2705 a_3200_n23917.t2 vdd.n33 6.99537763614969e-05f
CMODEL2706 a_3200_n23917.t2 vdd.t17 6.66864325344798e-06f
CMODEL2707 a_3200_n23917.t2 vdd.t16 5.27121697436404e-05f
CMODEL2708 a_3200_n23917.t2 vdd.n34 1.19006081219373e-05f
CMODEL2709 a_3200_n23917.t2 vdd.n35 3.79655701543564e-06f
CMODEL2710 a_3200_n23917.t2 vdd.t1 1.74801978496442e-06f
CMODEL2711 a_3200_n23917.t2 vdd.t31 1.74801978496442e-06f
CMODEL2712 a_3200_n23917.t2 vdd.t0 3.53222529591734e-05f
CMODEL2713 a_3200_n23917.t2 vdd.t30 3.53222529591734e-05f
CMODEL2714 a_3200_n23917.t2 vdd.n36 1.1440040306351e-05f
CMODEL2715 a_3200_n23917.t2 vdd.n37 0.000133888407822746f
CMODEL2716 a_3200_n23917.t2 vdd.n38 7.7233069011817e-05f
CMODEL2717 a_3200_n23917.t2 vdd.t19 6.66864325344798e-06f
CMODEL2718 a_3200_n23917.t2 vdd.t18 5.27121697436404e-05f
CMODEL2719 a_3200_n23917.t2 vdd.n39 6.51740109013345e-05f
CMODEL2720 a_3200_n23917.t2 vdd.t21 6.66870433671265e-06f
CMODEL2721 a_3200_n23917.t2 vdd.t20 5.27121697436404e-05f
CMODEL2722 a_3200_n23917.t2 vdd.n40 6.51740109013345e-05f
CMODEL2723 a_3200_n23917.t2 vdd.t11 6.66864325344798e-06f
CMODEL2724 a_3200_n23917.t2 vdd.t10 5.27121697436404e-05f
CMODEL2725 a_3200_n23917.t2 vdd.n41 0.000280390509799147f
CMODEL2726 a_3200_n23917.t2 vdd.n42 0.000537087432066762f
CMODEL2727 a_3200_n23917.t2 vdd.n43 6.51740109013345e-05f
CMODEL2728 a_3200_n23917.t2 vdd.t13 6.66864325344798e-06f
CMODEL2729 a_3200_n23917.t2 vdd.t12 5.27121697436404e-05f
CMODEL2730 a_3200_n23917.t2 vdd.n44 6.51740109013345e-05f
CMODEL2731 a_3200_n23917.t2 vdd.t23 6.66864325344798e-06f
CMODEL2732 a_3200_n23917.t2 vdd.t22 5.27121697436404e-05f
CMODEL2733 a_3200_n23917.t2 vdd.n45 8.04546003903341e-05f
CMODEL2734 a_3200_n23917.t2 vdd.n46 0.00132798682381093f
CMODEL2735 a_6400_n24000.t0 din 7.89569001008042e-05f
CMODEL2736 a_6400_n24000.t0 din.t0 0.000444498962883251f
CMODEL2737 a_6400_n24000.t0 din.t1 0.000459923224428893f
CMODEL2738 a_6400_n24000.t0 din.n0 0.0258917282095037f
CMODEL2739 a_6400_n24000.t0 din.t2 0.000783411722223478f
CMODEL2740 a_6400_n24000.t0 din.n1 0.0341299632170267f
CMODEL2741 a_6400_n24000.t0 din.t3 0.000576799781562501f
CMODEL2742 a_6400_n24000.t1 din 7.89397274983878e-05f
CMODEL2743 a_6400_n24000.t1 din.t0 0.000444402287305128f
CMODEL2744 a_6400_n24000.t1 din.t1 0.000459823194176121f
CMODEL2745 a_6400_n24000.t1 din.n0 0.0258860969302381f
CMODEL2746 a_6400_n24000.t1 din.t2 0.000783241335366637f
CMODEL2747 a_6400_n24000.t1 din.n1 0.034122540176253f
CMODEL2748 a_6400_n24000.t1 din.t3 0.000576674331433253f
CMODEL2749 a_9600_n36000.t1 sa_en 9.2550920574939e-05f
CMODEL2750 a_9600_n36000.t1 sa_en.t1 0.000627109030093287f
CMODEL2751 a_9600_n36000.t1 sa_en.n0 0.0274774548202231f
CMODEL2752 a_9600_n36000.t1 sa_en.t0 0.000768266990215986f
CMODEL2753 a_9600_n36000.t2 sa_en 0.000121108773908665f
CMODEL2754 a_9600_n36000.t2 sa_en.t1 0.000820612104880732f
CMODEL2755 a_9600_n36000.t2 sa_en.n0 0.035955999602548f
CMODEL2756 a_9600_n36000.t2 sa_en.t0 0.00100532628569826f
CMODEL2757 a_9600_n36000.t0 sa_en 3.73955489286503e-05f
CMODEL2758 a_9600_n36000.t0 sa_en.t1 0.000253385771559814f
CMODEL2759 a_9600_n36000.t0 sa_en.n0 0.0111023693744076f
CMODEL2760 a_9600_n36000.t0 sa_en.t0 0.000310421178356905f
CMODEL2761 a_9600_n36000.n0 sa_en 0.00191973805723743f
CMODEL2762 a_9600_n36000.n0 sa_en.t1 0.0130078130355553f
CMODEL2763 a_9600_n36000.n0 sa_en.n0 0.569951280945852f
CMODEL2764 a_9600_n36000.n0 sa_en.t0 0.0159357829190113f
CMODEL2765 a_9600_n36000.t3 sa_en 4.00161004077185e-05f
CMODEL2766 a_9600_n36000.t3 sa_en.t1 0.000271142175128132f
CMODEL2767 a_9600_n36000.t3 sa_en.n0 0.0118803852431083f
CMODEL2768 a_9600_n36000.t3 sa_en.t0 0.000332174427109299f
CMODEL2769 a_9600_n36000.n1 sa_en 0.000960176918024562f
CMODEL2770 a_9600_n36000.n1 sa_en.t1 0.00650599272313875f
CMODEL2771 a_9600_n36000.n1 sa_en.n0 0.285067049798585f
CMODEL2772 a_9600_n36000.n1 sa_en.t0 0.00797044725544675f
CMODEL2773 a_0_n11917.t2 a_0_n23917.t1 6.49254752644566e-05f
CMODEL2774 a_0_n11917.t2 a_0_n23917.n0 0.000217324077722889f
CMODEL2775 a_0_n11917.t2 a_0_n23917.t0 1.47396653553165e-05f
CMODEL2776 a_0_n11917.t2 a_0_n23917.t3 4.26393728677889e-05f
CMODEL2777 a_0_n11917.t2 a_0_n23917.n1 0.00178797470336335f
CMODEL2778 a_0_n11917.t2 a_0_n23917.t2 3.18074827505766e-05f
CMODEL2779 a_0_n11917.t1 a_0_n23917.t1 0.000101566907100327f
CMODEL2780 a_0_n11917.t1 a_0_n23917.n0 0.000339973397542902f
CMODEL2781 a_0_n11917.t1 a_0_n23917.t0 2.30581634671978e-05f
CMODEL2782 a_0_n11917.t1 a_0_n23917.t3 6.67033888506598e-05f
CMODEL2783 a_0_n11917.t1 a_0_n23917.n1 0.002797038602406f
CMODEL2784 a_0_n11917.t1 a_0_n23917.t2 4.97583981089726e-05f
CMODEL2785 a_0_n11917.n0 a_0_n23917.t1 0.00276954565830308f
CMODEL2786 a_0_n11917.n0 a_0_n23917.n0 0.00927045899087399f
CMODEL2787 a_0_n11917.n0 a_0_n23917.t0 0.000628754368348926f
CMODEL2788 a_0_n11917.n0 a_0_n23917.t3 0.00181888063996045f
CMODEL2789 a_0_n11917.n0 a_0_n23917.n1 0.0762701783342451f
CMODEL2790 a_0_n11917.n0 a_0_n23917.t2 0.00135682142324857f
CMODEL2791 a_0_n11917.t6 a_0_n23917.t1 0.000173044207339653f
CMODEL2792 a_0_n11917.t6 a_0_n23917.n0 0.000579228301559559f
CMODEL2793 a_0_n11917.t6 a_0_n23917.t0 3.92852527836453e-05f
CMODEL2794 a_0_n11917.t6 a_0_n23917.t3 0.000113645629074136f
CMODEL2795 a_0_n11917.t6 a_0_n23917.n1 0.00476544321049032f
CMODEL2796 a_0_n11917.t6 a_0_n23917.t2 8.47756696061711e-05f
CMODEL2797 a_0_n11917.n1 a_0_n23917.t1 0.0107369835916108f
CMODEL2798 a_0_n11917.n1 a_0_n23917.n0 0.0359397454861608f
CMODEL2799 a_0_n11917.n1 a_0_n23917.t0 0.00243755697468889f
CMODEL2800 a_0_n11917.n1 a_0_n23917.t3 0.00705144236485329f
CMODEL2801 a_0_n11917.n1 a_0_n23917.n1 0.295684474761744f
CMODEL2802 a_0_n11917.n1 a_0_n23917.t2 0.00526012969473551f
CMODEL2803 a_0_n11917.t4 a_0_n23917.t1 1.37375283436756e-05f
CMODEL2804 a_0_n11917.t4 a_0_n23917.n0 4.59834243079582e-05f
CMODEL2805 a_0_n11917.t4 a_0_n23917.t0 3.11875376761093e-06f
CMODEL2806 a_0_n11917.t4 a_0_n23917.t3 9.02203011902291e-06f
CMODEL2807 a_0_n11917.t4 a_0_n23917.n1 0.000378316108818317f
CMODEL2808 a_0_n11917.t4 a_0_n23917.t2 6.73011932599948e-06f
CMODEL2809 a_0_n11917.t5 a_0_n23917.t1 1.3869825200444e-05f
CMODEL2810 a_0_n11917.t5 a_0_n23917.n0 4.64262596089816e-05f
CMODEL2811 a_0_n11917.t5 a_0_n23917.t0 3.14878837865357e-06f
CMODEL2812 a_0_n11917.t5 a_0_n23917.t3 9.10891519736859e-06f
CMODEL2813 a_0_n11917.t5 a_0_n23917.n1 0.000381959415737101f
CMODEL2814 a_0_n11917.t5 a_0_n23917.t2 6.79493255951799e-06f
CMODEL2815 a_0_n11917.n2 a_0_n23917.t1 0.00348807940416624f
CMODEL2816 a_0_n11917.n2 a_0_n23917.n0 0.0116755963117242f
CMODEL2817 a_0_n11917.n2 a_0_n23917.t0 0.000791879041944084f
CMODEL2818 a_0_n11917.n2 a_0_n23917.t3 0.00229077288538728f
CMODEL2819 a_0_n11917.n2 a_0_n23917.n1 0.0960577910684342f
CMODEL2820 a_0_n11917.n2 a_0_n23917.t2 0.00170883655496931f
CMODEL2821 a_0_n11917.t0 a_0_n23917.t1 2.74919292121082e-05f
CMODEL2822 a_0_n11917.t0 a_0_n23917.n0 9.20233257670917e-05f
CMODEL2823 a_0_n11917.t0 a_0_n23917.t0 6.24133800958656e-06f
CMODEL2824 a_0_n11917.t0 a_0_n23917.t3 1.80551411561508e-05f
CMODEL2825 a_0_n11917.t0 a_0_n23917.n1 0.000757096868027321f
CMODEL2826 a_0_n11917.t0 a_0_n23917.t2 1.34685046298447e-05f
CMODEL2827 a_0_n11917.t3 a_0_n23917.t1 4.93718534066487e-05f
CMODEL2828 a_0_n11917.t3 a_0_n23917.n0 0.000165261670605645f
CMODEL2829 a_0_n11917.t3 a_0_n23917.t0 1.12086140951846e-05f
CMODEL2830 a_0_n11917.t3 a_0_n23917.t3 3.24246354455628e-05f
CMODEL2831 a_0_n11917.t3 a_0_n23917.n1 0.00135964541791469f
CMODEL2832 a_0_n11917.t3 a_0_n23917.t2 2.41876454380872e-05f
CMODEL2833 a_0_n11917.n3 a_0_n23917.t1 0.00765480021373433f
CMODEL2834 a_0_n11917.n3 a_0_n23917.n0 0.0256227989063871f
CMODEL2835 a_0_n11917.n3 a_0_n23917.t0 0.00173782622387699f
CMODEL2836 a_0_n11917.n3 a_0_n23917.t3 0.00502723898766027f
CMODEL2837 a_0_n11917.n3 a_0_n23917.n1 0.210804604597944f
CMODEL2838 a_0_n11917.n3 a_0_n23917.t2 0.00375014468150929f
CMODEL2839 a_0_n11917.n4 a_0_n23917.t1 0.0139434544590818f
CMODEL2840 a_0_n11917.n4 a_0_n23917.n0 0.0466727177313397f
CMODEL2841 a_0_n11917.n4 a_0_n23917.t0 0.00316550401497754f
CMODEL2842 a_0_n11917.n4 a_0_n23917.t3 0.00915727072191808f
CMODEL2843 a_0_n11917.n4 a_0_n23917.n1 0.383987082863689f
CMODEL2844 a_0_n11917.n4 a_0_n23917.t2 0.00683100409175586f
CMODEL2845 a_1600_n11917.t5 a_20000_6483.t1 1.30288698650844e-05f
CMODEL2846 a_1600_n11917.t5 a_20000_6483.t0 6.16865924308727e-06f
CMODEL2847 a_1600_n11917.t5 a_20000_6483.n0 1.67438682960749e-05f
CMODEL2848 a_1600_n11917.t5 a_20000_6483.t2 5.59262276350791e-06f
CMODEL2849 a_1600_n11917.t5 a_20000_6483.t3 5.89155437976409e-06f
CMODEL2850 a_1600_n11917.t5 a_20000_6483.t4 5.7627863545897e-06f
CMODEL2851 a_1600_n11917.t5 a_20000_6483.n1 0.000146867540987337f
CMODEL2852 a_1600_n11917.t4 a_20000_6483.t1 2.07097341232577e-05f
CMODEL2853 a_1600_n11917.t4 a_20000_6483.t0 9.80524743467349e-06f
CMODEL2854 a_1600_n11917.t4 a_20000_6483.n0 2.66148226359853e-05f
CMODEL2855 a_1600_n11917.t4 a_20000_6483.t2 8.8896221762345e-06f
CMODEL2856 a_1600_n11917.t4 a_20000_6483.t3 9.3647819067259e-06f
CMODEL2857 a_1600_n11917.t4 a_20000_6483.t4 9.16010171630624e-06f
CMODEL2858 a_1600_n11917.t4 a_20000_6483.n1 0.000233449850729989f
CMODEL2859 a_1600_n11917.n0 a_20000_6483.t1 0.000360532981724546f
CMODEL2860 a_1600_n11917.n0 a_20000_6483.t0 0.000170698236545671f
CMODEL2861 a_1600_n11917.n0 a_20000_6483.n0 0.000463333875071127f
CMODEL2862 a_1600_n11917.n0 a_20000_6483.t2 0.000154758239315258f
CMODEL2863 a_1600_n11917.n0 a_20000_6483.t3 0.000163030231288207f
CMODEL2864 a_1600_n11917.n0 a_20000_6483.t4 0.000159466981325037f
CMODEL2865 a_1600_n11917.n0 a_20000_6483.n1 0.00406409711809441f
CMODEL2866 a_1600_n11917.t6 a_20000_6483.t1 3.82329569348198e-05f
CMODEL2867 a_1600_n11917.t6 a_20000_6483.t0 1.81018066515937e-05f
CMODEL2868 a_1600_n11917.t6 a_20000_6483.n0 4.91345452149836e-05f
CMODEL2869 a_1600_n11917.t6 a_20000_6483.t2 1.64114391719351e-05f
CMODEL2870 a_1600_n11917.t6 a_20000_6483.t3 1.72886479958107e-05f
CMODEL2871 a_1600_n11917.t6 a_20000_6483.t4 1.69107808122365e-05f
CMODEL2872 a_1600_n11917.t6 a_20000_6483.n1 0.000430979849199328f
CMODEL2873 a_1600_n11917.n1 a_20000_6483.t1 0.00212400592684256f
CMODEL2874 a_1600_n11917.n1 a_20000_6483.t0 0.00100563356059774f
CMODEL2875 a_1600_n11917.n1 a_20000_6483.n0 0.00272963625144811f
CMODEL2876 a_1600_n11917.n1 a_20000_6483.t2 0.000911726344594083f
CMODEL2877 a_1600_n11917.n1 a_20000_6483.t3 0.00096045908436534f
CMODEL2878 a_1600_n11917.n1 a_20000_6483.t4 0.000939466929904487f
CMODEL2879 a_1600_n11917.n1 a_20000_6483.n1 0.0239427924868505f
CMODEL2880 a_1600_n11917.t2 a_20000_6483.t1 2.67046266475146e-06f
CMODEL2881 a_1600_n11917.t2 a_20000_6483.t0 1.26435940882213e-06f
CMODEL2882 a_1600_n11917.t2 a_20000_6483.n0 3.43190741877089e-06f
CMODEL2883 a_1600_n11917.t2 a_20000_6483.t2 1.14629207618463e-06f
CMODEL2884 a_1600_n11917.t2 a_20000_6483.t3 1.2075626030064e-06f
CMODEL2885 a_1600_n11917.t2 a_20000_6483.t4 1.18116966123917e-06f
CMODEL2886 a_1600_n11917.t2 a_20000_6483.n1 3.01027095160105e-05f
CMODEL2887 a_1600_n11917.t3 a_20000_6483.t1 2.67046266475146e-06f
CMODEL2888 a_1600_n11917.t3 a_20000_6483.t0 1.26435940882213e-06f
CMODEL2889 a_1600_n11917.t3 a_20000_6483.n0 3.43190741877089e-06f
CMODEL2890 a_1600_n11917.t3 a_20000_6483.t2 1.14629207618463e-06f
CMODEL2891 a_1600_n11917.t3 a_20000_6483.t3 1.2075626030064e-06f
CMODEL2892 a_1600_n11917.t3 a_20000_6483.t4 1.18116966123917e-06f
CMODEL2893 a_1600_n11917.t3 a_20000_6483.n1 3.01027095160105e-05f
CMODEL2894 a_1600_n11917.n2 a_20000_6483.t1 0.000647800551395634f
CMODEL2895 a_1600_n11917.n2 a_20000_6483.t0 0.000306708171961454f
CMODEL2896 a_1600_n11917.n2 a_20000_6483.n0 0.000832511739468735f
CMODEL2897 a_1600_n11917.n2 a_20000_6483.t2 0.000278067410870155f
CMODEL2898 a_1600_n11917.n2 a_20000_6483.t3 0.000292930408800565f
CMODEL2899 a_1600_n11917.n2 a_20000_6483.t4 0.000286528011771976f
CMODEL2900 a_1600_n11917.n2 a_20000_6483.n1 0.00730231209758895f
CMODEL2901 a_1600_n11917.t1 a_20000_6483.t1 9.43446964637075e-06f
CMODEL2902 a_1600_n11917.t1 a_20000_6483.t0 4.46685161417369e-06f
CMODEL2903 a_1600_n11917.t1 a_20000_6483.n0 1.21245755647222e-05f
CMODEL2904 a_1600_n11917.t1 a_20000_6483.t2 4.04973188406128e-06f
CMODEL2905 a_1600_n11917.t1 a_20000_6483.t3 4.2661943469697e-06f
CMODEL2906 a_1600_n11917.t1 a_20000_6483.t4 4.17295080109727e-06f
CMODEL2907 a_1600_n11917.t1 a_20000_6483.n1 0.00010634977337485f
CMODEL2908 a_1600_n11917.t0 a_20000_6483.t1 1.2967265267985e-05f
CMODEL2909 a_1600_n11917.t0 a_20000_6483.t0 6.13949188081803e-06f
CMODEL2910 a_1600_n11917.t0 a_20000_6483.n0 1.66646980172291e-05f
CMODEL2911 a_1600_n11917.t0 a_20000_6483.t2 5.56617908300129e-06f
CMODEL2912 a_1600_n11917.t0 a_20000_6483.t3 5.86369725649762e-06f
CMODEL2913 a_1600_n11917.t0 a_20000_6483.t4 5.73553808707145e-06f
CMODEL2914 a_1600_n11917.t0 a_20000_6483.n1 0.000146173105032171f
CMODEL2915 a_1600_n11917.n3 a_20000_6483.t1 0.00179749383265542f
CMODEL2916 a_1600_n11917.n3 a_20000_6483.t0 0.000851042880926832f
CMODEL2917 a_1600_n11917.n3 a_20000_6483.n0 0.00231002384002968f
CMODEL2918 a_1600_n11917.n3 a_20000_6483.t2 0.000771571520006786f
CMODEL2919 a_1600_n11917.n3 a_20000_6483.t3 0.000812812835805492f
CMODEL2920 a_1600_n11917.n3 a_20000_6483.t4 0.000795047693203641f
CMODEL2921 a_1600_n11917.n3 a_20000_6483.n1 0.0202621947932316f
CMODEL2922 a_1600_n11917.n4 a_20000_6483.t1 0.00263540910793269f
CMODEL2923 a_1600_n11917.n4 a_20000_6483.t0 0.00124776292351586f
CMODEL2924 a_1600_n11917.n4 a_20000_6483.n0 0.00338685883476013f
CMODEL2925 a_1600_n11917.n4 a_20000_6483.t2 0.00113124538972321f
CMODEL2926 a_1600_n11917.n4 a_20000_6483.t3 0.00119171165520045f
CMODEL2927 a_1600_n11917.n4 a_20000_6483.t4 0.0011656651577015f
CMODEL2928 a_1600_n11917.n4 a_20000_6483.n1 0.0297075693583342f
CMODEL2929 a_0_n23917.t1 we 5.70707788650657e-05f
CMODEL2930 a_0_n23917.t1 we.t1 0.000326293741674898f
CMODEL2931 a_0_n23917.t1 we.t3 0.000332438068488213f
CMODEL2932 a_0_n23917.t1 we.n0 0.0113590929065553f
CMODEL2933 a_0_n23917.t1 we.t0 0.00040292874619694f
CMODEL2934 a_0_n23917.t1 we.n1 0.031020077354937f
CMODEL2935 a_0_n23917.t1 we.t2 0.000606342332007214f
CMODEL2936 a_0_n23917.n0 we 0.000191032169287289f
CMODEL2937 a_0_n23917.n0 we.t1 0.00109219818857557f
CMODEL2938 a_0_n23917.n0 we.t3 0.00111276500233385f
CMODEL2939 a_0_n23917.n0 we.n0 0.0380221227435076f
CMODEL2940 a_0_n23917.n0 we.t0 0.00134871739942777f
CMODEL2941 a_0_n23917.n0 we.n1 0.103833043571803f
CMODEL2942 a_0_n23917.n0 we.t2 0.00202960066986144f
CMODEL2943 a_0_n23917.t0 we 1.29564578250974e-05f
CMODEL2944 a_0_n23917.t0 we.t1 7.40766323270186e-05f
CMODEL2945 a_0_n23917.t0 we.t3 7.54715442732626e-05f
CMODEL2946 a_0_n23917.t0 we.n0 0.00257879095225097f
CMODEL2947 a_0_n23917.t0 we.t0 9.147464622768e-05f
CMODEL2948 a_0_n23917.t0 we.n1 0.00704231363182814f
CMODEL2949 a_0_n23917.t0 we.t2 0.000137654488136512f
CMODEL2950 a_0_n23917.t3 we 3.74808533933807e-05f
CMODEL2951 a_0_n23917.t3 we.t1 0.000214291238670664f
CMODEL2952 a_0_n23917.t3 we.t3 0.000218326484326508f
CMODEL2953 a_0_n23917.t3 we.n0 0.00746000850836469f
CMODEL2954 a_0_n23917.t3 we.t0 0.000264620766783166f
CMODEL2955 a_0_n23917.t3 we.n1 0.0203722289184214f
CMODEL2956 a_0_n23917.t3 we.t2 0.000398211282623203f
CMODEL2957 a_0_n23917.n1 we 0.00157166518221614f
CMODEL2958 a_0_n23917.n1 we.t1 0.00898576334796396f
CMODEL2959 a_0_n23917.n1 we.t3 0.00915497121077369f
CMODEL2960 a_0_n23917.n1 we.n0 0.312816666914621f
CMODEL2961 a_0_n23917.n1 we.t0 0.011096205341949f
CMODEL2962 a_0_n23917.n1 we.n1 0.854258107177307f
CMODEL2963 a_0_n23917.n1 we.t2 0.016697987142818f
CMODEL2964 a_0_n23917.t2 we 2.79594074116285e-05f
CMODEL2965 a_0_n23917.t2 we.t1 0.000159853778777453f
CMODEL2966 a_0_n23917.t2 we.t3 0.000162863931084115f
CMODEL2967 a_0_n23917.t2 we.n0 0.00556490576643111f
CMODEL2968 a_0_n23917.t2 we.t0 0.000197397848720667f
CMODEL2969 a_0_n23917.t2 we.n1 0.0151969711637808f
CMODEL2970 a_0_n23917.t2 we.t2 0.000297051707172055f
CMODEL2971 a_1600_n11917.t5 a_n104_n35959.t0 4.23835670489177e-06f
CMODEL2972 a_1600_n11917.t5 a_n104_n35959.t3 3.69871258433887e-06f
CMODEL2973 a_1600_n11917.t5 a_n104_n35959.t4 1.48295300052042e-06f
CMODEL2974 a_1600_n11917.t5 a_n104_n35959.t2 2.02973302429181e-06f
CMODEL2975 a_1600_n11917.t5 a_n104_n35959.n0 0.000151518098568948f
CMODEL2976 a_1600_n11917.t5 a_n104_n35959.t1 3.75625179627904e-06f
CMODEL2977 a_1600_n11917.t5 a_n104_n35959.n1 7.07817225482068e-05f
CMODEL2978 a_1600_n11917.t4 a_n104_n35959.t0 6.73698036642925e-06f
CMODEL2979 a_1600_n11917.t4 a_n104_n35959.t3 5.87920172764034e-06f
CMODEL2980 a_1600_n11917.t4 a_n104_n35959.t4 2.35719311621708e-06f
CMODEL2981 a_1600_n11917.t4 a_n104_n35959.t2 3.22631446238694e-06f
CMODEL2982 a_1600_n11917.t4 a_n104_n35959.n0 0.000240842035319856f
CMODEL2983 a_1600_n11917.t4 a_n104_n35959.t1 5.97066183072542e-06f
CMODEL2984 a_1600_n11917.t4 a_n104_n35959.n1 0.000112509424834144f
CMODEL2985 a_1600_n11917.n0 a_n104_n35959.t0 0.000117283186972484f
CMODEL2986 a_1600_n11917.n0 a_n104_n35959.t3 0.000102350233779479f
CMODEL2987 a_1600_n11917.n0 a_n104_n35959.t4 4.10360585815496e-05f
CMODEL2988 a_1600_n11917.n0 a_n104_n35959.t2 5.61664754449495e-05f
CMODEL2989 a_1600_n11917.n0 a_n104_n35959.n0 0.00419278666745227f
CMODEL2990 a_1600_n11917.n0 a_n104_n35959.t1 0.000103942450438459f
CMODEL2991 a_1600_n11917.n0 a_n104_n35959.n1 0.00195866147610334f
CMODEL2992 a_1600_n11917.t6 a_n104_n35959.t0 1.24373726232995e-05f
CMODEL2993 a_1600_n11917.t6 a_n104_n35959.t3 1.08537977902651e-05f
CMODEL2994 a_1600_n11917.t6 a_n104_n35959.t4 4.35169579498227e-06f
CMODEL2995 a_1600_n11917.t6 a_n104_n35959.t2 5.95621079268701e-06f
CMODEL2996 a_1600_n11917.t6 a_n104_n35959.n0 0.000444626817016324f
CMODEL2997 a_1600_n11917.t6 a_n104_n35959.t1 1.1022645452031e-05f
CMODEL2998 a_1600_n11917.t6 a_n104_n35959.n1 0.000207707543169971f
CMODEL2999 a_1600_n11917.n1 a_n104_n35959.t0 0.000690949779565144f
CMODEL3000 a_1600_n11917.n1 a_n104_n35959.t3 0.000602975356433342f
CMODEL3001 a_1600_n11917.n1 a_n104_n35959.t4 0.000241755501048895f
CMODEL3002 a_1600_n11917.n1 a_n104_n35959.t2 0.000330893240791145f
CMODEL3003 a_1600_n11917.n1 a_n104_n35959.n0 0.0247009405049634f
CMODEL3004 a_1600_n11917.n1 a_n104_n35959.t1 0.000612355573478436f
CMODEL3005 a_1600_n11917.n1 a_n104_n35959.n1 0.0115390513345605f
CMODEL3006 a_1600_n11917.t2 a_n104_n35959.t0 8.6871489680346e-07f
CMODEL3007 a_1600_n11917.t2 a_n104_n35959.t3 7.58106725019419e-07f
CMODEL3008 a_1600_n11917.t2 a_n104_n35959.t4 3.0395350191375e-07f
CMODEL3009 a_1600_n11917.t2 a_n104_n35959.t2 4.16024284294225e-07f
CMODEL3010 a_1600_n11917.t2 a_n104_n35959.n0 3.10559111766741e-05f
CMODEL3011 a_1600_n11917.t2 a_n104_n35959.t1 7.69900251153042e-07f
CMODEL3012 a_1600_n11917.t2 a_n104_n35959.n1 1.45077776790396e-05f
CMODEL3013 a_1600_n11917.t3 a_n104_n35959.t0 8.6871489680346e-07f
CMODEL3014 a_1600_n11917.t3 a_n104_n35959.t3 7.58106725019419e-07f
CMODEL3015 a_1600_n11917.t3 a_n104_n35959.t4 3.0395350191375e-07f
CMODEL3016 a_1600_n11917.t3 a_n104_n35959.t2 4.16024284294225e-07f
CMODEL3017 a_1600_n11917.t3 a_n104_n35959.n0 3.10559111766741e-05f
CMODEL3018 a_1600_n11917.t3 a_n104_n35959.t1 7.69900251153042e-07f
CMODEL3019 a_1600_n11917.t3 a_n104_n35959.n1 1.45077776790396e-05f
CMODEL3020 a_1600_n11917.n2 a_n104_n35959.t0 0.000210732767989197f
CMODEL3021 a_1600_n11917.n2 a_n104_n35959.t3 0.000183901449350547f
CMODEL3022 a_1600_n11917.n2 a_n104_n35959.t4 7.37330084173586e-05f
CMODEL3023 a_1600_n11917.n2 a_n104_n35959.t2 0.000100919126980139f
CMODEL3024 a_1600_n11917.n2 a_n104_n35959.n0 0.00753353965583927f
CMODEL3025 a_1600_n11917.n2 a_n104_n35959.t1 0.000186762321675445f
CMODEL3026 a_1600_n11917.n2 a_n104_n35959.n1 0.00351929517834386f
CMODEL3027 a_1600_n11917.t1 a_n104_n35959.t0 3.06908028837959e-06f
CMODEL3028 a_1600_n11917.t1 a_n104_n35959.t3 2.6783130055746e-06f
CMODEL3029 a_1600_n11917.t1 a_n104_n35959.t4 1.07383642750919e-06f
CMODEL3030 a_1600_n11917.t1 a_n104_n35959.t2 1.46977096296244e-06f
CMODEL3031 a_1600_n11917.t1 a_n104_n35959.n0 0.000109717336701274f
CMODEL3032 a_1600_n11917.t1 a_n104_n35959.t1 2.7199783191549e-06f
CMODEL3033 a_1600_n11917.t1 a_n104_n35959.n1 5.12544848335982e-05f
CMODEL3034 a_1600_n11917.t0 a_n104_n35959.t0 4.21831642051776e-06f
CMODEL3035 a_1600_n11917.t0 a_n104_n35959.t3 3.68122390720078e-06f
CMODEL3036 a_1600_n11917.t0 a_n104_n35959.t4 1.47594113202681e-06f
CMODEL3037 a_1600_n11917.t0 a_n104_n35959.t2 2.02013580776608e-06f
CMODEL3038 a_1600_n11917.t0 a_n104_n35959.n0 0.000150801673313937f
CMODEL3039 a_1600_n11917.t0 a_n104_n35959.t1 3.73849105563847e-06f
CMODEL3040 a_1600_n11917.t0 a_n104_n35959.n1 7.04470442879483e-05f
CMODEL3041 a_1600_n11917.n3 a_n104_n35959.t0 0.000584733757918101f
CMODEL3042 a_1600_n11917.n3 a_n104_n35959.t3 0.000510283173288187f
CMODEL3043 a_1600_n11917.n3 a_n104_n35959.t4 0.000204591718250003f
CMODEL3044 a_1600_n11917.n3 a_n104_n35959.t2 0.00028002678903708f
CMODEL3045 a_1600_n11917.n3 a_n104_n35959.n0 0.0209037967631581f
CMODEL3046 a_1600_n11917.n3 a_n104_n35959.t1 0.000518221419634133f
CMODEL3047 a_1600_n11917.n3 a_n104_n35959.n1 0.00976521456293666f
CMODEL3048 a_1600_n11917.n4 a_n104_n35959.t0 0.000857311798982113f
CMODEL3049 a_1600_n11917.n4 a_n104_n35959.t3 0.000748155514125918f
CMODEL3050 a_1600_n11917.n4 a_n104_n35959.t4 0.000299963687156093f
CMODEL3051 a_1600_n11917.n4 a_n104_n35959.t2 0.000410563383799346f
CMODEL3052 a_1600_n11917.n4 a_n104_n35959.n0 0.0306482589142555f
CMODEL3053 a_1600_n11917.n4 a_n104_n35959.t1 0.000759794233737107f
CMODEL3054 a_1600_n11917.n4 a_n104_n35959.n1 0.0143173428094947f
CMODEL3055 a_n104_n35959.t0 dout 0.000595729312404726f
CMODEL3056 a_n104_n35959.t0 dout.n0 0.000255433137779232f
CMODEL3057 a_n104_n35959.t0 dout.t0 4.28195686184393e-05f
CMODEL3058 a_n104_n35959.t0 dout.t1 0.000188612267136629f
CMODEL3059 a_n104_n35959.t3 dout 0.000519878730855233f
CMODEL3060 a_n104_n35959.t3 dout.n0 0.000222910393566163f
CMODEL3061 a_n104_n35959.t3 dout.t0 3.73676139910992e-05f
CMODEL3062 a_n104_n35959.t3 dout.t1 0.000164597417016308f
CMODEL3063 a_n104_n35959.t4 dout 0.00020843893821134f
CMODEL3064 a_n104_n35959.t4 dout.n0 8.93731614578039e-05f
CMODEL3065 a_n104_n35959.t4 dout.t0 1.49820820155169e-05f
CMODEL3066 a_n104_n35959.t4 dout.t1 6.5993295741814e-05f
CMODEL3067 a_n104_n35959.t2 dout 0.000285292518567618f
CMODEL3068 a_n104_n35959.t2 dout.n0 0.000122325965308818f
CMODEL3069 a_n104_n35959.t2 dout.t0 2.05061297484622e-05f
CMODEL3070 a_n104_n35959.t2 dout.t1 9.03257026365694e-05f
CMODEL3071 a_n104_n35959.n0 dout 0.0212968796546009f
CMODEL3072 a_n104_n35959.n0 dout.n0 0.009131544615662f
CMODEL3073 a_n104_n35959.n0 dout.t0 0.00153076771738451f
CMODEL3074 a_n104_n35959.n0 dout.t1 0.00674274820954464f
CMODEL3075 a_n104_n35959.t1 dout 0.000527966250984406f
CMODEL3076 a_n104_n35959.t1 dout.n0 0.000226378110531622f
CMODEL3077 a_n104_n35959.t1 dout.t0 3.79489251938773e-05f
CMODEL3078 a_n104_n35959.t1 dout.t1 0.000167157985172538f
CMODEL3079 a_n104_n35959.n1 dout 0.00994884334671451f
CMODEL3080 a_n104_n35959.n1 dout.n0 0.00426580364673888f
CMODEL3081 a_n104_n35959.n1 dout.t0 0.000715098571596433f
CMODEL3082 a_n104_n35959.n1 dout.t1 0.00314987673081991f
CMODEL3083 a_0_n23917.t1 a_6400_n24000.t0 0.00213048861372657f
CMODEL3084 a_0_n23917.t1 a_6400_n24000.t1 0.00213002524657475f
CMODEL3085 a_0_n23917.n0 a_6400_n24000.t0 0.00713135285019183f
CMODEL3086 a_0_n23917.n0 a_6400_n24000.t1 0.00712980182821615f
CMODEL3087 a_0_n23917.t0 a_6400_n24000.t0 0.000483672843082493f
CMODEL3088 a_0_n23917.t0 a_6400_n24000.t1 0.000483567647445085f
CMODEL3089 a_0_n23917.t3 a_6400_n24000.t0 0.00139918418804394f
CMODEL3090 a_0_n23917.t3 a_6400_n24000.t1 0.00139887987475735f
CMODEL3091 a_0_n23917.n1 a_6400_n24000.t0 0.0586712647328457f
CMODEL3092 a_0_n23917.n1 a_6400_n24000.t1 0.0586585041216612f
CMODEL3093 a_0_n23917.t2 a_6400_n24000.t0 0.00104374253026848f
CMODEL3094 a_0_n23917.t2 a_6400_n24000.t1 0.00104351552318646f
CMODEL3095 a_20000_6483.t1 vdd 8.16674020379399e-06f
CMODEL3096 a_20000_6483.t1 vdd.n0 0.00274060604182137f
CMODEL3097 a_20000_6483.t1 vdd.n1 0.000253974039015954f
CMODEL3098 a_20000_6483.t1 vdd.t7 2.09367059278947e-05f
CMODEL3099 a_20000_6483.t1 vdd.t6 0.00016549381257923f
CMODEL3100 a_20000_6483.t1 vdd.n2 0.000227748740309867f
CMODEL3101 a_20000_6483.t1 vdd.t27 2.09367059278947e-05f
CMODEL3102 a_20000_6483.t1 vdd.t26 0.00016549381257923f
CMODEL3103 a_20000_6483.t1 vdd.n3 0.000427172240262228f
CMODEL3104 a_20000_6483.t1 vdd.n4 0.000227748740309867f
CMODEL3105 a_20000_6483.t1 vdd.t36 2.09367059278947e-05f
CMODEL3106 a_20000_6483.t1 vdd.t35 0.00016549381257923f
CMODEL3107 a_20000_6483.t1 vdd.n5 0.000324961655608605f
CMODEL3108 a_20000_6483.t1 vdd.t3 3.3350908934411e-05f
CMODEL3109 a_20000_6483.t1 vdd.n6 0.000319085654494495f
CMODEL3110 a_20000_6483.t1 vdd.t2 0.000418183722892178f
CMODEL3111 a_20000_6483.t1 vdd.n7 0.000427747566742069f
CMODEL3112 a_20000_6483.t1 vdd.t25 3.3350908934411e-05f
CMODEL3113 a_20000_6483.t1 vdd.n8 0.000192730535236877f
CMODEL3114 a_20000_6483.t1 vdd.t24 0.000418183722892178f
CMODEL3115 a_20000_6483.t1 vdd.n9 0.000427747566742069f
CMODEL3116 a_20000_6483.t1 vdd.t5 3.3350908934411e-05f
CMODEL3117 a_20000_6483.t1 vdd.n10 0.00057069318392337f
CMODEL3118 a_20000_6483.t1 vdd.t4 0.000418413853484115f
CMODEL3119 a_20000_6483.t1 vdd.n11 0.00137984001619151f
CMODEL3120 a_20000_6483.t1 vdd.n12 0.00340217396099056f
CMODEL3121 a_20000_6483.t1 vdd.n13 0.000257880505814074f
CMODEL3122 a_20000_6483.t1 vdd.t42 2.09367059278947e-05f
CMODEL3123 a_20000_6483.t1 vdd.t41 0.00016549381257923f
CMODEL3124 a_20000_6483.t1 vdd.n14 0.000231854653620999f
CMODEL3125 a_20000_6483.t1 vdd.t9 2.09367059278947e-05f
CMODEL3126 a_20000_6483.t1 vdd.t8 0.00016549381257923f
CMODEL3127 a_20000_6483.t1 vdd.n15 0.000445130097452999f
CMODEL3128 a_20000_6483.t1 vdd.t15 3.52594586435369e-05f
CMODEL3129 a_20000_6483.t1 vdd.n16 0.000277343800627096f
CMODEL3130 a_20000_6483.t1 vdd.t14 0.000475628154149372f
CMODEL3131 a_20000_6483.t1 vdd.n17 0.000388498794287314f
CMODEL3132 a_20000_6483.t1 vdd.t32 0.000475628154149372f
CMODEL3133 a_20000_6483.t1 vdd.n18 0.000383501124932429f
CMODEL3134 a_20000_6483.t1 vdd.t34 3.52594586435369e-05f
CMODEL3135 a_20000_6483.t1 vdd.n19 0.000386189817348219f
CMODEL3136 a_20000_6483.t1 vdd.t33 0.000475628154149372f
CMODEL3137 a_20000_6483.t1 vdd.n20 0.00077069776362037f
CMODEL3138 a_20000_6483.t1 vdd.t48 0.000476537169987521f
CMODEL3139 a_20000_6483.t1 vdd.n21 0.00136807267192383f
CMODEL3140 a_20000_6483.t1 vdd.n22 0.00599540053622598f
CMODEL3141 a_20000_6483.t1 vdd.t47 6.77824727734566e-06f
CMODEL3142 a_20000_6483.t1 vdd.t45 6.70865195083423e-06f
CMODEL3143 a_20000_6483.t1 vdd.n23 7.66051043418187e-05f
CMODEL3144 a_20000_6483.t1 vdd.t46 0.000182822262601055f
CMODEL3145 a_20000_6483.t1 vdd.n24 0.000196426048992389f
CMODEL3146 a_20000_6483.t1 vdd.t44 0.000182822262601055f
CMODEL3147 a_20000_6483.t1 vdd.n25 0.000309782625315466f
CMODEL3148 a_20000_6483.t1 vdd.t43 0.000183218278994679f
CMODEL3149 a_20000_6483.t1 vdd.n26 0.00165751175291212f
CMODEL3150 a_20000_6483.t1 vdd.n27 0.00110808071792874f
CMODEL3151 a_20000_6483.t1 vdd.n28 0.000250295785054837f
CMODEL3152 a_20000_6483.t1 vdd.t29 2.09367059278947e-05f
CMODEL3153 a_20000_6483.t1 vdd.t28 0.00016549381257923f
CMODEL3154 a_20000_6483.t1 vdd.n29 3.73628522538357e-05f
CMODEL3155 a_20000_6483.t1 vdd.n30 1.19195756542476e-05f
CMODEL3156 a_20000_6483.t1 vdd.t38 5.48803929120351e-06f
CMODEL3157 a_20000_6483.t1 vdd.t40 5.48803929120351e-06f
CMODEL3158 a_20000_6483.t1 vdd.t37 0.000110896863846263f
CMODEL3159 a_20000_6483.t1 vdd.t39 0.000110896863846263f
CMODEL3160 a_20000_6483.t1 vdd.n31 3.59168650345019e-05f
CMODEL3161 a_20000_6483.t1 vdd.n32 0.000433441381137562f
CMODEL3162 a_20000_6483.t1 vdd.n33 0.000219625130414512f
CMODEL3163 a_20000_6483.t1 vdd.t17 2.09367059278947e-05f
CMODEL3164 a_20000_6483.t1 vdd.t16 0.00016549381257923f
CMODEL3165 a_20000_6483.t1 vdd.n34 3.73628522538357e-05f
CMODEL3166 a_20000_6483.t1 vdd.n35 1.19195756542476e-05f
CMODEL3167 a_20000_6483.t1 vdd.t1 5.48803929120351e-06f
CMODEL3168 a_20000_6483.t1 vdd.t31 5.48803929120351e-06f
CMODEL3169 a_20000_6483.t1 vdd.t0 0.000110896863846263f
CMODEL3170 a_20000_6483.t1 vdd.t30 0.000110896863846263f
CMODEL3171 a_20000_6483.t1 vdd.n36 3.59168650345019e-05f
CMODEL3172 a_20000_6483.t1 vdd.n37 0.000420352703721179f
CMODEL3173 a_20000_6483.t1 vdd.n38 0.00024247901594873f
CMODEL3174 a_20000_6483.t1 vdd.t19 2.09367059278947e-05f
CMODEL3175 a_20000_6483.t1 vdd.t18 0.00016549381257923f
CMODEL3176 a_20000_6483.t1 vdd.n39 0.000204618698065325f
CMODEL3177 a_20000_6483.t1 vdd.t21 2.09368977033879e-05f
CMODEL3178 a_20000_6483.t1 vdd.t20 0.00016549381257923f
CMODEL3179 a_20000_6483.t1 vdd.n40 0.000204618698065325f
CMODEL3180 a_20000_6483.t1 vdd.t11 2.09367059278947e-05f
CMODEL3181 a_20000_6483.t1 vdd.t10 0.00016549381257923f
CMODEL3182 a_20000_6483.t1 vdd.n41 0.000880307046804749f
CMODEL3183 a_20000_6483.t1 vdd.n42 0.00168622629752099f
CMODEL3184 a_20000_6483.t1 vdd.n43 0.000204618698065325f
CMODEL3185 a_20000_6483.t1 vdd.t13 2.09367059278947e-05f
CMODEL3186 a_20000_6483.t1 vdd.t12 0.00016549381257923f
CMODEL3187 a_20000_6483.t1 vdd.n44 0.000204618698065325f
CMODEL3188 a_20000_6483.t1 vdd.t23 2.09367059278947e-05f
CMODEL3189 a_20000_6483.t1 vdd.t22 0.00016549381257923f
CMODEL3190 a_20000_6483.t1 vdd.n45 0.000252593255464335f
CMODEL3191 a_20000_6483.t1 vdd.n46 0.00416931428921058f
CMODEL3192 a_20000_6483.t0 vdd 3.86663140899365e-06f
CMODEL3193 a_20000_6483.t0 vdd.n0 0.00129756954874863f
CMODEL3194 a_20000_6483.t0 vdd.n1 0.000120246753517621f
CMODEL3195 a_20000_6483.t0 vdd.t7 9.9127096885061e-06f
CMODEL3196 a_20000_6483.t0 vdd.t6 7.83548340885976e-05f
CMODEL3197 a_20000_6483.t0 vdd.n2 0.000107830102423457f
CMODEL3198 a_20000_6483.t0 vdd.t27 9.9127096885061e-06f
CMODEL3199 a_20000_6483.t0 vdd.t26 7.83548340885976e-05f
CMODEL3200 a_20000_6483.t0 vdd.n3 0.000202249313683418f
CMODEL3201 a_20000_6483.t0 vdd.n4 0.000107830102423457f
CMODEL3202 a_20000_6483.t0 vdd.t36 9.9127096885061e-06f
CMODEL3203 a_20000_6483.t0 vdd.t35 7.83548340885976e-05f
CMODEL3204 a_20000_6483.t0 vdd.n5 0.000153856607770023f
CMODEL3205 a_20000_6483.t0 vdd.t3 1.57903482645832e-05f
CMODEL3206 a_20000_6483.t0 vdd.n6 0.000151074551539491f
CMODEL3207 a_20000_6483.t0 vdd.t2 0.000197993602993959f
CMODEL3208 a_20000_6483.t0 vdd.n7 0.000202521708222961f
CMODEL3209 a_20000_6483.t0 vdd.t25 1.57903482645832e-05f
CMODEL3210 a_20000_6483.t0 vdd.n8 9.12503547832784e-05f
CMODEL3211 a_20000_6483.t0 vdd.t24 0.000197993602993959f
CMODEL3212 a_20000_6483.t0 vdd.n9 0.000202521708222961f
CMODEL3213 a_20000_6483.t0 vdd.t5 1.57903482645832e-05f
CMODEL3214 a_20000_6483.t0 vdd.n10 0.000270200855517793f
CMODEL3215 a_20000_6483.t0 vdd.t4 0.000198102560809776f
CMODEL3216 a_20000_6483.t0 vdd.n11 0.000653300167858138f
CMODEL3217 a_20000_6483.t0 vdd.n12 0.00161079602976902f
CMODEL3218 a_20000_6483.t0 vdd.n13 0.000122096312441118f
CMODEL3219 a_20000_6483.t0 vdd.t42 9.9127096885061e-06f
CMODEL3220 a_20000_6483.t0 vdd.t41 7.83548340885976e-05f
CMODEL3221 a_20000_6483.t0 vdd.n14 0.000109774091453995f
CMODEL3222 a_20000_6483.t0 vdd.t9 9.9127096885061e-06f
CMODEL3223 a_20000_6483.t0 vdd.t8 7.83548340885976e-05f
CMODEL3224 a_20000_6483.t0 vdd.n15 0.000210751655244351f
CMODEL3225 a_20000_6483.t0 vdd.t15 1.66939717504269e-05f
CMODEL3226 a_20000_6483.t0 vdd.n16 0.000131311419713854f
CMODEL3227 a_20000_6483.t0 vdd.t14 0.000225191289785521f
CMODEL3228 a_20000_6483.t0 vdd.n17 0.000183938952735343f
CMODEL3229 a_20000_6483.t0 vdd.t32 0.000225191289785521f
CMODEL3230 a_20000_6483.t0 vdd.n18 0.000181572752168514f
CMODEL3231 a_20000_6483.t0 vdd.t34 1.66939717504269e-05f
CMODEL3232 a_20000_6483.t0 vdd.n19 0.000182845742649978f
CMODEL3233 a_20000_6483.t0 vdd.t33 0.000225191289785521f
CMODEL3234 a_20000_6483.t0 vdd.n20 0.000364895185262692f
CMODEL3235 a_20000_6483.t0 vdd.t48 0.000225621673157998f
CMODEL3236 a_20000_6483.t0 vdd.n21 0.000647728791542687f
CMODEL3237 a_20000_6483.t0 vdd.n22 0.00283858717730474f
CMODEL3238 a_20000_6483.t0 vdd.t47 3.20923442726078e-06f
CMODEL3239 a_20000_6483.t0 vdd.t45 3.17628376779408e-06f
CMODEL3240 a_20000_6483.t0 vdd.n23 3.62695145364984e-05f
CMODEL3241 a_20000_6483.t0 vdd.t46 8.65591760232704e-05f
CMODEL3242 a_20000_6483.t0 vdd.n24 9.30000357089424e-05f
CMODEL3243 a_20000_6483.t0 vdd.t44 8.65591760232704e-05f
CMODEL3244 a_20000_6483.t0 vdd.n25 0.000146669931835082f
CMODEL3245 a_20000_6483.t0 vdd.t43 8.67466742646558e-05f
CMODEL3246 a_20000_6483.t0 vdd.n26 0.000784766852459531f
CMODEL3247 a_20000_6483.t0 vdd.n27 0.000524632791141446f
CMODEL3248 a_20000_6483.t0 vdd.n28 0.000118505244428144f
CMODEL3249 a_20000_6483.t0 vdd.t29 9.9127096885061e-06f
CMODEL3250 a_20000_6483.t0 vdd.t28 7.83548340885976e-05f
CMODEL3251 a_20000_6483.t0 vdd.n29 1.76898461869958e-05f
CMODEL3252 a_20000_6483.t0 vdd.n30 5.64345191061407e-06f
CMODEL3253 a_20000_6483.t0 vdd.t38 2.59837151269983e-06f
CMODEL3254 a_20000_6483.t0 vdd.t40 2.59837151269983e-06f
CMODEL3255 a_20000_6483.t0 vdd.t37 5.25053186714141e-05f
CMODEL3256 a_20000_6483.t0 vdd.t39 5.25053186714141e-05f
CMODEL3257 a_20000_6483.t0 vdd.n31 1.70052279109446e-05f
CMODEL3258 a_20000_6483.t0 vdd.n32 0.000205217506182637f
CMODEL3259 a_20000_6483.t0 vdd.n33 0.000103983891525111f
CMODEL3260 a_20000_6483.t0 vdd.t17 9.9127096885061e-06f
CMODEL3261 a_20000_6483.t0 vdd.t16 7.83548340885976e-05f
CMODEL3262 a_20000_6483.t0 vdd.n34 1.76898461869958e-05f
CMODEL3263 a_20000_6483.t0 vdd.n35 5.64345191061407e-06f
CMODEL3264 a_20000_6483.t0 vdd.t1 2.59837151269983e-06f
CMODEL3265 a_20000_6483.t0 vdd.t31 2.59837151269983e-06f
CMODEL3266 a_20000_6483.t0 vdd.t0 5.25053186714141e-05f
CMODEL3267 a_20000_6483.t0 vdd.t30 5.25053186714141e-05f
CMODEL3268 a_20000_6483.t0 vdd.n36 1.70052279109446e-05f
CMODEL3269 a_20000_6483.t0 vdd.n37 0.000199020530408036f
CMODEL3270 a_20000_6483.t0 vdd.n38 0.000114804310617554f
CMODEL3271 a_20000_6483.t0 vdd.t19 9.9127096885061e-06f
CMODEL3272 a_20000_6483.t0 vdd.t18 7.83548340885976e-05f
CMODEL3273 a_20000_6483.t0 vdd.n39 9.68789339520335e-05f
CMODEL3274 a_20000_6483.t0 vdd.t21 9.91280048668595e-06f
CMODEL3275 a_20000_6483.t0 vdd.t20 7.83548340885976e-05f
CMODEL3276 a_20000_6483.t0 vdd.n40 9.68789339520335e-05f
CMODEL3277 a_20000_6483.t0 vdd.t11 9.9127096885061e-06f
CMODEL3278 a_20000_6483.t0 vdd.t10 7.83548340885976e-05f
CMODEL3279 a_20000_6483.t0 vdd.n41 0.000416790884954609f
CMODEL3280 a_20000_6483.t0 vdd.n42 0.000798362063928118f
CMODEL3281 a_20000_6483.t0 vdd.n43 9.68789339520335e-05f
CMODEL3282 a_20000_6483.t0 vdd.t13 9.9127096885061e-06f
CMODEL3283 a_20000_6483.t0 vdd.t12 7.83548340885976e-05f
CMODEL3284 a_20000_6483.t0 vdd.n44 9.68789339520335e-05f
CMODEL3285 a_20000_6483.t0 vdd.t23 9.9127096885061e-06f
CMODEL3286 a_20000_6483.t0 vdd.t22 7.83548340885976e-05f
CMODEL3287 a_20000_6483.t0 vdd.n45 0.000119593006622718f
CMODEL3288 a_20000_6483.t0 vdd.n46 0.00197400690879554f
CMODEL3289 a_20000_6483.n0 vdd 1.04953709566966e-05f
CMODEL3290 a_20000_6483.n0 vdd.n0 0.00352205119023091f
CMODEL3291 a_20000_6483.n0 vdd.n1 0.000326391153180635f
CMODEL3292 a_20000_6483.n0 vdd.t7 2.69065122486007e-05f
CMODEL3293 a_20000_6483.n0 vdd.t6 0.000212682038452763f
CMODEL3294 a_20000_6483.n0 vdd.n2 0.000292688080534503f
CMODEL3295 a_20000_6483.n0 vdd.t27 2.69065122486007e-05f
CMODEL3296 a_20000_6483.n0 vdd.t26 0.000212682038452763f
CMODEL3297 a_20000_6483.n0 vdd.n3 0.000548974378035487f
CMODEL3298 a_20000_6483.n0 vdd.n4 0.000292688080534503f
CMODEL3299 a_20000_6483.n0 vdd.t36 2.69065122486007e-05f
CMODEL3300 a_20000_6483.n0 vdd.t35 0.000212682038452763f
CMODEL3301 a_20000_6483.n0 vdd.n5 0.000417619887152789f
CMODEL3302 a_20000_6483.n0 vdd.t3 4.28604501030947e-05f
CMODEL3303 a_20000_6483.n0 vdd.n6 0.000410068427219499f
CMODEL3304 a_20000_6483.n0 vdd.t2 0.000537422911747193f
CMODEL3305 a_20000_6483.n0 vdd.n7 0.00054971375074436f
CMODEL3306 a_20000_6483.n0 vdd.t25 4.28604501030947e-05f
CMODEL3307 a_20000_6483.n0 vdd.n8 0.000247684928321094f
CMODEL3308 a_20000_6483.n0 vdd.t24 0.000537422911747193f
CMODEL3309 a_20000_6483.n0 vdd.n9 0.00054971375074436f
CMODEL3310 a_20000_6483.n0 vdd.t5 4.28604501030947e-05f
CMODEL3311 a_20000_6483.n0 vdd.n10 0.000733418293990969f
CMODEL3312 a_20000_6483.n0 vdd.t4 0.000537718660830742f
CMODEL3313 a_20000_6483.n0 vdd.n11 0.00177328193005287f
CMODEL3314 a_20000_6483.n0 vdd.n12 0.00437225586816408f
CMODEL3315 a_20000_6483.n0 vdd.n13 0.000331411493873883f
CMODEL3316 a_20000_6483.n0 vdd.t42 2.69065122486007e-05f
CMODEL3317 a_20000_6483.n0 vdd.t41 0.000212682038452763f
CMODEL3318 a_20000_6483.n0 vdd.n14 0.00029796473710016f
CMODEL3319 a_20000_6483.n0 vdd.t9 2.69065122486007e-05f
CMODEL3320 a_20000_6483.n0 vdd.t8 0.000212682038452763f
CMODEL3321 a_20000_6483.n0 vdd.n15 0.000572052664855112f
CMODEL3322 a_20000_6483.n0 vdd.t15 4.53131958359964e-05f
CMODEL3323 a_20000_6483.n0 vdd.n16 0.00035642447261506f
CMODEL3324 a_20000_6483.n0 vdd.t14 0.000611246812152475f
CMODEL3325 a_20000_6483.n0 vdd.n17 0.000499273744545038f
CMODEL3326 a_20000_6483.n0 vdd.t32 0.000611246812152475f
CMODEL3327 a_20000_6483.n0 vdd.n18 0.000492851060280627f
CMODEL3328 a_20000_6483.n0 vdd.t34 4.53131958359964e-05f
CMODEL3329 a_20000_6483.n0 vdd.n19 0.00049630639540676f
CMODEL3330 a_20000_6483.n0 vdd.t33 0.000611246812152475f
CMODEL3331 a_20000_6483.n0 vdd.n20 0.000990451357927915f
CMODEL3332 a_20000_6483.n0 vdd.t48 0.000612415021032495f
CMODEL3333 a_20000_6483.n0 vdd.n21 0.00175815929358072f
CMODEL3334 a_20000_6483.n0 vdd.n22 0.00770490441613866f
CMODEL3335 a_20000_6483.n0 vdd.t47 8.71096886110228e-06f
CMODEL3336 a_20000_6483.n0 vdd.t45 8.62152940908559e-06f
CMODEL3337 a_20000_6483.n0 vdd.n23 9.84479691015916e-05f
CMODEL3338 a_20000_6483.n0 vdd.t46 0.000234951451528881f
CMODEL3339 a_20000_6483.n0 vdd.n24 0.000252434165687755f
CMODEL3340 a_20000_6483.n0 vdd.t44 0.000234951451528881f
CMODEL3341 a_20000_6483.n0 vdd.n25 0.000398112770517021f
CMODEL3342 a_20000_6483.n0 vdd.t43 0.000235460386410156f
CMODEL3343 a_20000_6483.n0 vdd.n26 0.00213012784511199f
CMODEL3344 a_20000_6483.n0 vdd.n27 0.00142403430186527f
CMODEL3345 a_20000_6483.n0 vdd.n28 0.000321664096995239f
CMODEL3346 a_20000_6483.n0 vdd.t29 2.69065122486007e-05f
CMODEL3347 a_20000_6483.n0 vdd.t28 0.000212682038452763f
CMODEL3348 a_20000_6483.n0 vdd.n29 4.80163424596364e-05f
CMODEL3349 a_20000_6483.n0 vdd.n30 1.53182744909188e-05f
CMODEL3350 a_20000_6483.n0 vdd.t38 7.05287626994044e-06f
CMODEL3351 a_20000_6483.n0 vdd.t40 7.05287626994044e-06f
CMODEL3352 a_20000_6483.n0 vdd.t37 0.000142517540041264f
CMODEL3353 a_20000_6483.n0 vdd.t39 0.000142517540041264f
CMODEL3354 a_20000_6483.n0 vdd.n31 4.61580523846687e-05f
CMODEL3355 a_20000_6483.n0 vdd.n32 0.000557031075986507f
CMODEL3356 a_20000_6483.n0 vdd.n33 0.000282248137885215f
CMODEL3357 a_20000_6483.n0 vdd.t17 2.69065122486007e-05f
CMODEL3358 a_20000_6483.n0 vdd.t16 0.000212682038452763f
CMODEL3359 a_20000_6483.n0 vdd.n34 4.80163424596364e-05f
CMODEL3360 a_20000_6483.n0 vdd.n35 1.53182744909188e-05f
CMODEL3361 a_20000_6483.n0 vdd.t1 7.05287626994044e-06f
CMODEL3362 a_20000_6483.n0 vdd.t31 7.05287626994044e-06f
CMODEL3363 a_20000_6483.n0 vdd.t0 0.000142517540041264f
CMODEL3364 a_20000_6483.n0 vdd.t30 0.000142517540041264f
CMODEL3365 a_20000_6483.n0 vdd.n36 4.61580523846687e-05f
CMODEL3366 a_20000_6483.n0 vdd.n37 0.000540210346859644f
CMODEL3367 a_20000_6483.n0 vdd.n38 0.00031161848645735f
CMODEL3368 a_20000_6483.n0 vdd.t19 2.69065122486007e-05f
CMODEL3369 a_20000_6483.n0 vdd.t18 0.000212682038452763f
CMODEL3370 a_20000_6483.n0 vdd.n39 0.000262962833062108f
CMODEL3371 a_20000_6483.n0 vdd.t21 2.69067587061704e-05f
CMODEL3372 a_20000_6483.n0 vdd.t20 0.000212682038452763f
CMODEL3373 a_20000_6483.n0 vdd.n40 0.000262962833062108f
CMODEL3374 a_20000_6483.n0 vdd.t11 2.69065122486007e-05f
CMODEL3375 a_20000_6483.n0 vdd.t10 0.000212682038452763f
CMODEL3376 a_20000_6483.n0 vdd.n41 0.00113131418184672f
CMODEL3377 a_20000_6483.n0 vdd.n42 0.00216702993701185f
CMODEL3378 a_20000_6483.n0 vdd.n43 0.000262962833062108f
CMODEL3379 a_20000_6483.n0 vdd.t13 2.69065122486007e-05f
CMODEL3380 a_20000_6483.n0 vdd.t12 0.000212682038452763f
CMODEL3381 a_20000_6483.n0 vdd.n44 0.000262962833062108f
CMODEL3382 a_20000_6483.n0 vdd.t23 2.69065122486007e-05f
CMODEL3383 a_20000_6483.n0 vdd.t22 0.000212682038452763f
CMODEL3384 a_20000_6483.n0 vdd.n45 0.000324616658679339f
CMODEL3385 a_20000_6483.n0 vdd.n46 0.00535813543817546f
CMODEL3386 a_20000_6483.t2 vdd 3.50556093048348e-06f
CMODEL3387 a_20000_6483.t2 vdd.n0 0.00117640101513119f
CMODEL3388 a_20000_6483.t2 vdd.n1 0.000109017973672997f
CMODEL3389 a_20000_6483.t2 vdd.t7 8.9870494814752e-06f
CMODEL3390 a_20000_6483.t2 vdd.t6 7.10379697575034e-05f
CMODEL3391 a_20000_6483.t2 vdd.n2 9.7760803707971e-05f
CMODEL3392 a_20000_6483.t2 vdd.t27 8.9870494814752e-06f
CMODEL3393 a_20000_6483.t2 vdd.t26 7.10379697575034e-05f
CMODEL3394 a_20000_6483.t2 vdd.n3 0.000183363040660298f
CMODEL3395 a_20000_6483.t2 vdd.n4 9.7760803707971e-05f
CMODEL3396 a_20000_6483.t2 vdd.t36 8.9870494814752e-06f
CMODEL3397 a_20000_6483.t2 vdd.t35 7.10379697575034e-05f
CMODEL3398 a_20000_6483.t2 vdd.n5 0.00013948930116297f
CMODEL3399 a_20000_6483.t2 vdd.t3 1.43158274218481e-05f
CMODEL3400 a_20000_6483.t2 vdd.n6 0.000136967036536071f
CMODEL3401 a_20000_6483.t2 vdd.t2 0.000179504733119086f
CMODEL3402 a_20000_6483.t2 vdd.n7 0.000183609998685125f
CMODEL3403 a_20000_6483.t2 vdd.t25 1.43158274218481e-05f
CMODEL3404 a_20000_6483.t2 vdd.n8 8.27292919301746e-05f
CMODEL3405 a_20000_6483.t2 vdd.t24 0.000179504733119086f
CMODEL3406 a_20000_6483.t2 vdd.n9 0.000183609998685125f
CMODEL3407 a_20000_6483.t2 vdd.t5 1.43158274218481e-05f
CMODEL3408 a_20000_6483.t2 vdd.n10 0.000244969189533613f
CMODEL3409 a_20000_6483.t2 vdd.t4 0.000179603516329017f
CMODEL3410 a_20000_6483.t2 vdd.n11 0.00059229424842381f
CMODEL3411 a_20000_6483.t2 vdd.n12 0.00146037804787963f
CMODEL3412 a_20000_6483.t2 vdd.n13 0.000110694818661571f
CMODEL3413 a_20000_6483.t2 vdd.t42 8.9870494814752e-06f
CMODEL3414 a_20000_6483.t2 vdd.t41 7.10379697575034e-05f
CMODEL3415 a_20000_6483.t2 vdd.n14 9.95232608118189e-05f
CMODEL3416 a_20000_6483.t2 vdd.t9 8.9870494814752e-06f
CMODEL3417 a_20000_6483.t2 vdd.t8 7.10379697575034e-05f
CMODEL3418 a_20000_6483.t2 vdd.n15 0.000191071423808562f
CMODEL3419 a_20000_6483.t2 vdd.t15 1.51350695095405e-05f
CMODEL3420 a_20000_6483.t2 vdd.n16 0.000119049408641465f
CMODEL3421 a_20000_6483.t2 vdd.t14 0.000204162668704635f
CMODEL3422 a_20000_6483.t2 vdd.n17 0.000166762522231435f
CMODEL3423 a_20000_6483.t2 vdd.t32 0.000204162668704635f
CMODEL3424 a_20000_6483.t2 vdd.n18 0.000164617280189106f
CMODEL3425 a_20000_6483.t2 vdd.t34 1.51350695095405e-05f
CMODEL3426 a_20000_6483.t2 vdd.n19 0.000165771397358463f
CMODEL3427 a_20000_6483.t2 vdd.t33 0.000204162668704635f
CMODEL3428 a_20000_6483.t2 vdd.n20 0.000330820854091016f
CMODEL3429 a_20000_6483.t2 vdd.t48 0.000204552862383861f
CMODEL3430 a_20000_6483.t2 vdd.n21 0.000587243133622684f
CMODEL3431 a_20000_6483.t2 vdd.n22 0.00257351664898433f
CMODEL3432 a_20000_6483.t2 vdd.t47 2.90955243336628e-06f
CMODEL3433 a_20000_6483.t2 vdd.t45 2.87967874429639e-06f
CMODEL3434 a_20000_6483.t2 vdd.n23 3.28826256443831e-05f
CMODEL3435 a_20000_6483.t2 vdd.t46 7.8476180826606e-05f
CMODEL3436 a_20000_6483.t2 vdd.n24 8.43155856429793e-05f
CMODEL3437 a_20000_6483.t2 vdd.t44 7.8476180826606e-05f
CMODEL3438 a_20000_6483.t2 vdd.n25 0.000132973725274621f
CMODEL3439 a_20000_6483.t2 vdd.t43 7.86461702670285e-05f
CMODEL3440 a_20000_6483.t2 vdd.n26 0.000711484423139426f
CMODEL3441 a_20000_6483.t2 vdd.n27 0.000475641979009998f
CMODEL3442 a_20000_6483.t2 vdd.n28 0.000107439088700937f
CMODEL3443 a_20000_6483.t2 vdd.t29 8.9870494814752e-06f
CMODEL3444 a_20000_6483.t2 vdd.t28 7.10379697575034e-05f
CMODEL3445 a_20000_6483.t2 vdd.n29 1.60379480483076e-05f
CMODEL3446 a_20000_6483.t2 vdd.n30 5.1164598944951e-06f
CMODEL3447 a_20000_6483.t2 vdd.t38 2.35573259882366e-06f
CMODEL3448 a_20000_6483.t2 vdd.t40 2.35573259882366e-06f
CMODEL3449 a_20000_6483.t2 vdd.t37 4.76023117561648e-05f
CMODEL3450 a_20000_6483.t2 vdd.t39 4.76023117561648e-05f
CMODEL3451 a_20000_6483.t2 vdd.n31 1.54172602125761e-05f
CMODEL3452 a_20000_6483.t2 vdd.n32 0.000186054059937495f
CMODEL3453 a_20000_6483.t2 vdd.n33 9.42737563974154e-05f
CMODEL3454 a_20000_6483.t2 vdd.t17 8.9870494814752e-06f
CMODEL3455 a_20000_6483.t2 vdd.t16 7.10379697575034e-05f
CMODEL3456 a_20000_6483.t2 vdd.n34 1.60379480483076e-05f
CMODEL3457 a_20000_6483.t2 vdd.n35 5.1164598944951e-06f
CMODEL3458 a_20000_6483.t2 vdd.t1 2.35573259882366e-06f
CMODEL3459 a_20000_6483.t2 vdd.t31 2.35573259882366e-06f
CMODEL3460 a_20000_6483.t2 vdd.t0 4.76023117561648e-05f
CMODEL3461 a_20000_6483.t2 vdd.t30 4.76023117561648e-05f
CMODEL3462 a_20000_6483.t2 vdd.n36 1.54172602125761e-05f
CMODEL3463 a_20000_6483.t2 vdd.n37 0.000180435764872684f
CMODEL3464 a_20000_6483.t2 vdd.n38 0.000104083752336955f
CMODEL3465 a_20000_6483.t2 vdd.t19 8.9870494814752e-06f
CMODEL3466 a_20000_6483.t2 vdd.t18 7.10379697575034e-05f
CMODEL3467 a_20000_6483.t2 vdd.n39 8.78322679165141e-05f
CMODEL3468 a_20000_6483.t2 vdd.t21 8.98713180081681e-06f
CMODEL3469 a_20000_6483.t2 vdd.t20 7.10379697575034e-05f
CMODEL3470 a_20000_6483.t2 vdd.n40 8.78322679165141e-05f
CMODEL3471 a_20000_6483.t2 vdd.t11 8.9870494814752e-06f
CMODEL3472 a_20000_6483.t2 vdd.t10 7.10379697575034e-05f
CMODEL3473 a_20000_6483.t2 vdd.n41 0.000377870473787618f
CMODEL3474 a_20000_6483.t2 vdd.n42 0.000723810098158536f
CMODEL3475 a_20000_6483.t2 vdd.n43 8.78322679165141e-05f
CMODEL3476 a_20000_6483.t2 vdd.t13 8.9870494814752e-06f
CMODEL3477 a_20000_6483.t2 vdd.t12 7.10379697575034e-05f
CMODEL3478 a_20000_6483.t2 vdd.n44 8.78322679165141e-05f
CMODEL3479 a_20000_6483.t2 vdd.t23 8.9870494814752e-06f
CMODEL3480 a_20000_6483.t2 vdd.t22 7.10379697575034e-05f
CMODEL3481 a_20000_6483.t2 vdd.n45 0.000108425274413412f
CMODEL3482 a_20000_6483.t2 vdd.n46 0.0017896718781838f
CMODEL3483 a_20000_6483.t3 vdd 3.69293687896899e-06f
CMODEL3484 a_20000_6483.t3 vdd.n0 0.00123928089666248f
CMODEL3485 a_20000_6483.t3 vdd.n1 0.000114845099951509f
CMODEL3486 a_20000_6483.t3 vdd.t7 9.46741680472847e-06f
CMODEL3487 a_20000_6483.t3 vdd.t6 7.48350245586478e-05f
CMODEL3488 a_20000_6483.t3 vdd.n2 0.000102986222316502f
CMODEL3489 a_20000_6483.t3 vdd.t27 9.46741680472847e-06f
CMODEL3490 a_20000_6483.t3 vdd.t26 7.48350245586478e-05f
CMODEL3491 a_20000_6483.t3 vdd.n3 0.000193163989593219f
CMODEL3492 a_20000_6483.t3 vdd.n4 0.000102986222316502f
CMODEL3493 a_20000_6483.t3 vdd.t36 9.46741680472847e-06f
CMODEL3494 a_20000_6483.t3 vdd.t35 7.48350245586478e-05f
CMODEL3495 a_20000_6483.t3 vdd.n5 0.000146945152202874f
CMODEL3496 a_20000_6483.t3 vdd.t3 1.5081023575821e-05f
CMODEL3497 a_20000_6483.t3 vdd.n6 0.000144288069857451f
CMODEL3498 a_20000_6483.t3 vdd.t2 0.00018909945142318f
CMODEL3499 a_20000_6483.t3 vdd.n7 0.000193424147786309f
CMODEL3500 a_20000_6483.t3 vdd.t25 1.5081023575821e-05f
CMODEL3501 a_20000_6483.t3 vdd.n8 8.71512602971066e-05f
CMODEL3502 a_20000_6483.t3 vdd.t24 0.00018909945142318f
CMODEL3503 a_20000_6483.t3 vdd.n9 0.000193424147786309f
CMODEL3504 a_20000_6483.t3 vdd.t5 1.5081023575821e-05f
CMODEL3505 a_20000_6483.t3 vdd.n10 0.000258063052441384f
CMODEL3506 a_20000_6483.t3 vdd.t4 0.000189203514700416f
CMODEL3507 a_20000_6483.t3 vdd.n11 0.000623953003978692f
CMODEL3508 a_20000_6483.t3 vdd.n12 0.00153843680289637f
CMODEL3509 a_20000_6483.t3 vdd.n13 0.000116611574082588f
CMODEL3510 a_20000_6483.t3 vdd.t42 9.46741680472847e-06f
CMODEL3511 a_20000_6483.t3 vdd.t41 7.48350245586478e-05f
CMODEL3512 a_20000_6483.t3 vdd.n14 0.000104842884621185f
CMODEL3513 a_20000_6483.t3 vdd.t9 9.46741680472847e-06f
CMODEL3514 a_20000_6483.t3 vdd.t8 7.48350245586478e-05f
CMODEL3515 a_20000_6483.t3 vdd.n15 0.000201284393993526f
CMODEL3516 a_20000_6483.t3 vdd.t15 1.59440550216974e-05f
CMODEL3517 a_20000_6483.t3 vdd.n16 0.000125412725754814f
CMODEL3518 a_20000_6483.t3 vdd.t14 0.000215075379809213f
CMODEL3519 a_20000_6483.t3 vdd.n17 0.000175676155853727f
CMODEL3520 a_20000_6483.t3 vdd.t32 0.000215075379809213f
CMODEL3521 a_20000_6483.t3 vdd.n18 0.000173416248349754f
CMODEL3522 a_20000_6483.t3 vdd.t34 1.59440550216974e-05f
CMODEL3523 a_20000_6483.t3 vdd.n19 0.00017463205430546f
CMODEL3524 a_20000_6483.t3 vdd.t33 0.000215075379809213f
CMODEL3525 a_20000_6483.t3 vdd.n20 0.000348503579493121f
CMODEL3526 a_20000_6483.t3 vdd.t48 0.000215486429754295f
CMODEL3527 a_20000_6483.t3 vdd.n21 0.00061863190173603f
CMODEL3528 a_20000_6483.t3 vdd.n22 0.00271107384242903f
CMODEL3529 a_20000_6483.t3 vdd.t47 3.06507109576623e-06f
CMODEL3530 a_20000_6483.t3 vdd.t45 3.03360062634214e-06f
CMODEL3531 a_20000_6483.t3 vdd.n23 3.46402368486933e-05f
CMODEL3532 a_20000_6483.t3 vdd.t46 8.26708158957152e-05f
CMODEL3533 a_20000_6483.t3 vdd.n24 8.88223430907196e-05f
CMODEL3534 a_20000_6483.t3 vdd.t44 8.26708158957152e-05f
CMODEL3535 a_20000_6483.t3 vdd.n25 0.00014008131187519f
CMODEL3536 a_20000_6483.t3 vdd.t43 8.28498914519586e-05f
CMODEL3537 a_20000_6483.t3 vdd.n26 0.000749514019903566f
CMODEL3538 a_20000_6483.t3 vdd.n27 0.000501065547084802f
CMODEL3539 a_20000_6483.t3 vdd.n28 0.000113181821903688f
CMODEL3540 a_20000_6483.t3 vdd.t29 9.46741680472847e-06f
CMODEL3541 a_20000_6483.t3 vdd.t28 7.48350245586478e-05f
CMODEL3542 a_20000_6483.t3 vdd.n29 1.68951933756334e-05f
CMODEL3543 a_20000_6483.t3 vdd.n30 5.38994010055355e-06f
CMODEL3544 a_20000_6483.t3 vdd.t38 2.48164900388296e-06f
CMODEL3545 a_20000_6483.t3 vdd.t40 2.48164900388296e-06f
CMODEL3546 a_20000_6483.t3 vdd.t37 5.01467057896138e-05f
CMODEL3547 a_20000_6483.t3 vdd.t39 5.01467057896138e-05f
CMODEL3548 a_20000_6483.t3 vdd.n31 1.62413291170012e-05f
CMODEL3549 a_20000_6483.t3 vdd.n32 0.00019599884670392f
CMODEL3550 a_20000_6483.t3 vdd.n33 9.93127886300746e-05f
CMODEL3551 a_20000_6483.t3 vdd.t17 9.46741680472847e-06f
CMODEL3552 a_20000_6483.t3 vdd.t16 7.48350245586478e-05f
CMODEL3553 a_20000_6483.t3 vdd.n34 1.68951933756334e-05f
CMODEL3554 a_20000_6483.t3 vdd.n35 5.38994010055355e-06f
CMODEL3555 a_20000_6483.t3 vdd.t1 2.48164900388296e-06f
CMODEL3556 a_20000_6483.t3 vdd.t31 2.48164900388296e-06f
CMODEL3557 a_20000_6483.t3 vdd.t0 5.01467057896138e-05f
CMODEL3558 a_20000_6483.t3 vdd.t30 5.01467057896138e-05f
CMODEL3559 a_20000_6483.t3 vdd.n36 1.62413291170012e-05f
CMODEL3560 a_20000_6483.t3 vdd.n37 0.000190080247811128f
CMODEL3561 a_20000_6483.t3 vdd.n38 0.000109647139253576f
CMODEL3562 a_20000_6483.t3 vdd.t19 9.46741680472847e-06f
CMODEL3563 a_20000_6483.t3 vdd.t18 7.48350245586478e-05f
CMODEL3564 a_20000_6483.t3 vdd.n39 9.25269957603174e-05f
CMODEL3565 a_20000_6483.t3 vdd.t21 9.46750352412617e-06f
CMODEL3566 a_20000_6483.t3 vdd.t20 7.48350245586478e-05f
CMODEL3567 a_20000_6483.t3 vdd.n40 9.25269957603174e-05f
CMODEL3568 a_20000_6483.t3 vdd.t11 9.46741680472847e-06f
CMODEL3569 a_20000_6483.t3 vdd.t10 7.48350245586478e-05f
CMODEL3570 a_20000_6483.t3 vdd.n41 0.0003980680512466f
CMODEL3571 a_20000_6483.t3 vdd.n42 0.000762498515320675f
CMODEL3572 a_20000_6483.t3 vdd.n43 9.25269957603174e-05f
CMODEL3573 a_20000_6483.t3 vdd.t13 9.46741680472847e-06f
CMODEL3574 a_20000_6483.t3 vdd.t12 7.48350245586478e-05f
CMODEL3575 a_20000_6483.t3 vdd.n44 9.25269957603174e-05f
CMODEL3576 a_20000_6483.t3 vdd.t23 9.46741680472847e-06f
CMODEL3577 a_20000_6483.t3 vdd.t22 7.48350245586478e-05f
CMODEL3578 a_20000_6483.t3 vdd.n45 0.000114220720288093f
CMODEL3579 a_20000_6483.t3 vdd.n46 0.00188533173756222f
CMODEL3580 a_20000_6483.t4 vdd 3.61222266361152e-06f
CMODEL3581 a_20000_6483.t4 vdd.n0 0.00121219470795689f
CMODEL3582 a_20000_6483.t4 vdd.n1 0.00011233500231539f
CMODEL3583 a_20000_6483.t4 vdd.t7 9.26049338743218e-06f
CMODEL3584 a_20000_6483.t4 vdd.t6 7.31994021566223e-05f
CMODEL3585 a_20000_6483.t4 vdd.n2 0.00010073531676373f
CMODEL3586 a_20000_6483.t4 vdd.t27 9.26049338743218e-06f
CMODEL3587 a_20000_6483.t4 vdd.t26 7.31994021566223e-05f
CMODEL3588 a_20000_6483.t4 vdd.n3 0.000188942124891408f
CMODEL3589 a_20000_6483.t4 vdd.n4 0.00010073531676373f
CMODEL3590 a_20000_6483.t4 vdd.t36 9.26049338743218e-06f
CMODEL3591 a_20000_6483.t4 vdd.t35 7.31994021566223e-05f
CMODEL3592 a_20000_6483.t4 vdd.n5 0.000143733463769155f
CMODEL3593 a_20000_6483.t4 vdd.t3 1.47514070606723e-05f
CMODEL3594 a_20000_6483.t4 vdd.n6 0.000141134455613375f
CMODEL3595 a_20000_6483.t4 vdd.t2 0.000184966422794104f
CMODEL3596 a_20000_6483.t4 vdd.n7 0.000189196596969324f
CMODEL3597 a_20000_6483.t4 vdd.t25 1.47514070606723e-05f
CMODEL3598 a_20000_6483.t4 vdd.n8 8.52464496212579e-05f
CMODEL3599 a_20000_6483.t4 vdd.t24 0.000184966422794104f
CMODEL3600 a_20000_6483.t4 vdd.n9 0.000189196596969324f
CMODEL3601 a_20000_6483.t4 vdd.t5 1.47514070606723e-05f
CMODEL3602 a_20000_6483.t4 vdd.n10 0.000252422729448272f
CMODEL3603 a_20000_6483.t4 vdd.t4 0.000185068211625271f
CMODEL3604 a_20000_6483.t4 vdd.n11 0.000610315652790026f
CMODEL3605 a_20000_6483.t4 vdd.n12 0.00150481215035221f
CMODEL3606 a_20000_6483.t4 vdd.n13 0.000114062867724438f
CMODEL3607 a_20000_6483.t4 vdd.t42 9.26049338743218e-06f
CMODEL3608 a_20000_6483.t4 vdd.t41 7.31994021566223e-05f
CMODEL3609 a_20000_6483.t4 vdd.n14 0.000102551399159789f
CMODEL3610 a_20000_6483.t4 vdd.t9 9.26049338743218e-06f
CMODEL3611 a_20000_6483.t4 vdd.t8 7.31994021566223e-05f
CMODEL3612 a_20000_6483.t4 vdd.n15 0.000196885046683418f
CMODEL3613 a_20000_6483.t4 vdd.t15 1.55955757671449e-05f
CMODEL3614 a_20000_6483.t4 vdd.n16 0.000122671658120328f
CMODEL3615 a_20000_6483.t4 vdd.t14 0.000210374611533732f
CMODEL3616 a_20000_6483.t4 vdd.n17 0.000171836511813911f
CMODEL3617 a_20000_6483.t4 vdd.t32 0.000210374611533732f
CMODEL3618 a_20000_6483.t4 vdd.n18 0.000169625997697083f
CMODEL3619 a_20000_6483.t4 vdd.t34 1.55955757671449e-05f
CMODEL3620 a_20000_6483.t4 vdd.n19 0.000170815230541209f
CMODEL3621 a_20000_6483.t4 vdd.t33 0.000210374611533732f
CMODEL3622 a_20000_6483.t4 vdd.n20 0.000340886554374645f
CMODEL3623 a_20000_6483.t4 vdd.t48 0.000210776677416839f
CMODEL3624 a_20000_6483.t4 vdd.n21 0.000605110850556389f
CMODEL3625 a_20000_6483.t4 vdd.n22 0.00265181959434968f
CMODEL3626 a_20000_6483.t4 vdd.t47 2.99807975076964e-06f
CMODEL3627 a_20000_6483.t4 vdd.t45 2.96729711174443e-06f
CMODEL3628 a_20000_6483.t4 vdd.n23 3.38831268225345e-05f
CMODEL3629 a_20000_6483.t4 vdd.t46 8.08639314953928e-05f
CMODEL3630 a_20000_6483.t4 vdd.n24 8.68810086017368e-05f
CMODEL3631 a_20000_6483.t4 vdd.t44 8.08639314953928e-05f
CMODEL3632 a_20000_6483.t4 vdd.n25 0.000137019642113478f
CMODEL3633 a_20000_6483.t4 vdd.t43 8.10390931090248e-05f
CMODEL3634 a_20000_6483.t4 vdd.n26 0.000733132359994766f
CMODEL3635 a_20000_6483.t4 vdd.n27 0.000490114070306001f
CMODEL3636 a_20000_6483.t4 vdd.n28 0.000110708077497249f
CMODEL3637 a_20000_6483.t4 vdd.t29 9.26049338743218e-06f
CMODEL3638 a_20000_6483.t4 vdd.t28 7.31994021566223e-05f
CMODEL3639 a_20000_6483.t4 vdd.n29 1.65259256840049e-05f
CMODEL3640 a_20000_6483.t4 vdd.n30 5.27213554545338e-06f
CMODEL3641 a_20000_6483.t4 vdd.t38 2.42740915123837e-06f
CMODEL3642 a_20000_6483.t4 vdd.t40 2.42740915123837e-06f
CMODEL3643 a_20000_6483.t4 vdd.t37 4.90506805546251e-05f
CMODEL3644 a_20000_6483.t4 vdd.t39 4.90506805546251e-05f
CMODEL3645 a_20000_6483.t4 vdd.n31 1.58863525281766e-05f
CMODEL3646 a_20000_6483.t4 vdd.n32 0.00019171502230043f
CMODEL3647 a_20000_6483.t4 vdd.n33 9.71421710235597e-05f
CMODEL3648 a_20000_6483.t4 vdd.t17 9.26049338743218e-06f
CMODEL3649 a_20000_6483.t4 vdd.t16 7.31994021566223e-05f
CMODEL3650 a_20000_6483.t4 vdd.n34 1.65259256840049e-05f
CMODEL3651 a_20000_6483.t4 vdd.n35 5.27213554545338e-06f
CMODEL3652 a_20000_6483.t4 vdd.t1 2.42740915123837e-06f
CMODEL3653 a_20000_6483.t4 vdd.t31 2.42740915123837e-06f
CMODEL3654 a_20000_6483.t4 vdd.t0 4.90506805546251e-05f
CMODEL3655 a_20000_6483.t4 vdd.t30 4.90506805546251e-05f
CMODEL3656 a_20000_6483.t4 vdd.n36 1.58863525281766e-05f
CMODEL3657 a_20000_6483.t4 vdd.n37 0.000185925782527847f
CMODEL3658 a_20000_6483.t4 vdd.n38 0.000107250650198633f
CMODEL3659 a_20000_6483.t4 vdd.t19 9.26049338743218e-06f
CMODEL3660 a_20000_6483.t4 vdd.t18 7.31994021566223e-05f
CMODEL3661 a_20000_6483.t4 vdd.n39 9.05046909912571e-05f
CMODEL3662 a_20000_6483.t4 vdd.t21 9.26057821145815e-06f
CMODEL3663 a_20000_6483.t4 vdd.t20 7.31994021566223e-05f
CMODEL3664 a_20000_6483.t4 vdd.n40 9.05046909912571e-05f
CMODEL3665 a_20000_6483.t4 vdd.t11 9.26049338743218e-06f
CMODEL3666 a_20000_6483.t4 vdd.t10 7.31994021566223e-05f
CMODEL3667 a_20000_6483.t4 vdd.n41 0.000389367726418894f
CMODEL3668 a_20000_6483.t4 vdd.n42 0.000745833061403541f
CMODEL3669 a_20000_6483.t4 vdd.n43 9.05046909912571e-05f
CMODEL3670 a_20000_6483.t4 vdd.t13 9.26049338743218e-06f
CMODEL3671 a_20000_6483.t4 vdd.t12 7.31994021566223e-05f
CMODEL3672 a_20000_6483.t4 vdd.n44 9.05046909912571e-05f
CMODEL3673 a_20000_6483.t4 vdd.t23 9.26049338743218e-06f
CMODEL3674 a_20000_6483.t4 vdd.t22 7.31994021566223e-05f
CMODEL3675 a_20000_6483.t4 vdd.n45 0.000111724269328392f
CMODEL3676 a_20000_6483.t4 vdd.n46 0.00184412521904508f
CMODEL3677 a_20000_6483.n1 vdd 9.2059331625374e-05f
CMODEL3678 a_20000_6483.n1 vdd.n0 0.0308933986098061f
CMODEL3679 a_20000_6483.n1 vdd.n1 0.00286291466344718f
CMODEL3680 a_20000_6483.n1 vdd.t7 0.000236008383524136f
CMODEL3681 a_20000_6483.n1 vdd.t6 0.00186552399047799f
CMODEL3682 a_20000_6483.n1 vdd.n2 0.00256729077799083f
CMODEL3683 a_20000_6483.n1 vdd.t27 0.000236008383524136f
CMODEL3684 a_20000_6483.n1 vdd.t26 0.00186552399047799f
CMODEL3685 a_20000_6483.n1 vdd.n3 0.00481528614185441f
CMODEL3686 a_20000_6483.n1 vdd.n4 0.00256729077799083f
CMODEL3687 a_20000_6483.n1 vdd.t36 0.000236008383524136f
CMODEL3688 a_20000_6483.n1 vdd.t35 0.00186552399047799f
CMODEL3689 a_20000_6483.n1 vdd.n5 0.00366312042169595f
CMODEL3690 a_20000_6483.n1 vdd.t3 0.00037594711096286f
CMODEL3691 a_20000_6483.n1 vdd.n6 0.00359688337708621f
CMODEL3692 a_20000_6483.n1 vdd.t2 0.00471396335200915f
CMODEL3693 a_20000_6483.n1 vdd.n7 0.0048217714921752f
CMODEL3694 a_20000_6483.n1 vdd.t25 0.00037594711096286f
CMODEL3695 a_20000_6483.n1 vdd.n8 0.0021725491217983f
CMODEL3696 a_20000_6483.n1 vdd.t24 0.00471396335200915f
CMODEL3697 a_20000_6483.n1 vdd.n9 0.0048217714921752f
CMODEL3698 a_20000_6483.n1 vdd.t5 0.00037594711096286f
CMODEL3699 a_20000_6483.n1 vdd.n10 0.00643312163288051f
CMODEL3700 a_20000_6483.n1 vdd.t4 0.00471655749213747f
CMODEL3701 a_20000_6483.n1 vdd.n11 0.0155542047953875f
CMODEL3702 a_20000_6483.n1 vdd.n12 0.038350902943691f
CMODEL3703 a_20000_6483.n1 vdd.n13 0.00290695019212539f
CMODEL3704 a_20000_6483.n1 vdd.t42 0.000236008383524136f
CMODEL3705 a_20000_6483.n1 vdd.t41 0.00186552399047799f
CMODEL3706 a_20000_6483.n1 vdd.n14 0.00261357456144692f
CMODEL3707 a_20000_6483.n1 vdd.t9 0.000236008383524136f
CMODEL3708 a_20000_6483.n1 vdd.t8 0.00186552399047799f
CMODEL3709 a_20000_6483.n1 vdd.n15 0.00501771554320089f
CMODEL3710 a_20000_6483.n1 vdd.t15 0.000397461179760385f
CMODEL3711 a_20000_6483.n1 vdd.n16 0.00312634959347796f
CMODEL3712 a_20000_6483.n1 vdd.t14 0.00536150396370636f
CMODEL3713 a_20000_6483.n1 vdd.n17 0.00437934089329041f
CMODEL3714 a_20000_6483.n1 vdd.t32 0.00536150396370636f
CMODEL3715 a_20000_6483.n1 vdd.n18 0.00432300481683708f
CMODEL3716 a_20000_6483.n1 vdd.t34 0.000397461179760385f
CMODEL3717 a_20000_6483.n1 vdd.n19 0.00435331302066961f
CMODEL3718 a_20000_6483.n1 vdd.t33 0.00536150396370636f
CMODEL3719 a_20000_6483.n1 vdd.n20 0.00868766720056809f
CMODEL3720 a_20000_6483.n1 vdd.t48 0.00537175081721322f
CMODEL3721 a_20000_6483.n1 vdd.n21 0.0154215577634928f
CMODEL3722 a_20000_6483.n1 vdd.n22 0.0675829709796528f
CMODEL3723 a_20000_6483.n1 vdd.t47 7.64075871611618e-05f
CMODEL3724 a_20000_6483.n1 vdd.t45 7.56230759506893e-05f
CMODEL3725 a_20000_6483.n1 vdd.n23 0.000863528718781045f
CMODEL3726 a_20000_6483.n1 vdd.t46 0.00206085841857353f
CMODEL3727 a_20000_6483.n1 vdd.n24 0.00221420668869222f
CMODEL3728 a_20000_6483.n1 vdd.t44 0.00206085841857353f
CMODEL3729 a_20000_6483.n1 vdd.n25 0.00349201526239892f
CMODEL3730 a_20000_6483.n1 vdd.t43 0.00206532250137768f
CMODEL3731 a_20000_6483.n1 vdd.n26 0.0186842510385483f
CMODEL3732 a_20000_6483.n1 vdd.n27 0.0124908063356901f
CMODEL3733 a_20000_6483.n1 vdd.n28 0.00282145165706288f
CMODEL3734 a_20000_6483.n1 vdd.t29 0.000236008383524136f
CMODEL3735 a_20000_6483.n1 vdd.t28 0.00186552399047799f
CMODEL3736 a_20000_6483.n1 vdd.n29 0.00042117162053322f
CMODEL3737 a_20000_6483.n1 vdd.n30 0.000134363055589591f
CMODEL3738 a_20000_6483.n1 vdd.t38 6.18637567100857e-05f
CMODEL3739 a_20000_6483.n1 vdd.t40 6.18637567100857e-05f
CMODEL3740 a_20000_6483.n1 vdd.t37 0.00125008153930185f
CMODEL3741 a_20000_6483.n1 vdd.t39 0.00125008153930185f
CMODEL3742 a_20000_6483.n1 vdd.n31 0.000404871773393616f
CMODEL3743 a_20000_6483.n1 vdd.n32 0.00488595484251669f
CMODEL3744 a_20000_6483.n1 vdd.n33 0.00247571763146117f
CMODEL3745 a_20000_6483.n1 vdd.t17 0.000236008383524136f
CMODEL3746 a_20000_6483.n1 vdd.t16 0.00186552399047799f
CMODEL3747 a_20000_6483.n1 vdd.n34 0.00042117162053322f
CMODEL3748 a_20000_6483.n1 vdd.n35 0.000134363055589591f
CMODEL3749 a_20000_6483.n1 vdd.t1 6.18637567100857e-05f
CMODEL3750 a_20000_6483.n1 vdd.t31 6.18637567100857e-05f
CMODEL3751 a_20000_6483.n1 vdd.t0 0.00125008153930185f
CMODEL3752 a_20000_6483.n1 vdd.t30 0.00125008153930185f
CMODEL3753 a_20000_6483.n1 vdd.n36 0.000404871773393616f
CMODEL3754 a_20000_6483.n1 vdd.n37 0.00473841312271855f
CMODEL3755 a_20000_6483.n1 vdd.n38 0.00273333736403764f
CMODEL3756 a_20000_6483.n1 vdd.t19 0.000236008383524136f
CMODEL3757 a_20000_6483.n1 vdd.t18 0.00186552399047799f
CMODEL3758 a_20000_6483.n1 vdd.n39 0.00230655807726037f
CMODEL3759 a_20000_6483.n1 vdd.t21 0.000236010545307576f
CMODEL3760 a_20000_6483.n1 vdd.t20 0.00186552399047799f
CMODEL3761 a_20000_6483.n1 vdd.n40 0.00230655807726037f
CMODEL3762 a_20000_6483.n1 vdd.t11 0.000236008383524136f
CMODEL3763 a_20000_6483.n1 vdd.t10 0.00186552399047799f
CMODEL3764 a_20000_6483.n1 vdd.n41 0.00992323452585199f
CMODEL3765 a_20000_6483.n1 vdd.n42 0.0190079348730593f
CMODEL3766 a_20000_6483.n1 vdd.n43 0.00230655807726037f
CMODEL3767 a_20000_6483.n1 vdd.t13 0.000236008383524136f
CMODEL3768 a_20000_6483.n1 vdd.t12 0.00186552399047799f
CMODEL3769 a_20000_6483.n1 vdd.n44 0.00230655807726037f
CMODEL3770 a_20000_6483.n1 vdd.t23 0.000236008383524136f
CMODEL3771 a_20000_6483.n1 vdd.t22 0.00186552399047799f
CMODEL3772 a_20000_6483.n1 vdd.n45 0.00284734982267726f
CMODEL3773 a_20000_6483.n1 vdd.n46 0.0469984690614421f
CMODEL3774 a_9600_83.t0 vdd 5.81236475452374e-08f
CMODEL3775 a_9600_83.t0 vdd.n0 1.95052145238036e-05f
CMODEL3776 a_9600_83.t0 vdd.n1 1.80756301303007e-06f
CMODEL3777 a_9600_83.t0 vdd.t7 1.49008990826706e-07f
CMODEL3778 a_9600_83.t0 vdd.t6 1.17783886755746e-06f
CMODEL3779 a_9600_83.t0 vdd.n2 1.62091448733643e-06f
CMODEL3780 a_9600_83.t0 vdd.t27 1.49008990826706e-07f
CMODEL3781 a_9600_83.t0 vdd.t26 1.17783886755746e-06f
CMODEL3782 a_9600_83.t0 vdd.n3 3.04023491803701e-06f
CMODEL3783 a_9600_83.t0 vdd.n4 1.62091448733643e-06f
CMODEL3784 a_9600_83.t0 vdd.t36 1.49008990826706e-07f
CMODEL3785 a_9600_83.t0 vdd.t35 1.17783886755746e-06f
CMODEL3786 a_9600_83.t0 vdd.n5 2.31279020330984e-06f
CMODEL3787 a_9600_83.t0 vdd.t3 2.37362329135493e-07f
CMODEL3788 a_9600_83.t0 vdd.n6 2.2709700144451e-06f
CMODEL3789 a_9600_83.t0 vdd.t2 2.97626258604973e-06f
CMODEL3790 a_9600_83.t0 vdd.n7 3.04432958404858e-06f
CMODEL3791 a_9600_83.t0 vdd.t25 2.37362329135493e-07f
CMODEL3792 a_9600_83.t0 vdd.n8 1.37168581609943e-06f
CMODEL3793 a_9600_83.t0 vdd.t24 2.97626258604973e-06f
CMODEL3794 a_9600_83.t0 vdd.n9 3.04432958404858e-06f
CMODEL3795 a_9600_83.t0 vdd.t5 2.37362329135493e-07f
CMODEL3796 a_9600_83.t0 vdd.n10 4.06169030128095e-06f
CMODEL3797 a_9600_83.t0 vdd.t4 2.97790045245436e-06f
CMODEL3798 a_9600_83.t0 vdd.n11 9.82048317548677e-06f
CMODEL3799 a_9600_83.t0 vdd.n12 2.42136709704973e-05f
CMODEL3800 a_9600_83.t0 vdd.n13 1.83536579524857e-06f
CMODEL3801 a_9600_83.t0 vdd.t42 1.49008990826706e-07f
CMODEL3802 a_9600_83.t0 vdd.t41 1.17783886755746e-06f
CMODEL3803 a_9600_83.t0 vdd.n14 1.65013675377227e-06f
CMODEL3804 a_9600_83.t0 vdd.t9 1.49008990826706e-07f
CMODEL3805 a_9600_83.t0 vdd.t8 1.17783886755746e-06f
CMODEL3806 a_9600_83.t0 vdd.n15 3.16804309314453e-06f
CMODEL3807 a_9600_83.t0 vdd.t15 2.5094570118451e-07f
CMODEL3808 a_9600_83.t0 vdd.n16 1.97388834641967e-06f
CMODEL3809 a_9600_83.t0 vdd.t14 3.38510133841736e-06f
CMODEL3810 a_9600_83.t0 vdd.n17 2.7649914687399e-06f
CMODEL3811 a_9600_83.t0 vdd.t32 3.38510133841736e-06f
CMODEL3812 a_9600_83.t0 vdd.n18 2.72942246998615e-06f
CMODEL3813 a_9600_83.t0 vdd.t34 2.5094570118451e-07f
CMODEL3814 a_9600_83.t0 vdd.n19 2.74855820914684e-06f
CMODEL3815 a_9600_83.t0 vdd.t33 3.38510133841736e-06f
CMODEL3816 a_9600_83.t0 vdd.n20 5.48514634465322e-06f
CMODEL3817 a_9600_83.t0 vdd.t48 3.39157091071563e-06f
CMODEL3818 a_9600_83.t0 vdd.n21 9.73673360666365e-06f
CMODEL3819 a_9600_83.t0 vdd.n22 4.26699685510061e-05f
CMODEL3820 a_9600_83.t0 vdd.t47 4.82415805929367e-08f
CMODEL3821 a_9600_83.t0 vdd.t45 4.77462624944049e-08f
CMODEL3822 a_9600_83.t0 vdd.n23 5.45207509216651e-07f
CMODEL3823 a_9600_83.t0 vdd.t46 1.30116747804833e-06f
CMODEL3824 a_9600_83.t0 vdd.n24 1.39798722078036e-06f
CMODEL3825 a_9600_83.t0 vdd.t44 1.30116747804833e-06f
CMODEL3826 a_9600_83.t0 vdd.n25 2.20475926503816e-06f
CMODEL3827 a_9600_83.t0 vdd.t43 1.30398597315296e-06f
CMODEL3828 a_9600_83.t0 vdd.n26 1.1796705481533e-05f
CMODEL3829 a_9600_83.t0 vdd.n27 7.88634038715265e-06f
CMODEL3830 a_9600_83.t0 vdd.n28 1.78138444832949e-06f
CMODEL3831 a_9600_83.t0 vdd.t29 1.49008990826706e-07f
CMODEL3832 a_9600_83.t0 vdd.t28 1.17783886755746e-06f
CMODEL3833 a_9600_83.t0 vdd.n29 2.65915800122776e-07f
CMODEL3834 a_9600_83.t0 vdd.n30 8.48330174497809e-08f
CMODEL3835 a_9600_83.t0 vdd.t38 3.90590190842777e-08f
CMODEL3836 a_9600_83.t0 vdd.t40 3.90590190842777e-08f
CMODEL3837 a_9600_83.t0 vdd.t37 7.89265982169716e-07f
CMODEL3838 a_9600_83.t0 vdd.t39 7.89265982169716e-07f
CMODEL3839 a_9600_83.t0 vdd.n31 2.55624539547054e-07f
CMODEL3840 a_9600_83.t0 vdd.n32 3.08485312867632e-06f
CMODEL3841 a_9600_83.t0 vdd.n33 1.56309780325319e-06f
CMODEL3842 a_9600_83.t0 vdd.t17 1.49008990826706e-07f
CMODEL3843 a_9600_83.t0 vdd.t16 1.17783886755746e-06f
CMODEL3844 a_9600_83.t0 vdd.n34 2.65915800122776e-07f
CMODEL3845 a_9600_83.t0 vdd.n35 8.48330174497809e-08f
CMODEL3846 a_9600_83.t0 vdd.t1 3.90590190842777e-08f
CMODEL3847 a_9600_83.t0 vdd.t31 3.90590190842777e-08f
CMODEL3848 a_9600_83.t0 vdd.t0 7.89265982169716e-07f
CMODEL3849 a_9600_83.t0 vdd.t30 7.89265982169716e-07f
CMODEL3850 a_9600_83.t0 vdd.n36 2.55624539547054e-07f
CMODEL3851 a_9600_83.t0 vdd.n37 2.99169947691331e-06f
CMODEL3852 a_9600_83.t0 vdd.n38 1.72575158611909e-06f
CMODEL3853 a_9600_83.t0 vdd.t19 1.49008990826706e-07f
CMODEL3854 a_9600_83.t0 vdd.t18 1.17783886755746e-06f
CMODEL3855 a_9600_83.t0 vdd.n39 1.45629526478498e-06f
CMODEL3856 a_9600_83.t0 vdd.t21 1.49010355715377e-07f
CMODEL3857 a_9600_83.t0 vdd.t20 1.17783886755746e-06f
CMODEL3858 a_9600_83.t0 vdd.n40 1.45629526478498e-06f
CMODEL3859 a_9600_83.t0 vdd.t11 1.49008990826706e-07f
CMODEL3860 a_9600_83.t0 vdd.t10 1.17783886755746e-06f
CMODEL3861 a_9600_83.t0 vdd.n41 6.26524846428906e-06f
CMODEL3862 a_9600_83.t0 vdd.n42 1.200107026217e-05f
CMODEL3863 a_9600_83.t0 vdd.n43 1.45629526478498e-06f
CMODEL3864 a_9600_83.t0 vdd.t13 1.49008990826706e-07f
CMODEL3865 a_9600_83.t0 vdd.t12 1.17783886755746e-06f
CMODEL3866 a_9600_83.t0 vdd.n44 1.45629526478498e-06f
CMODEL3867 a_9600_83.t0 vdd.t23 1.49008990826706e-07f
CMODEL3868 a_9600_83.t0 vdd.t22 1.17783886755746e-06f
CMODEL3869 a_9600_83.t0 vdd.n45 1.79773581460232e-06f
CMODEL3870 a_9600_83.t0 vdd.n46 2.96734986303123e-05f
CMODEL3871 a_9600_83.t1 vdd 5.81236475452374e-08f
CMODEL3872 a_9600_83.t1 vdd.n0 1.95052145238036e-05f
CMODEL3873 a_9600_83.t1 vdd.n1 1.80756301303007e-06f
CMODEL3874 a_9600_83.t1 vdd.t7 1.49008990826706e-07f
CMODEL3875 a_9600_83.t1 vdd.t6 1.17783886755746e-06f
CMODEL3876 a_9600_83.t1 vdd.n2 1.62091448733643e-06f
CMODEL3877 a_9600_83.t1 vdd.t27 1.49008990826706e-07f
CMODEL3878 a_9600_83.t1 vdd.t26 1.17783886755746e-06f
CMODEL3879 a_9600_83.t1 vdd.n3 3.04023491803701e-06f
CMODEL3880 a_9600_83.t1 vdd.n4 1.62091448733643e-06f
CMODEL3881 a_9600_83.t1 vdd.t36 1.49008990826706e-07f
CMODEL3882 a_9600_83.t1 vdd.t35 1.17783886755746e-06f
CMODEL3883 a_9600_83.t1 vdd.n5 2.31279020330984e-06f
CMODEL3884 a_9600_83.t1 vdd.t3 2.37362329135493e-07f
CMODEL3885 a_9600_83.t1 vdd.n6 2.2709700144451e-06f
CMODEL3886 a_9600_83.t1 vdd.t2 2.97626258604973e-06f
CMODEL3887 a_9600_83.t1 vdd.n7 3.04432958404858e-06f
CMODEL3888 a_9600_83.t1 vdd.t25 2.37362329135493e-07f
CMODEL3889 a_9600_83.t1 vdd.n8 1.37168581609943e-06f
CMODEL3890 a_9600_83.t1 vdd.t24 2.97626258604973e-06f
CMODEL3891 a_9600_83.t1 vdd.n9 3.04432958404858e-06f
CMODEL3892 a_9600_83.t1 vdd.t5 2.37362329135493e-07f
CMODEL3893 a_9600_83.t1 vdd.n10 4.06169030128095e-06f
CMODEL3894 a_9600_83.t1 vdd.t4 2.97790045245436e-06f
CMODEL3895 a_9600_83.t1 vdd.n11 9.82048317548677e-06f
CMODEL3896 a_9600_83.t1 vdd.n12 2.42136709704973e-05f
CMODEL3897 a_9600_83.t1 vdd.n13 1.83536579524857e-06f
CMODEL3898 a_9600_83.t1 vdd.t42 1.49008990826706e-07f
CMODEL3899 a_9600_83.t1 vdd.t41 1.17783886755746e-06f
CMODEL3900 a_9600_83.t1 vdd.n14 1.65013675377227e-06f
CMODEL3901 a_9600_83.t1 vdd.t9 1.49008990826706e-07f
CMODEL3902 a_9600_83.t1 vdd.t8 1.17783886755746e-06f
CMODEL3903 a_9600_83.t1 vdd.n15 3.16804309314453e-06f
CMODEL3904 a_9600_83.t1 vdd.t15 2.5094570118451e-07f
CMODEL3905 a_9600_83.t1 vdd.n16 1.97388834641967e-06f
CMODEL3906 a_9600_83.t1 vdd.t14 3.38510133841736e-06f
CMODEL3907 a_9600_83.t1 vdd.n17 2.7649914687399e-06f
CMODEL3908 a_9600_83.t1 vdd.t32 3.38510133841736e-06f
CMODEL3909 a_9600_83.t1 vdd.n18 2.72942246998615e-06f
CMODEL3910 a_9600_83.t1 vdd.t34 2.5094570118451e-07f
CMODEL3911 a_9600_83.t1 vdd.n19 2.74855820914684e-06f
CMODEL3912 a_9600_83.t1 vdd.t33 3.38510133841736e-06f
CMODEL3913 a_9600_83.t1 vdd.n20 5.48514634465322e-06f
CMODEL3914 a_9600_83.t1 vdd.t48 3.39157091071563e-06f
CMODEL3915 a_9600_83.t1 vdd.n21 9.73673360666365e-06f
CMODEL3916 a_9600_83.t1 vdd.n22 4.26699685510061e-05f
CMODEL3917 a_9600_83.t1 vdd.t47 4.82415805929367e-08f
CMODEL3918 a_9600_83.t1 vdd.t45 4.77462624944049e-08f
CMODEL3919 a_9600_83.t1 vdd.n23 5.45207509216651e-07f
CMODEL3920 a_9600_83.t1 vdd.t46 1.30116747804833e-06f
CMODEL3921 a_9600_83.t1 vdd.n24 1.39798722078036e-06f
CMODEL3922 a_9600_83.t1 vdd.t44 1.30116747804833e-06f
CMODEL3923 a_9600_83.t1 vdd.n25 2.20475926503816e-06f
CMODEL3924 a_9600_83.t1 vdd.t43 1.30398597315296e-06f
CMODEL3925 a_9600_83.t1 vdd.n26 1.1796705481533e-05f
CMODEL3926 a_9600_83.t1 vdd.n27 7.88634038715265e-06f
CMODEL3927 a_9600_83.t1 vdd.n28 1.78138444832949e-06f
CMODEL3928 a_9600_83.t1 vdd.t29 1.49008990826706e-07f
CMODEL3929 a_9600_83.t1 vdd.t28 1.17783886755746e-06f
CMODEL3930 a_9600_83.t1 vdd.n29 2.65915800122776e-07f
CMODEL3931 a_9600_83.t1 vdd.n30 8.48330174497809e-08f
CMODEL3932 a_9600_83.t1 vdd.t38 3.90590190842777e-08f
CMODEL3933 a_9600_83.t1 vdd.t40 3.90590190842777e-08f
CMODEL3934 a_9600_83.t1 vdd.t37 7.89265982169716e-07f
CMODEL3935 a_9600_83.t1 vdd.t39 7.89265982169716e-07f
CMODEL3936 a_9600_83.t1 vdd.n31 2.55624539547054e-07f
CMODEL3937 a_9600_83.t1 vdd.n32 3.08485312867632e-06f
CMODEL3938 a_9600_83.t1 vdd.n33 1.56309780325319e-06f
CMODEL3939 a_9600_83.t1 vdd.t17 1.49008990826706e-07f
CMODEL3940 a_9600_83.t1 vdd.t16 1.17783886755746e-06f
CMODEL3941 a_9600_83.t1 vdd.n34 2.65915800122776e-07f
CMODEL3942 a_9600_83.t1 vdd.n35 8.48330174497809e-08f
CMODEL3943 a_9600_83.t1 vdd.t1 3.90590190842777e-08f
CMODEL3944 a_9600_83.t1 vdd.t31 3.90590190842777e-08f
CMODEL3945 a_9600_83.t1 vdd.t0 7.89265982169716e-07f
CMODEL3946 a_9600_83.t1 vdd.t30 7.89265982169716e-07f
CMODEL3947 a_9600_83.t1 vdd.n36 2.55624539547054e-07f
CMODEL3948 a_9600_83.t1 vdd.n37 2.99169947691331e-06f
CMODEL3949 a_9600_83.t1 vdd.n38 1.72575158611909e-06f
CMODEL3950 a_9600_83.t1 vdd.t19 1.49008990826706e-07f
CMODEL3951 a_9600_83.t1 vdd.t18 1.17783886755746e-06f
CMODEL3952 a_9600_83.t1 vdd.n39 1.45629526478498e-06f
CMODEL3953 a_9600_83.t1 vdd.t21 1.49010355715377e-07f
CMODEL3954 a_9600_83.t1 vdd.t20 1.17783886755746e-06f
CMODEL3955 a_9600_83.t1 vdd.n40 1.45629526478498e-06f
CMODEL3956 a_9600_83.t1 vdd.t11 1.49008990826706e-07f
CMODEL3957 a_9600_83.t1 vdd.t10 1.17783886755746e-06f
CMODEL3958 a_9600_83.t1 vdd.n41 6.26524846428906e-06f
CMODEL3959 a_9600_83.t1 vdd.n42 1.200107026217e-05f
CMODEL3960 a_9600_83.t1 vdd.n43 1.45629526478498e-06f
CMODEL3961 a_9600_83.t1 vdd.t13 1.49008990826706e-07f
CMODEL3962 a_9600_83.t1 vdd.t12 1.17783886755746e-06f
CMODEL3963 a_9600_83.t1 vdd.n44 1.45629526478498e-06f
CMODEL3964 a_9600_83.t1 vdd.t23 1.49008990826706e-07f
CMODEL3965 a_9600_83.t1 vdd.t22 1.17783886755746e-06f
CMODEL3966 a_9600_83.t1 vdd.n45 1.79773581460232e-06f
CMODEL3967 a_9600_83.t1 vdd.n46 2.96734986303123e-05f
CMODEL3968 a_n104_n35959.t0 vdd 6.71012242671688e-06f
CMODEL3969 a_n104_n35959.t0 vdd.n0 0.00225179222126817f
CMODEL3970 a_n104_n35959.t0 vdd.n1 0.00020867529179061f
CMODEL3971 a_n104_n35959.t0 vdd.t7 1.72024402004457e-05f
CMODEL3972 a_n104_n35959.t0 vdd.t6 0.000135976376811262f
CMODEL3973 a_n104_n35959.t0 vdd.n2 0.000187127530921064f
CMODEL3974 a_n104_n35959.t0 vdd.t27 1.72024402004457e-05f
CMODEL3975 a_n104_n35959.t0 vdd.t26 0.000135976376811262f
CMODEL3976 a_n104_n35959.t0 vdd.n3 0.000350981904398385f
CMODEL3977 a_n104_n35959.t0 vdd.n4 0.000187127530921064f
CMODEL3978 a_n104_n35959.t0 vdd.t36 1.72024402004457e-05f
CMODEL3979 a_n104_n35959.t0 vdd.t35 0.000135976376811262f
CMODEL3980 a_n104_n35959.t0 vdd.n5 0.000267001574521661f
CMODEL3981 a_n104_n35959.t0 vdd.t3 2.74024490075268e-05f
CMODEL3982 a_n104_n35959.t0 vdd.n6 0.000262173615523176f
CMODEL3983 a_n104_n35959.t0 vdd.t2 0.000343596576778965f
CMODEL3984 a_n104_n35959.t0 vdd.n7 0.000351454615788576f
CMODEL3985 a_n104_n35959.t0 vdd.t25 2.74024490075268e-05f
CMODEL3986 a_n104_n35959.t0 vdd.n8 0.000158355164304764f
CMODEL3987 a_n104_n35959.t0 vdd.t24 0.000343596576778965f
CMODEL3988 a_n104_n35959.t0 vdd.n9 0.000351454615788576f
CMODEL3989 a_n104_n35959.t0 vdd.t5 2.74024490075268e-05f
CMODEL3990 a_n104_n35959.t0 vdd.n10 0.000468904487795467f
CMODEL3991 a_n104_n35959.t0 vdd.t4 0.000343785661335042f
CMODEL3992 a_n104_n35959.t0 vdd.n11 0.00113373208977882f
CMODEL3993 a_n104_n35959.t0 vdd.n12 0.00279536304884896f
CMODEL3994 a_n104_n35959.t0 vdd.n13 0.000211885002130008f
CMODEL3995 a_n104_n35959.t0 vdd.t42 1.72024402004457e-05f
CMODEL3996 a_n104_n35959.t0 vdd.t41 0.000135976376811262f
CMODEL3997 a_n104_n35959.t0 vdd.n14 0.000190501114542395f
CMODEL3998 a_n104_n35959.t0 vdd.t9 1.72024402004457e-05f
CMODEL3999 a_n104_n35959.t0 vdd.t8 0.000135976376811262f
CMODEL4000 a_n104_n35959.t0 vdd.n15 0.000365736802590884f
CMODEL4001 a_n104_n35959.t0 vdd.t15 2.89705902592542e-05f
CMODEL4002 a_n104_n35959.t0 vdd.n16 0.000227876828460175f
CMODEL4003 a_n104_n35959.t0 vdd.t14 0.000390795233384917f
CMODEL4004 a_n104_n35959.t0 vdd.n17 0.000319206244749737f
CMODEL4005 a_n104_n35959.t0 vdd.t32 0.000390795233384917f
CMODEL4006 a_n104_n35959.t0 vdd.n18 0.00031509995847361f
CMODEL4007 a_n104_n35959.t0 vdd.t34 2.89705902592542e-05f
CMODEL4008 a_n104_n35959.t0 vdd.n19 0.000317309096370436f
CMODEL4009 a_n104_n35959.t0 vdd.t33 0.000390795233384917f
CMODEL4010 a_n104_n35959.t0 vdd.n20 0.00063323629977688f
CMODEL4011 a_n104_n35959.t0 vdd.t48 0.000391542117381419f
CMODEL4012 a_n104_n35959.t0 vdd.n21 0.00112406356614478f
CMODEL4013 a_n104_n35959.t0 vdd.n22 0.0049260623689965f
CMODEL4014 a_n104_n35959.t0 vdd.t47 5.56928075762959e-06f
CMODEL4015 a_n104_n35959.t0 vdd.t45 5.5120984364628e-06f
CMODEL4016 a_n104_n35959.t0 vdd.n23 6.2941836744877e-05f
CMODEL4017 a_n104_n35959.t0 vdd.t46 0.000150214128742892f
CMODEL4018 a_n104_n35959.t0 vdd.n24 0.000161391547134425f
CMODEL4019 a_n104_n35959.t0 vdd.t44 0.000150214128742892f
CMODEL4020 a_n104_n35959.t0 vdd.n25 0.000254529872343785f
CMODEL4021 a_n104_n35959.t0 vdd.t43 0.000150539511749807f
CMODEL4022 a_n104_n35959.t0 vdd.n26 0.0013618783637314f
CMODEL4023 a_n104_n35959.t0 vdd.n27 0.000910443713212768f
CMODEL4024 a_n104_n35959.t0 vdd.n28 0.000205653090302655f
CMODEL4025 a_n104_n35959.t0 vdd.t29 1.72024402004457e-05f
CMODEL4026 a_n104_n35959.t0 vdd.t28 0.000135976376811262f
CMODEL4027 a_n104_n35959.t0 vdd.n29 3.0698823101793e-05f
CMODEL4028 a_n104_n35959.t0 vdd.n30 9.79360306788734e-06f
CMODEL4029 a_n104_n35959.t0 vdd.t38 4.50919395103328e-06f
CMODEL4030 a_n104_n35959.t0 vdd.t40 4.50919395103328e-06f
CMODEL4031 a_n104_n35959.t0 vdd.t37 9.11173264458297e-05f
CMODEL4032 a_n104_n35959.t0 vdd.t39 9.11173264458297e-05f
CMODEL4033 a_n104_n35959.t0 vdd.n31 2.95107418077792e-05f
CMODEL4034 a_n104_n35959.t0 vdd.n32 0.000356132882846834f
CMODEL4035 a_n104_n35959.t0 vdd.n33 0.000180452846091566f
CMODEL4036 a_n104_n35959.t0 vdd.t17 1.72024402004457e-05f
CMODEL4037 a_n104_n35959.t0 vdd.t16 0.000135976376811262f
CMODEL4038 a_n104_n35959.t0 vdd.n34 3.0698823101793e-05f
CMODEL4039 a_n104_n35959.t0 vdd.n35 9.79360306788734e-06f
CMODEL4040 a_n104_n35959.t0 vdd.t1 4.50919395103328e-06f
CMODEL4041 a_n104_n35959.t0 vdd.t31 4.50919395103328e-06f
CMODEL4042 a_n104_n35959.t0 vdd.t0 9.11173264458297e-05f
CMODEL4043 a_n104_n35959.t0 vdd.t30 9.11173264458297e-05f
CMODEL4044 a_n104_n35959.t0 vdd.n36 2.95107418077792e-05f
CMODEL4045 a_n104_n35959.t0 vdd.n37 0.000345378698719986f
CMODEL4046 a_n104_n35959.t0 vdd.n38 0.000199230518214592f
CMODEL4047 a_n104_n35959.t0 vdd.t19 1.72024402004457e-05f
CMODEL4048 a_n104_n35959.t0 vdd.t18 0.000135976376811262f
CMODEL4049 a_n104_n35959.t0 vdd.n39 0.000168122957330747f
CMODEL4050 a_n104_n35959.t0 vdd.t21 1.72025977709091e-05f
CMODEL4051 a_n104_n35959.t0 vdd.t20 0.000135976376811262f
CMODEL4052 a_n104_n35959.t0 vdd.n40 0.000168122957330747f
CMODEL4053 a_n104_n35959.t0 vdd.t11 1.72024402004457e-05f
CMODEL4054 a_n104_n35959.t0 vdd.t10 0.000135976376811262f
CMODEL4055 a_n104_n35959.t0 vdd.n41 0.000723295698131462f
CMODEL4056 a_n104_n35959.t0 vdd.n42 0.00138547138921584f
CMODEL4057 a_n104_n35959.t0 vdd.n43 0.000168122957330747f
CMODEL4058 a_n104_n35959.t0 vdd.t13 1.72024402004457e-05f
CMODEL4059 a_n104_n35959.t0 vdd.t12 0.000135976376811262f
CMODEL4060 a_n104_n35959.t0 vdd.n44 0.000168122957330747f
CMODEL4061 a_n104_n35959.t0 vdd.t23 1.72024402004457e-05f
CMODEL4062 a_n104_n35959.t0 vdd.t22 0.000135976376811262f
CMODEL4063 a_n104_n35959.t0 vdd.n45 0.000207540784454152f
CMODEL4064 a_n104_n35959.t0 vdd.n46 0.00342567641652983f
CMODEL4065 a_n104_n35959.t3 vdd 5.85576344565504e-06f
CMODEL4066 a_n104_n35959.t3 vdd.n0 0.00196508524554061f
CMODEL4067 a_n104_n35959.t3 vdd.n1 0.000182105939053146f
CMODEL4068 a_n104_n35959.t3 vdd.t7 1.50121583625298e-05f
CMODEL4069 a_n104_n35959.t3 vdd.t6 0.000118663333717085f
CMODEL4070 a_n104_n35959.t3 vdd.n2 0.000163301723211538f
CMODEL4071 a_n104_n35959.t3 vdd.t27 1.50121583625298e-05f
CMODEL4072 a_n104_n35959.t3 vdd.t26 0.000118663333717085f
CMODEL4073 a_n104_n35959.t3 vdd.n3 0.000306293518234369f
CMODEL4074 a_n104_n35959.t3 vdd.n4 0.000163301723211538f
CMODEL4075 a_n104_n35959.t3 vdd.t36 1.50121583625298e-05f
CMODEL4076 a_n104_n35959.t3 vdd.t35 0.000118663333717085f
CMODEL4077 a_n104_n35959.t3 vdd.n5 0.000233005891783895f
CMODEL4078 a_n104_n35959.t3 vdd.t3 2.39134622314502e-05f
CMODEL4079 a_n104_n35959.t3 vdd.n6 0.00022879264737156f
CMODEL4080 a_n104_n35959.t3 vdd.t2 0.000299848519356883f
CMODEL4081 a_n104_n35959.t3 vdd.n7 0.00030670604216508f
CMODEL4082 a_n104_n35959.t3 vdd.t25 2.39134622314502e-05f
CMODEL4083 a_n104_n35959.t3 vdd.n8 0.000138192766628885f
CMODEL4084 a_n104_n35959.t3 vdd.t24 0.000299848519356883f
CMODEL4085 a_n104_n35959.t3 vdd.n9 0.00030670604216508f
CMODEL4086 a_n104_n35959.t3 vdd.t5 2.39134622314502e-05f
CMODEL4087 a_n104_n35959.t3 vdd.n10 0.000409201737989712f
CMODEL4088 a_n104_n35959.t3 vdd.t4 0.000300013528929167f
CMODEL4089 a_n104_n35959.t3 vdd.n11 0.000989380894461737f
CMODEL4090 a_n104_n35959.t3 vdd.n12 0.00243944651346601f
CMODEL4091 a_n104_n35959.t3 vdd.n13 0.000184906976542679f
CMODEL4092 a_n104_n35959.t3 vdd.t42 1.50121583625298e-05f
CMODEL4093 a_n104_n35959.t3 vdd.t41 0.000118663333717085f
CMODEL4094 a_n104_n35959.t3 vdd.n14 0.00016624576899705f
CMODEL4095 a_n104_n35959.t3 vdd.t9 1.50121583625298e-05f
CMODEL4096 a_n104_n35959.t3 vdd.t8 0.000118663333717085f
CMODEL4097 a_n104_n35959.t3 vdd.n15 0.00031916976519165f
CMODEL4098 a_n104_n35959.t3 vdd.t15 2.52819416175979e-05f
CMODEL4099 a_n104_n35959.t3 vdd.n16 0.000198862661118656f
CMODEL4100 a_n104_n35959.t3 vdd.t14 0.000341037658758678f
CMODEL4101 a_n104_n35959.t3 vdd.n17 0.000278563659611927f
CMODEL4102 a_n104_n35959.t3 vdd.t32 0.000341037658758678f
CMODEL4103 a_n104_n35959.t3 vdd.n18 0.000274980201733812f
CMODEL4104 a_n104_n35959.t3 vdd.t34 2.52819416175979e-05f
CMODEL4105 a_n104_n35959.t3 vdd.n19 0.000276908063570005f
CMODEL4106 a_n104_n35959.t3 vdd.t33 0.000341037658758678f
CMODEL4107 a_n104_n35959.t3 vdd.n20 0.000552610182182562f
CMODEL4108 a_n104_n35959.t3 vdd.t48 0.000341689446569202f
CMODEL4109 a_n104_n35959.t3 vdd.n21 0.000980943404998914f
CMODEL4110 a_n104_n35959.t3 vdd.n22 0.00429885687875597f
CMODEL4111 a_n104_n35959.t3 vdd.t47 4.86017819127539e-06f
CMODEL4112 a_n104_n35959.t3 vdd.t45 4.81027654645697e-06f
CMODEL4113 a_n104_n35959.t3 vdd.n23 5.4927836390218e-05f
CMODEL4114 a_n104_n35959.t3 vdd.t46 0.000131088279494168f
CMODEL4115 a_n104_n35959.t3 vdd.n24 0.000140842545343823f
CMODEL4116 a_n104_n35959.t3 vdd.t44 0.000131088279494168f
CMODEL4117 a_n104_n35959.t3 vdd.n25 0.000222122135411951f
CMODEL4118 a_n104_n35959.t3 vdd.t43 0.000131372233466474f
CMODEL4119 a_n104_n35959.t3 vdd.n26 0.0011884786942209f
CMODEL4120 a_n104_n35959.t3 vdd.n27 0.000794522465630523f
CMODEL4121 a_n104_n35959.t3 vdd.n28 0.00017946853605613f
CMODEL4122 a_n104_n35959.t3 vdd.t29 1.50121583625298e-05f
CMODEL4123 a_n104_n35959.t3 vdd.t28 0.000118663333717085f
CMODEL4124 a_n104_n35959.t3 vdd.n29 2.67901291082799e-05f
CMODEL4125 a_n104_n35959.t3 vdd.n30 8.54664329488983e-06f
CMODEL4126 a_n104_n35959.t3 vdd.t38 3.935065775059e-06f
CMODEL4127 a_n104_n35959.t3 vdd.t40 3.935065775059e-06f
CMODEL4128 a_n104_n35959.t3 vdd.t37 7.95159127563588e-05f
CMODEL4129 a_n104_n35959.t3 vdd.t39 7.95159127563588e-05f
CMODEL4130 a_n104_n35959.t3 vdd.n31 2.57533189624245e-05f
CMODEL4131 a_n104_n35959.t3 vdd.n32 0.000310788653999357f
CMODEL4132 a_n104_n35959.t3 vdd.n33 0.000157476885309888f
CMODEL4133 a_n104_n35959.t3 vdd.t17 1.50121583625298e-05f
CMODEL4134 a_n104_n35959.t3 vdd.t16 0.000118663333717085f
CMODEL4135 a_n104_n35959.t3 vdd.n34 2.67901291082799e-05f
CMODEL4136 a_n104_n35959.t3 vdd.n35 8.54664329488983e-06f
CMODEL4137 a_n104_n35959.t3 vdd.t1 3.935065775059e-06f
CMODEL4138 a_n104_n35959.t3 vdd.t31 3.935065775059e-06f
CMODEL4139 a_n104_n35959.t3 vdd.t0 7.95159127563588e-05f
CMODEL4140 a_n104_n35959.t3 vdd.t30 7.95159127563588e-05f
CMODEL4141 a_n104_n35959.t3 vdd.n36 2.57533189624245e-05f
CMODEL4142 a_n104_n35959.t3 vdd.n37 0.000301403734575666f
CMODEL4143 a_n104_n35959.t3 vdd.n38 0.000173863710917526f
CMODEL4144 a_n104_n35959.t3 vdd.t19 1.50121583625298e-05f
CMODEL4145 a_n104_n35959.t3 vdd.t18 0.000118663333717085f
CMODEL4146 a_n104_n35959.t3 vdd.n39 0.000146716886117158f
CMODEL4147 a_n104_n35959.t3 vdd.t21 1.50122958705068e-05f
CMODEL4148 a_n104_n35959.t3 vdd.t20 0.000118663333717085f
CMODEL4149 a_n104_n35959.t3 vdd.n40 0.000146716886117158f
CMODEL4150 a_n104_n35959.t3 vdd.t11 1.50121583625298e-05f
CMODEL4151 a_n104_n35959.t3 vdd.t10 0.000118663333717085f
CMODEL4152 a_n104_n35959.t3 vdd.n41 0.000631202866381988f
CMODEL4153 a_n104_n35959.t3 vdd.n42 0.00120906776360272f
CMODEL4154 a_n104_n35959.t3 vdd.n43 0.000146716886117158f
CMODEL4155 a_n104_n35959.t3 vdd.t13 1.50121583625298e-05f
CMODEL4156 a_n104_n35959.t3 vdd.t12 0.000118663333717085f
CMODEL4157 a_n104_n35959.t3 vdd.n44 0.000146716886117158f
CMODEL4158 a_n104_n35959.t3 vdd.t23 1.50121583625298e-05f
CMODEL4159 a_n104_n35959.t3 vdd.t22 0.000118663333717085f
CMODEL4160 a_n104_n35959.t3 vdd.n45 0.000181115881619438f
CMODEL4161 a_n104_n35959.t3 vdd.n46 0.002989505922677f
CMODEL4162 a_n104_n35959.t4 vdd 2.34779582734843e-06f
CMODEL4163 a_n104_n35959.t4 vdd.n0 0.000787876590760768f
CMODEL4164 a_n104_n35959.t4 vdd.n1 7.30131208017948e-05f
CMODEL4165 a_n104_n35959.t4 vdd.t7 6.01893896332058e-06f
CMODEL4166 a_n104_n35959.t4 vdd.t6 4.75765939566676e-05f
CMODEL4167 a_n104_n35959.t4 vdd.n2 6.5473803358525e-05f
CMODEL4168 a_n104_n35959.t4 vdd.t27 6.01893896332058e-06f
CMODEL4169 a_n104_n35959.t4 vdd.t26 4.75765939566676e-05f
CMODEL4170 a_n104_n35959.t4 vdd.n3 0.000122804592557116f
CMODEL4171 a_n104_n35959.t4 vdd.n4 6.5473803358525e-05f
CMODEL4172 a_n104_n35959.t4 vdd.t36 6.01893896332058e-06f
CMODEL4173 a_n104_n35959.t4 vdd.t35 4.75765939566676e-05f
CMODEL4174 a_n104_n35959.t4 vdd.n5 9.34208264310506e-05f
CMODEL4175 a_n104_n35959.t4 vdd.t3 9.5878065030294e-06f
CMODEL4176 a_n104_n35959.t4 vdd.n6 9.17315782667962e-05f
CMODEL4177 a_n104_n35959.t4 vdd.t2 0.000120220550081313f
CMODEL4178 a_n104_n35959.t4 vdd.n7 0.000122969988917846f
CMODEL4179 a_n104_n35959.t4 vdd.t25 9.5878065030294e-06f
CMODEL4180 a_n104_n35959.t4 vdd.n8 5.54066782021005e-05f
CMODEL4181 a_n104_n35959.t4 vdd.t24 0.000120220550081313f
CMODEL4182 a_n104_n35959.t4 vdd.n9 0.000122969988917846f
CMODEL4183 a_n104_n35959.t4 vdd.t5 9.5878065030294e-06f
CMODEL4184 a_n104_n35959.t4 vdd.n10 0.000164064368704789f
CMODEL4185 a_n104_n35959.t4 vdd.t4 0.000120286708625605f
CMODEL4186 a_n104_n35959.t4 vdd.n11 0.000396680015720083f
CMODEL4187 a_n104_n35959.t4 vdd.n12 0.000978065865964042f
CMODEL4188 a_n104_n35959.t4 vdd.n13 7.41361620911506e-05f
CMODEL4189 a_n104_n35959.t4 vdd.t42 6.01893896332058e-06f
CMODEL4190 a_n104_n35959.t4 vdd.t41 4.75765939566676e-05f
CMODEL4191 a_n104_n35959.t4 vdd.n14 6.66541820529338e-05f
CMODEL4192 a_n104_n35959.t4 vdd.t9 6.01893896332058e-06f
CMODEL4193 a_n104_n35959.t4 vdd.t8 4.75765939566676e-05f
CMODEL4194 a_n104_n35959.t4 vdd.n15 0.000127967164296698f
CMODEL4195 a_n104_n35959.t4 vdd.t15 1.01364813636906e-05f
CMODEL4196 a_n104_n35959.t4 vdd.n16 7.97315209746419e-05f
CMODEL4197 a_n104_n35959.t4 vdd.t14 0.000136734825378988f
CMODEL4198 a_n104_n35959.t4 vdd.n17 0.000111686649188855f
CMODEL4199 a_n104_n35959.t4 vdd.t32 0.000136734825378988f
CMODEL4200 a_n104_n35959.t4 vdd.n18 0.000110249906135314f
CMODEL4201 a_n104_n35959.t4 vdd.t34 1.01364813636906e-05f
CMODEL4202 a_n104_n35959.t4 vdd.n19 0.000111022858461125f
CMODEL4203 a_n104_n35959.t4 vdd.t33 0.000136734825378988f
CMODEL4204 a_n104_n35959.t4 vdd.n20 0.000221562208227717f
CMODEL4205 a_n104_n35959.t4 vdd.t48 0.000136996151628941f
CMODEL4206 a_n104_n35959.t4 vdd.n21 0.000393297108821955f
CMODEL4207 a_n104_n35959.t4 vdd.n22 0.00172357342231784f
CMODEL4208 a_n104_n35959.t4 vdd.t47 1.94862825036297e-06f
CMODEL4209 a_n104_n35959.t4 vdd.t45 1.92862080392668e-06f
CMODEL4210 a_n104_n35959.t4 vdd.n23 2.20226356954222e-05f
CMODEL4211 a_n104_n35959.t4 vdd.t46 5.25582220776107e-05f
CMODEL4212 a_n104_n35959.t4 vdd.n24 5.64690741591886e-05f
CMODEL4213 a_n104_n35959.t4 vdd.t44 5.25582220776107e-05f
CMODEL4214 a_n104_n35959.t4 vdd.n25 8.90571191137942e-05f
CMODEL4215 a_n104_n35959.t4 vdd.t43 5.26720699059131e-05f
CMODEL4216 a_n104_n35959.t4 vdd.n26 0.000476505812620341f
CMODEL4217 a_n104_n35959.t4 vdd.n27 0.000318553942086926f
CMODEL4218 a_n104_n35959.t4 vdd.n28 7.19556867355285e-05f
CMODEL4219 a_n104_n35959.t4 vdd.t29 6.01893896332058e-06f
CMODEL4220 a_n104_n35959.t4 vdd.t28 4.75765939566676e-05f
CMODEL4221 a_n104_n35959.t4 vdd.n29 1.0741170458519e-05f
CMODEL4222 a_n104_n35959.t4 vdd.n30 3.42667077517733e-06f
CMODEL4223 a_n104_n35959.t4 vdd.t38 1.5777158850022e-06f
CMODEL4224 a_n104_n35959.t4 vdd.t40 1.5777158850022e-06f
CMODEL4225 a_n104_n35959.t4 vdd.t37 3.18809203803652e-05f
CMODEL4226 a_n104_n35959.t4 vdd.t39 3.18809203803652e-05f
CMODEL4227 a_n104_n35959.t4 vdd.n31 1.03254742718846e-05f
CMODEL4228 a_n104_n35959.t4 vdd.n32 0.000124606861567869f
CMODEL4229 a_n104_n35959.t4 vdd.n33 6.31384067450193e-05f
CMODEL4230 a_n104_n35959.t4 vdd.t17 6.01893896332058e-06f
CMODEL4231 a_n104_n35959.t4 vdd.t16 4.75765939566676e-05f
CMODEL4232 a_n104_n35959.t4 vdd.n34 1.0741170458519e-05f
CMODEL4233 a_n104_n35959.t4 vdd.n35 3.42667077517733e-06f
CMODEL4234 a_n104_n35959.t4 vdd.t1 1.5777158850022e-06f
CMODEL4235 a_n104_n35959.t4 vdd.t31 1.5777158850022e-06f
CMODEL4236 a_n104_n35959.t4 vdd.t0 3.18809203803652e-05f
CMODEL4237 a_n104_n35959.t4 vdd.t30 3.18809203803652e-05f
CMODEL4238 a_n104_n35959.t4 vdd.n36 1.03254742718846e-05f
CMODEL4239 a_n104_n35959.t4 vdd.n37 0.000120844094361265f
CMODEL4240 a_n104_n35959.t4 vdd.n38 6.9708501514412e-05f
CMODEL4241 a_n104_n35959.t4 vdd.t19 6.01893896332058e-06f
CMODEL4242 a_n104_n35959.t4 vdd.t18 4.75765939566676e-05f
CMODEL4243 a_n104_n35959.t4 vdd.n39 5.88243183359819e-05f
CMODEL4244 a_n104_n35959.t4 vdd.t21 6.01899409544082e-06f
CMODEL4245 a_n104_n35959.t4 vdd.t20 4.75765939566676e-05f
CMODEL4246 a_n104_n35959.t4 vdd.n40 5.88243183359819e-05f
CMODEL4247 a_n104_n35959.t4 vdd.t11 6.01893896332058e-06f
CMODEL4248 a_n104_n35959.t4 vdd.t10 4.75765939566676e-05f
CMODEL4249 a_n104_n35959.t4 vdd.n41 0.000253072971552769f
CMODEL4250 a_n104_n35959.t4 vdd.n42 0.000484760744984368f
CMODEL4251 a_n104_n35959.t4 vdd.n43 5.88243183359819e-05f
CMODEL4252 a_n104_n35959.t4 vdd.t13 6.01893896332058e-06f
CMODEL4253 a_n104_n35959.t4 vdd.t12 4.75765939566676e-05f
CMODEL4254 a_n104_n35959.t4 vdd.n44 5.88243183359819e-05f
CMODEL4255 a_n104_n35959.t4 vdd.t23 6.01893896332058e-06f
CMODEL4256 a_n104_n35959.t4 vdd.t22 4.75765939566676e-05f
CMODEL4257 a_n104_n35959.t4 vdd.n45 7.26161695360431e-05f
CMODEL4258 a_n104_n35959.t4 vdd.n46 0.00119860537336125f
CMODEL4259 a_n104_n35959.t2 vdd 3.21345229645934e-06f
CMODEL4260 a_n104_n35959.t2 vdd.n0 0.00107837479324858f
CMODEL4261 a_n104_n35959.t2 vdd.n1 9.99338093965233e-05f
CMODEL4262 a_n104_n35959.t2 vdd.t7 8.23818366513379e-06f
CMODEL4263 a_n104_n35959.t2 vdd.t6 6.51185734836379e-05f
CMODEL4264 a_n104_n35959.t2 vdd.n2 8.96146680684747e-05f
CMODEL4265 a_n104_n35959.t2 vdd.t27 8.23818366513379e-06f
CMODEL4266 a_n104_n35959.t2 vdd.t26 6.51185734836379e-05f
CMODEL4267 a_n104_n35959.t2 vdd.n3 0.000168083908903657f
CMODEL4268 a_n104_n35959.t2 vdd.n4 8.96146680684747e-05f
CMODEL4269 a_n104_n35959.t2 vdd.t36 8.23818366513379e-06f
CMODEL4270 a_n104_n35959.t2 vdd.t35 6.51185734836379e-05f
CMODEL4271 a_n104_n35959.t2 vdd.n5 0.000127866045988775f
CMODEL4272 a_n104_n35959.t2 vdd.t3 1.31229293732769e-05f
CMODEL4273 a_n104_n35959.t2 vdd.n6 0.000125553954652092f
CMODEL4274 a_n104_n35959.t2 vdd.t2 0.000164547103389612f
CMODEL4275 a_n104_n35959.t2 vdd.n7 0.000168310288603724f
CMODEL4276 a_n104_n35959.t2 vdd.t25 1.31229293732769e-05f
CMODEL4277 a_n104_n35959.t2 vdd.n8 7.5835690324404e-05f
CMODEL4278 a_n104_n35959.t2 vdd.t24 0.000164547103389612f
CMODEL4279 a_n104_n35959.t2 vdd.n9 0.000168310288603724f
CMODEL4280 a_n104_n35959.t2 vdd.t5 1.31229293732769e-05f
CMODEL4281 a_n104_n35959.t2 vdd.n10 0.00022455658888234f
CMODEL4282 a_n104_n35959.t2 vdd.t4 0.000164637655269639f
CMODEL4283 a_n104_n35959.t2 vdd.n11 0.0005429400174524f
CMODEL4284 a_n104_n35959.t2 vdd.n12 0.00133868881035549f
CMODEL4285 a_n104_n35959.t2 vdd.n13 0.000101470927559977f
CMODEL4286 a_n104_n35959.t2 vdd.t42 8.23818366513379e-06f
CMODEL4287 a_n104_n35959.t2 vdd.t41 6.51185734836379e-05f
CMODEL4288 a_n104_n35959.t2 vdd.n14 9.1230264527952e-05f
CMODEL4289 a_n104_n35959.t2 vdd.t9 8.23818366513379e-06f
CMODEL4290 a_n104_n35959.t2 vdd.t8 6.51185734836379e-05f
CMODEL4291 a_n104_n35959.t2 vdd.n15 0.000175149973941744f
CMODEL4292 a_n104_n35959.t2 vdd.t15 1.38739062982987e-05f
CMODEL4293 a_n104_n35959.t2 vdd.n16 0.00010912935281324f
CMODEL4294 a_n104_n35959.t2 vdd.t14 0.00018715036184229f
CMODEL4295 a_n104_n35959.t2 vdd.n17 0.000152866665465161f
CMODEL4296 a_n104_n35959.t2 vdd.t32 0.00018715036184229f
CMODEL4297 a_n104_n35959.t2 vdd.n18 0.00015090018047058f
CMODEL4298 a_n104_n35959.t2 vdd.t34 1.38739062982987e-05f
CMODEL4299 a_n104_n35959.t2 vdd.n19 0.000151958128268893f
CMODEL4300 a_n104_n35959.t2 vdd.t33 0.00018715036184229f
CMODEL4301 a_n104_n35959.t2 vdd.n20 0.00030325447321459f
CMODEL4302 a_n104_n35959.t2 vdd.t48 0.000187508041768395f
CMODEL4303 a_n104_n35959.t2 vdd.n21 0.000538309797987032f
CMODEL4304 a_n104_n35959.t2 vdd.n22 0.00235907267043694f
CMODEL4305 a_n104_n35959.t2 vdd.t47 2.66710752831794e-06f
CMODEL4306 a_n104_n35959.t2 vdd.t45 2.63972313059985e-06f
CMODEL4307 a_n104_n35959.t2 vdd.n23 3.0142607983705e-05f
CMODEL4308 a_n104_n35959.t2 vdd.t46 7.19369791298522e-05f
CMODEL4309 a_n104_n35959.t2 vdd.n24 7.72898025978336e-05f
CMODEL4310 a_n104_n35959.t2 vdd.t44 7.19369791298522e-05f
CMODEL4311 a_n104_n35959.t2 vdd.n25 0.000121893394902011f
CMODEL4312 a_n104_n35959.t2 vdd.t43 7.20928038233983e-05f
CMODEL4313 a_n104_n35959.t2 vdd.n26 0.000652198406694678f
CMODEL4314 a_n104_n35959.t2 vdd.n27 0.000436008056927809f
CMODEL4315 a_n104_n35959.t2 vdd.n28 9.84864885140957e-05f
CMODEL4316 a_n104_n35959.t2 vdd.t29 8.23818366513379e-06f
CMODEL4317 a_n104_n35959.t2 vdd.t28 6.51185734836379e-05f
CMODEL4318 a_n104_n35959.t2 vdd.n29 1.47015504817433e-05f
CMODEL4319 a_n104_n35959.t2 vdd.n30 4.69011953400559e-06f
CMODEL4320 a_n104_n35959.t2 vdd.t38 2.15943595893796e-06f
CMODEL4321 a_n104_n35959.t2 vdd.t40 2.15943595893796e-06f
CMODEL4322 a_n104_n35959.t2 vdd.t37 4.36357436264912e-05f
CMODEL4323 a_n104_n35959.t2 vdd.t39 4.36357436264912e-05f
CMODEL4324 a_n104_n35959.t2 vdd.n31 1.41325828355752e-05f
CMODEL4325 a_n104_n35959.t2 vdd.n32 0.000170550693035386f
CMODEL4326 a_n104_n35959.t2 vdd.n33 8.64181867035304e-05f
CMODEL4327 a_n104_n35959.t2 vdd.t17 8.23818366513379e-06f
CMODEL4328 a_n104_n35959.t2 vdd.t16 6.51185734836379e-05f
CMODEL4329 a_n104_n35959.t2 vdd.n34 1.47015504817433e-05f
CMODEL4330 a_n104_n35959.t2 vdd.n35 4.69011953400559e-06f
CMODEL4331 a_n104_n35959.t2 vdd.t1 2.15943595893796e-06f
CMODEL4332 a_n104_n35959.t2 vdd.t31 2.15943595893796e-06f
CMODEL4333 a_n104_n35959.t2 vdd.t0 4.36357436264912e-05f
CMODEL4334 a_n104_n35959.t2 vdd.t30 4.36357436264912e-05f
CMODEL4335 a_n104_n35959.t2 vdd.n36 1.41325828355752e-05f
CMODEL4336 a_n104_n35959.t2 vdd.n37 0.000165400554858864f
CMODEL4337 a_n104_n35959.t2 vdd.n38 9.5410742989187e-05f
CMODEL4338 a_n104_n35959.t2 vdd.t19 8.23818366513379e-06f
CMODEL4339 a_n104_n35959.t2 vdd.t18 6.51185734836379e-05f
CMODEL4340 a_n104_n35959.t2 vdd.n39 8.0513449526786e-05f
CMODEL4341 a_n104_n35959.t2 vdd.t21 8.23825912503382e-06f
CMODEL4342 a_n104_n35959.t2 vdd.t20 6.51185734836379e-05f
CMODEL4343 a_n104_n35959.t2 vdd.n40 8.0513449526786e-05f
CMODEL4344 a_n104_n35959.t2 vdd.t11 8.23818366513379e-06f
CMODEL4345 a_n104_n35959.t2 vdd.t10 6.51185734836379e-05f
CMODEL4346 a_n104_n35959.t2 vdd.n41 0.000346383579072332f
CMODEL4347 a_n104_n35959.t2 vdd.n42 0.000663497017525016f
CMODEL4348 a_n104_n35959.t2 vdd.n43 8.0513449526786e-05f
CMODEL4349 a_n104_n35959.t2 vdd.t13 8.23818366513379e-06f
CMODEL4350 a_n104_n35959.t2 vdd.t12 6.51185734836379e-05f
CMODEL4351 a_n104_n35959.t2 vdd.n44 8.0513449526786e-05f
CMODEL4352 a_n104_n35959.t2 vdd.t23 8.23818366513379e-06f
CMODEL4353 a_n104_n35959.t2 vdd.t22 6.51185734836379e-05f
CMODEL4354 a_n104_n35959.t2 vdd.n45 9.93904981163628e-05f
CMODEL4355 a_n104_n35959.t2 vdd.n46 0.00164054350242466f
CMODEL4356 a_n104_n35959.n0 vdd 0.000239881883959306f
CMODEL4357 a_n104_n35959.n0 vdd.n0 0.0804998964209676f
CMODEL4358 a_n104_n35959.n0 vdd.n1 0.00745998641264458f
CMODEL4359 a_n104_n35959.n0 vdd.t7 0.000614974437359002f
CMODEL4360 a_n104_n35959.n0 vdd.t6 0.00486105429516066f
CMODEL4361 a_n104_n35959.n0 vdd.n2 0.00668966999458477f
CMODEL4362 a_n104_n35959.n0 vdd.t27 0.000614974437359002f
CMODEL4363 a_n104_n35959.n0 vdd.t26 0.00486105429516066f
CMODEL4364 a_n104_n35959.n0 vdd.n3 0.0125473419273967f
CMODEL4365 a_n104_n35959.n0 vdd.n4 0.00668966999458477f
CMODEL4366 a_n104_n35959.n0 vdd.t36 0.000614974437359002f
CMODEL4367 a_n104_n35959.n0 vdd.t35 0.00486105429516066f
CMODEL4368 a_n104_n35959.n0 vdd.n5 0.00954510762148567f
CMODEL4369 a_n104_n35959.n0 vdd.t3 0.000979617162699153f
CMODEL4370 a_n104_n35959.n0 vdd.n6 0.00937251167962569f
CMODEL4371 a_n104_n35959.n0 vdd.t2 0.0122833219601977f
CMODEL4372 a_n104_n35959.n0 vdd.n7 0.012564241007866f
CMODEL4373 a_n104_n35959.n0 vdd.t25 0.000979617162699153f
CMODEL4374 a_n104_n35959.n0 vdd.n8 0.00566107929668553f
CMODEL4375 a_n104_n35959.n0 vdd.t24 0.0122833219601977f
CMODEL4376 a_n104_n35959.n0 vdd.n9 0.012564241007866f
CMODEL4377 a_n104_n35959.n0 vdd.t5 0.000979617162699153f
CMODEL4378 a_n104_n35959.n0 vdd.n10 0.0167629865412731f
CMODEL4379 a_n104_n35959.n0 vdd.t4 0.0122900815923855f
CMODEL4380 a_n104_n35959.n0 vdd.n11 0.0405300786343969f
CMODEL4381 a_n104_n35959.n0 vdd.n12 0.0999321490526379f
CMODEL4382 a_n104_n35959.n0 vdd.n13 0.00757473116903126f
CMODEL4383 a_n104_n35959.n0 vdd.t42 0.000614974437359002f
CMODEL4384 a_n104_n35959.n0 vdd.t41 0.00486105429516066f
CMODEL4385 a_n104_n35959.n0 vdd.n14 0.00681027309886748f
CMODEL4386 a_n104_n35959.n0 vdd.t9 0.000614974437359002f
CMODEL4387 a_n104_n35959.n0 vdd.t8 0.00486105429516066f
CMODEL4388 a_n104_n35959.n0 vdd.n15 0.0130748185591124f
CMODEL4389 a_n104_n35959.n0 vdd.t15 0.00103567704564271f
CMODEL4390 a_n104_n35959.n0 vdd.n16 0.00814642706130834f
CMODEL4391 a_n104_n35959.n0 vdd.t14 0.013970638814791f
CMODEL4392 a_n104_n35959.n0 vdd.n17 0.0114113857382491f
CMODEL4393 a_n104_n35959.n0 vdd.t32 0.013970638814791f
CMODEL4394 a_n104_n35959.n0 vdd.n18 0.0112645890592389f
CMODEL4395 a_n104_n35959.n0 vdd.t34 0.00103567704564271f
CMODEL4396 a_n104_n35959.n0 vdd.n19 0.0113435640952989f
CMODEL4397 a_n104_n35959.n0 vdd.t33 0.013970638814791f
CMODEL4398 a_n104_n35959.n0 vdd.n20 0.0226377265453591f
CMODEL4399 a_n104_n35959.n0 vdd.t48 0.0139973393619326f
CMODEL4400 a_n104_n35959.n0 vdd.n21 0.040184436108531f
CMODEL4401 a_n104_n35959.n0 vdd.n22 0.176103064360048f
CMODEL4402 a_n104_n35959.n0 vdd.t47 0.000199097643154651f
CMODEL4403 a_n104_n35959.n0 vdd.t45 0.000197053417720546f
CMODEL4404 a_n104_n35959.n0 vdd.n23 0.00225012383054352f
CMODEL4405 a_n104_n35959.n0 vdd.t46 0.00537004333284292f
CMODEL4406 a_n104_n35959.n0 vdd.n24 0.0057696277235668f
CMODEL4407 a_n104_n35959.n0 vdd.t44 0.00537004333284292f
CMODEL4408 a_n104_n35959.n0 vdd.n25 0.0090992535484368f
CMODEL4409 a_n104_n35959.n0 vdd.t43 0.00538167553323263f
CMODEL4410 a_n104_n35959.n0 vdd.n26 0.0486861381715727f
CMODEL4411 a_n104_n35959.n0 vdd.n27 0.0325476853141774f
CMODEL4412 a_n104_n35959.n0 vdd.n28 0.0073519449581774f
CMODEL4413 a_n104_n35959.n0 vdd.t29 0.000614974437359002f
CMODEL4414 a_n104_n35959.n0 vdd.t28 0.00486105429516066f
CMODEL4415 a_n104_n35959.n0 vdd.n29 0.00109746008383854f
CMODEL4416 a_n104_n35959.n0 vdd.n30 0.000350114022557995f
CMODEL4417 a_n104_n35959.n0 vdd.t38 0.000161200328596838f
CMODEL4418 a_n104_n35959.n0 vdd.t40 0.000161200328596838f
CMODEL4419 a_n104_n35959.n0 vdd.t37 0.00325737662283684f
CMODEL4420 a_n104_n35959.n0 vdd.t39 0.00325737662283684f
CMODEL4421 a_n104_n35959.n0 vdd.n31 0.00105498706159232f
CMODEL4422 a_n104_n35959.n0 vdd.n32 0.0127314855742441f
CMODEL4423 a_n104_n35959.n0 vdd.n33 0.00645105497835799f
CMODEL4424 a_n104_n35959.n0 vdd.t17 0.000614974437359002f
CMODEL4425 a_n104_n35959.n0 vdd.t16 0.00486105429516066f
CMODEL4426 a_n104_n35959.n0 vdd.n34 0.00109746008383854f
CMODEL4427 a_n104_n35959.n0 vdd.n35 0.000350114022557995f
CMODEL4428 a_n104_n35959.n0 vdd.t1 0.000161200328596838f
CMODEL4429 a_n104_n35959.n0 vdd.t31 0.000161200328596838f
CMODEL4430 a_n104_n35959.n0 vdd.t0 0.00325737662283684f
CMODEL4431 a_n104_n35959.n0 vdd.t30 0.00325737662283684f
CMODEL4432 a_n104_n35959.n0 vdd.n36 0.00105498706159232f
CMODEL4433 a_n104_n35959.n0 vdd.n37 0.0123470314935671f
CMODEL4434 a_n104_n35959.n0 vdd.n38 0.00712234278486758f
CMODEL4435 a_n104_n35959.n0 vdd.t19 0.000614974437359002f
CMODEL4436 a_n104_n35959.n0 vdd.t18 0.00486105429516066f
CMODEL4437 a_n104_n35959.n0 vdd.n39 0.00601027062944991f
CMODEL4438 a_n104_n35959.n0 vdd.t21 0.000614980070385825f
CMODEL4439 a_n104_n35959.n0 vdd.t20 0.00486105429516066f
CMODEL4440 a_n104_n35959.n0 vdd.n40 0.00601027062944991f
CMODEL4441 a_n104_n35959.n0 vdd.t11 0.000614974437359002f
CMODEL4442 a_n104_n35959.n0 vdd.t10 0.00486105429516066f
CMODEL4443 a_n104_n35959.n0 vdd.n41 0.0258572830261056f
CMODEL4444 a_n104_n35959.n0 vdd.n42 0.0495295712777964f
CMODEL4445 a_n104_n35959.n0 vdd.n43 0.00601027062944991f
CMODEL4446 a_n104_n35959.n0 vdd.t13 0.000614974437359002f
CMODEL4447 a_n104_n35959.n0 vdd.t12 0.00486105429516066f
CMODEL4448 a_n104_n35959.n0 vdd.n44 0.00601027062944991f
CMODEL4449 a_n104_n35959.n0 vdd.t23 0.000614974437359002f
CMODEL4450 a_n104_n35959.n0 vdd.t22 0.00486105429516066f
CMODEL4451 a_n104_n35959.n0 vdd.n45 0.00741942861951822f
CMODEL4452 a_n104_n35959.n0 vdd.n46 0.122465382950428f
CMODEL4453 a_n104_n35959.t1 vdd 5.9468589299048e-06f
CMODEL4454 a_n104_n35959.t1 vdd.n0 0.00199565519490689f
CMODEL4455 a_n104_n35959.t1 vdd.n1 0.000184938879430052f
CMODEL4456 a_n104_n35959.t1 vdd.t7 1.52456957737249e-05f
CMODEL4457 a_n104_n35959.t1 vdd.t6 0.000120509325951568f
CMODEL4458 a_n104_n35959.t1 vdd.n2 0.000165842134840668f
CMODEL4459 a_n104_n35959.t1 vdd.t27 1.52456957737249e-05f
CMODEL4460 a_n104_n35959.t1 vdd.t26 0.000120509325951568f
CMODEL4461 a_n104_n35959.t1 vdd.n3 0.000311058389053532f
CMODEL4462 a_n104_n35959.t1 vdd.n4 0.000165842134840668f
CMODEL4463 a_n104_n35959.t1 vdd.t36 1.52456957737249e-05f
CMODEL4464 a_n104_n35959.t1 vdd.t35 0.000120509325951568f
CMODEL4465 a_n104_n35959.t1 vdd.n5 0.000236630659884945f
CMODEL4466 a_n104_n35959.t1 vdd.t3 2.42854732326253e-05f
CMODEL4467 a_n104_n35959.t1 vdd.n6 0.000232351871919908f
CMODEL4468 a_n104_n35959.t1 vdd.t2 0.000304513128220593f
CMODEL4469 a_n104_n35959.t1 vdd.n7 0.000311477330433921f
CMODEL4470 a_n104_n35959.t1 vdd.t25 2.42854732326253e-05f
CMODEL4471 a_n104_n35959.t1 vdd.n8 0.000140342569487676f
CMODEL4472 a_n104_n35959.t1 vdd.t24 0.000304513128220593f
CMODEL4473 a_n104_n35959.t1 vdd.n9 0.000311477330433921f
CMODEL4474 a_n104_n35959.t1 vdd.t5 2.42854732326253e-05f
CMODEL4475 a_n104_n35959.t1 vdd.n10 0.000415567505805295f
CMODEL4476 a_n104_n35959.t1 vdd.t4 0.000304680704772748f
CMODEL4477 a_n104_n35959.t1 vdd.n11 0.00100477224906902f
CMODEL4478 a_n104_n35959.t1 vdd.n12 0.00247739588821585f
CMODEL4479 a_n104_n35959.t1 vdd.n13 0.000187783491402891f
CMODEL4480 a_n104_n35959.t1 vdd.t42 1.52456957737249e-05f
CMODEL4481 a_n104_n35959.t1 vdd.t41 0.000120509325951568f
CMODEL4482 a_n104_n35959.t1 vdd.n14 0.000168831979825375f
CMODEL4483 a_n104_n35959.t1 vdd.t9 1.52456957737249e-05f
CMODEL4484 a_n104_n35959.t1 vdd.t8 0.000120509325951568f
CMODEL4485 a_n104_n35959.t1 vdd.n15 0.000324134946006731f
CMODEL4486 a_n104_n35959.t1 vdd.t15 2.56752414385014e-05f
CMODEL4487 a_n104_n35959.t1 vdd.n16 0.000201956278301441f
CMODEL4488 a_n104_n35959.t1 vdd.t14 0.000346343028581136f
CMODEL4489 a_n104_n35959.t1 vdd.n17 0.000282897149463804f
CMODEL4490 a_n104_n35959.t1 vdd.t32 0.000346343028581136f
CMODEL4491 a_n104_n35959.t1 vdd.n18 0.000279257945339494f
CMODEL4492 a_n104_n35959.t1 vdd.t34 2.56752414385014e-05f
CMODEL4493 a_n104_n35959.t1 vdd.n19 0.000281215798057177f
CMODEL4494 a_n104_n35959.t1 vdd.t33 0.000346343028581136f
CMODEL4495 a_n104_n35959.t1 vdd.n20 0.000561206890812352f
CMODEL4496 a_n104_n35959.t1 vdd.t48 0.00034700495596215f
CMODEL4497 a_n104_n35959.t1 vdd.n21 0.000996203501368806f
CMODEL4498 a_n104_n35959.t1 vdd.n22 0.00436573226617984f
CMODEL4499 a_n104_n35959.t1 vdd.t47 4.93578580247473e-06f
CMODEL4500 a_n104_n35959.t1 vdd.t45 4.88510786016038e-06f
CMODEL4501 a_n104_n35959.t1 vdd.n23 5.57823240930079e-05f
CMODEL4502 a_n104_n35959.t1 vdd.t46 0.000133127561034622f
CMODEL4503 a_n104_n35959.t1 vdd.n24 0.000143033569621039f
CMODEL4504 a_n104_n35959.t1 vdd.t44 0.000133127561034622f
CMODEL4505 a_n104_n35959.t1 vdd.n25 0.000225577589799023f
CMODEL4506 a_n104_n35959.t1 vdd.t43 0.000133415932351456f
CMODEL4507 a_n104_n35959.t1 vdd.n26 0.00120696732395729f
CMODEL4508 a_n104_n35959.t1 vdd.n27 0.000806882495099889f
CMODEL4509 a_n104_n35959.t1 vdd.n28 0.0001822604475381f
CMODEL4510 a_n104_n35959.t1 vdd.t29 1.52456957737249e-05f
CMODEL4511 a_n104_n35959.t1 vdd.t28 0.000120509325951568f
CMODEL4512 a_n104_n35959.t1 vdd.n29 2.72068911252024e-05f
CMODEL4513 a_n104_n35959.t1 vdd.n30 8.67959958946756e-06f
CMODEL4514 a_n104_n35959.t1 vdd.t38 3.99628182752773e-06f
CMODEL4515 a_n104_n35959.t1 vdd.t40 3.99628182752773e-06f
CMODEL4516 a_n104_n35959.t1 vdd.t37 8.07529061296955e-05f
CMODEL4517 a_n104_n35959.t1 vdd.t39 8.07529061296955e-05f
CMODEL4518 a_n104_n35959.t1 vdd.n31 2.61539517891589e-05f
CMODEL4519 a_n104_n35959.t1 vdd.n32 0.000315623453628501f
CMODEL4520 a_n104_n35959.t1 vdd.n33 0.000159926682549579f
CMODEL4521 a_n104_n35959.t1 vdd.t17 1.52456957737249e-05f
CMODEL4522 a_n104_n35959.t1 vdd.t16 0.000120509325951568f
CMODEL4523 a_n104_n35959.t1 vdd.n34 2.72068911252024e-05f
CMODEL4524 a_n104_n35959.t1 vdd.n35 8.67959958946756e-06f
CMODEL4525 a_n104_n35959.t1 vdd.t1 3.99628182752773e-06f
CMODEL4526 a_n104_n35959.t1 vdd.t31 3.99628182752773e-06f
CMODEL4527 a_n104_n35959.t1 vdd.t0 8.07529061296955e-05f
CMODEL4528 a_n104_n35959.t1 vdd.t30 8.07529061296955e-05f
CMODEL4529 a_n104_n35959.t1 vdd.n36 2.61539517891589e-05f
CMODEL4530 a_n104_n35959.t1 vdd.n37 0.000306092537224658f
CMODEL4531 a_n104_n35959.t1 vdd.n38 0.000176568430649886f
CMODEL4532 a_n104_n35959.t1 vdd.t19 1.52456957737249e-05f
CMODEL4533 a_n104_n35959.t1 vdd.t18 0.000120509325951568f
CMODEL4534 a_n104_n35959.t1 vdd.n39 0.000148999294877774f
CMODEL4535 a_n104_n35959.t1 vdd.t21 1.52458354208517e-05f
CMODEL4536 a_n104_n35959.t1 vdd.t20 0.000120509325951568f
CMODEL4537 a_n104_n35959.t1 vdd.n40 0.000148999294877774f
CMODEL4538 a_n104_n35959.t1 vdd.t11 1.52456957737249e-05f
CMODEL4539 a_n104_n35959.t1 vdd.t10 0.000120509325951568f
CMODEL4540 a_n104_n35959.t1 vdd.n41 0.000641022206132738f
CMODEL4541 a_n104_n35959.t1 vdd.n42 0.00122787668825249f
CMODEL4542 a_n104_n35959.t1 vdd.n43 0.000148999294877774f
CMODEL4543 a_n104_n35959.t1 vdd.t13 1.52456957737249e-05f
CMODEL4544 a_n104_n35959.t1 vdd.t12 0.000120509325951568f
CMODEL4545 a_n104_n35959.t1 vdd.n44 0.000148999294877774f
CMODEL4546 a_n104_n35959.t1 vdd.t23 1.52456957737249e-05f
CMODEL4547 a_n104_n35959.t1 vdd.t22 0.000120509325951568f
CMODEL4548 a_n104_n35959.t1 vdd.n45 0.000183933420117119f
CMODEL4549 a_n104_n35959.t1 vdd.n46 0.00303601232482613f
CMODEL4550 a_n104_n35959.n1 vdd 0.000112060889854834f
CMODEL4551 a_n104_n35959.n1 vdd.n0 0.0376055493531387f
CMODEL4552 a_n104_n35959.n1 vdd.n1 0.00348493476000771f
CMODEL4553 a_n104_n35959.n1 vdd.t7 0.00028728548213385f
CMODEL4554 a_n104_n35959.n1 vdd.t6 0.00227084288716348f
CMODEL4555 a_n104_n35959.n1 vdd.n2 0.00312508122770756f
CMODEL4556 a_n104_n35959.n1 vdd.t27 0.00028728548213385f
CMODEL4557 a_n104_n35959.n1 vdd.t26 0.00227084288716348f
CMODEL4558 a_n104_n35959.n1 vdd.n3 0.00586149432583025f
CMODEL4559 a_n104_n35959.n1 vdd.n4 0.00312508122770756f
CMODEL4560 a_n104_n35959.n1 vdd.t36 0.00028728548213385f
CMODEL4561 a_n104_n35959.n1 vdd.t35 0.00227084288716348f
CMODEL4562 a_n104_n35959.n1 vdd.n5 0.00445899972173512f
CMODEL4563 a_n104_n35959.n1 vdd.t3 0.000457628434282921f
CMODEL4564 a_n104_n35959.n1 vdd.n6 0.00437837147873931f
CMODEL4565 a_n104_n35959.n1 vdd.t2 0.00573815732357133f
CMODEL4566 a_n104_n35959.n1 vdd.n7 0.00586938873604525f
CMODEL4567 a_n104_n35959.n1 vdd.t25 0.000457628434282921f
CMODEL4568 a_n104_n35959.n1 vdd.n8 0.00264457479262159f
CMODEL4569 a_n104_n35959.n1 vdd.t24 0.00573815732357133f
CMODEL4570 a_n104_n35959.n1 vdd.n9 0.00586938873604525f
CMODEL4571 a_n104_n35959.n1 vdd.t5 0.000457628434282921f
CMODEL4572 a_n104_n35959.n1 vdd.n10 0.00783083389806268f
CMODEL4573 a_n104_n35959.n1 vdd.t4 0.00574131508765733f
CMODEL4574 a_n104_n35959.n1 vdd.n11 0.0189336376832333f
CMODEL4575 a_n104_n35959.n1 vdd.n12 0.0466833316593604f
CMODEL4576 a_n104_n35959.n1 vdd.n13 0.00353853780536752f
CMODEL4577 a_n104_n35959.n1 vdd.t42 0.00028728548213385f
CMODEL4578 a_n104_n35959.n1 vdd.t41 0.00227084288716348f
CMODEL4579 a_n104_n35959.n1 vdd.n14 0.00318142100194191f
CMODEL4580 a_n104_n35959.n1 vdd.t9 0.00028728548213385f
CMODEL4581 a_n104_n35959.n1 vdd.t8 0.00227084288716348f
CMODEL4582 a_n104_n35959.n1 vdd.n15 0.00610790518334094f
CMODEL4583 a_n104_n35959.n1 vdd.t15 0.000483816824436129f
CMODEL4584 a_n104_n35959.n1 vdd.n16 0.00380560570294077f
CMODEL4585 a_n104_n35959.n1 vdd.t14 0.00652638786883777f
CMODEL4586 a_n104_n35959.n1 vdd.n17 0.00533083207117835f
CMODEL4587 a_n104_n35959.n1 vdd.t32 0.00652638786883777f
CMODEL4588 a_n104_n35959.n1 vdd.n18 0.00526225596111077f
CMODEL4589 a_n104_n35959.n1 vdd.t34 0.000483816824436129f
CMODEL4590 a_n104_n35959.n1 vdd.n19 0.00529914917151551f
CMODEL4591 a_n104_n35959.n1 vdd.t33 0.00652638786883777f
CMODEL4592 a_n104_n35959.n1 vdd.n20 0.0105752203505025f
CMODEL4593 a_n104_n35959.n1 vdd.t48 0.00653886103697746f
CMODEL4594 a_n104_n35959.n1 vdd.n21 0.0187721706796359f
CMODEL4595 a_n104_n35959.n1 vdd.n22 0.0822665962624249f
CMODEL4596 a_n104_n35959.n1 vdd.t47 9.30085202419673e-05f
CMODEL4597 a_n104_n35959.n1 vdd.t45 9.20535597529602e-05f
CMODEL4598 a_n104_n35959.n1 vdd.n23 0.00105114598306661f
CMODEL4599 a_n104_n35959.n1 vdd.t46 0.00250861725989896f
CMODEL4600 a_n104_n35959.n1 vdd.n24 0.00269528322090257f
CMODEL4601 a_n104_n35959.n1 vdd.t44 0.00250861725989896f
CMODEL4602 a_n104_n35959.n1 vdd.n25 0.00425071886556286f
CMODEL4603 a_n104_n35959.n1 vdd.t43 0.00251405124559695f
CMODEL4604 a_n104_n35959.n1 vdd.n26 0.0227437431999966f
CMODEL4605 a_n104_n35959.n1 vdd.n27 0.0152046603887794f
CMODEL4606 a_n104_n35959.n1 vdd.n28 0.00343446316403318f
CMODEL4607 a_n104_n35959.n1 vdd.t29 0.00028728548213385f
CMODEL4608 a_n104_n35959.n1 vdd.t28 0.00227084288716348f
CMODEL4609 a_n104_n35959.n1 vdd.n29 0.000512678788182147f
CMODEL4610 a_n104_n35959.n1 vdd.n30 0.000163555864540233f
CMODEL4611 a_n104_n35959.n1 vdd.t38 7.53047790408287e-05f
CMODEL4612 a_n104_n35959.n1 vdd.t40 7.53047790408287e-05f
CMODEL4613 a_n104_n35959.n1 vdd.t37 0.00152168440952112f
CMODEL4614 a_n104_n35959.n1 vdd.t39 0.00152168440952112f
CMODEL4615 a_n104_n35959.n1 vdd.n31 0.000492837503841795f
CMODEL4616 a_n104_n35959.n1 vdd.n32 0.00594751708247297f
CMODEL4617 a_n104_n35959.n1 vdd.n33 0.00301361215547185f
CMODEL4618 a_n104_n35959.n1 vdd.t17 0.00028728548213385f
CMODEL4619 a_n104_n35959.n1 vdd.t16 0.00227084288716348f
CMODEL4620 a_n104_n35959.n1 vdd.n34 0.000512678788182147f
CMODEL4621 a_n104_n35959.n1 vdd.n35 0.000163555864540233f
CMODEL4622 a_n104_n35959.n1 vdd.t1 7.53047790408287e-05f
CMODEL4623 a_n104_n35959.n1 vdd.t31 7.53047790408287e-05f
CMODEL4624 a_n104_n35959.n1 vdd.t0 0.00152168440952112f
CMODEL4625 a_n104_n35959.n1 vdd.t30 0.00152168440952112f
CMODEL4626 a_n104_n35959.n1 vdd.n36 0.000492837503841795f
CMODEL4627 a_n104_n35959.n1 vdd.n37 0.00576791925008186f
CMODEL4628 a_n104_n35959.n1 vdd.n38 0.00332720444391213f
CMODEL4629 a_n104_n35959.n1 vdd.t19 0.00028728548213385f
CMODEL4630 a_n104_n35959.n1 vdd.t18 0.00227084288716348f
CMODEL4631 a_n104_n35959.n1 vdd.n39 0.00280769962236409f
CMODEL4632 a_n104_n35959.n1 vdd.t21 0.000287288113603922f
CMODEL4633 a_n104_n35959.n1 vdd.t20 0.00227084288716348f
CMODEL4634 a_n104_n35959.n1 vdd.n40 0.00280769962236409f
CMODEL4635 a_n104_n35959.n1 vdd.t11 0.00028728548213385f
CMODEL4636 a_n104_n35959.n1 vdd.t10 0.00227084288716348f
CMODEL4637 a_n104_n35959.n1 vdd.n41 0.0120792370699625f
CMODEL4638 a_n104_n35959.n1 vdd.n42 0.0231377532138269f
CMODEL4639 a_n104_n35959.n1 vdd.n43 0.00280769962236409f
CMODEL4640 a_n104_n35959.n1 vdd.t13 0.00028728548213385f
CMODEL4641 a_n104_n35959.n1 vdd.t12 0.00227084288716348f
CMODEL4642 a_n104_n35959.n1 vdd.n44 0.00280769962236409f
CMODEL4643 a_n104_n35959.n1 vdd.t23 0.00028728548213385f
CMODEL4644 a_n104_n35959.n1 vdd.t22 0.00227084288716348f
CMODEL4645 a_n104_n35959.n1 vdd.n45 0.00346598817549173f
CMODEL4646 a_n104_n35959.n1 vdd.n46 0.0572097382400336f
CMODEL4647 a_12800_83.t1 a_1600_n11917.t5 6.19212929993385e-06f
CMODEL4648 a_12800_83.t1 a_1600_n11917.t4 9.84255371236171e-06f
CMODEL4649 a_12800_83.t1 a_1600_n11917.n0 0.000171347696526756f
CMODEL4650 a_12800_83.t1 a_1600_n11917.t6 1.8170679062015e-05f
CMODEL4651 a_12800_83.t1 a_1600_n11917.n1 0.00100945972053039f
CMODEL4652 a_12800_83.t1 a_1600_n11917.t2 1.26916994965932e-06f
CMODEL4653 a_12800_83.t1 a_1600_n11917.t3 1.26916994965932e-06f
CMODEL4654 a_12800_83.t1 a_1600_n11917.n2 0.000307875112450072f
CMODEL4655 a_12800_83.t1 a_1600_n11917.t1 4.48384675966294e-06f
CMODEL4656 a_12800_83.t1 a_1600_n11917.t0 6.16285096384947e-06f
CMODEL4657 a_12800_83.t1 a_1600_n11917.n3 0.000854280865715279f
CMODEL4658 a_12800_83.t1 a_1600_n11917.n4 0.00125251031927755f
CMODEL4659 a_12800_83.n0 a_1600_n11917.t5 8.62307771163947e-05f
CMODEL4660 a_12800_83.n0 a_1600_n11917.t4 0.000137066106716452f
CMODEL4661 a_12800_83.n0 a_1600_n11917.n0 0.00238616545503405f
CMODEL4662 a_12800_83.n0 a_1600_n11917.t6 0.000253042483506746f
CMODEL4663 a_12800_83.n0 a_1600_n11917.n1 0.0140576031204588f
CMODEL4664 a_12800_83.n0 a_1600_n11917.t2 1.76742935670073e-05f
CMODEL4665 a_12800_83.n0 a_1600_n11917.t3 1.76742935670073e-05f
CMODEL4666 a_12800_83.n0 a_1600_n11917.n2 0.00428742826827771f
CMODEL4667 a_12800_83.n0 a_1600_n11917.t1 6.24414594444425e-05f
CMODEL4668 a_12800_83.n0 a_1600_n11917.t0 8.58230508640927e-05f
CMODEL4669 a_12800_83.n0 a_1600_n11917.n3 0.0118966028256357f
CMODEL4670 a_12800_83.n0 a_1600_n11917.n4 0.0174422937484139f
CMODEL4671 a_12800_83.t0 a_1600_n11917.t5 1.40576636211254e-06f
CMODEL4672 a_12800_83.t0 a_1600_n11917.t4 2.23450290779164e-06f
CMODEL4673 a_12800_83.t0 a_1600_n11917.n0 3.89001612103538e-05f
CMODEL4674 a_12800_83.t0 a_1600_n11917.t6 4.12519315486455e-06f
CMODEL4675 a_12800_83.t0 a_1600_n11917.n1 0.000229172300882721f
CMODEL4676 a_12800_83.t0 a_1600_n11917.t2 2.88132940482072e-07f
CMODEL4677 a_12800_83.t0 a_1600_n11917.t3 2.88132940482072e-07f
CMODEL4678 a_12800_83.t0 a_1600_n11917.n2 6.98952582948407e-05f
CMODEL4679 a_12800_83.t0 a_1600_n11917.t1 1.01794401284043e-06f
CMODEL4680 a_12800_83.t0 a_1600_n11917.t0 1.3991194563371e-06f
CMODEL4681 a_12800_83.t0 a_1600_n11917.n3 0.000193942866282161f
CMODEL4682 a_12800_83.t0 a_1600_n11917.n4 0.000284350792716495f
CMODEL4683 a_12800_83.t2 a_1600_n11917.t5 1.38641544774133e-06f
CMODEL4684 a_12800_83.t2 a_1600_n11917.t4 2.20374411629095e-06f
CMODEL4685 a_12800_83.t2 a_1600_n11917.n0 3.83646855375138e-05f
CMODEL4686 a_12800_83.t2 a_1600_n11917.t6 4.06840828530447e-06f
CMODEL4687 a_12800_83.t2 a_1600_n11917.n1 0.000226017656063954f
CMODEL4688 a_12800_83.t2 a_1600_n11917.t2 2.84166679793905e-07f
CMODEL4689 a_12800_83.t2 a_1600_n11917.t3 2.84166679793905e-07f
CMODEL4690 a_12800_83.t2 a_1600_n11917.n2 6.89331231956732e-05f
CMODEL4691 a_12800_83.t2 a_1600_n11917.t1 1.00393162219142e-06f
CMODEL4692 a_12800_83.t2 a_1600_n11917.t0 1.37986003917904e-06f
CMODEL4693 a_12800_83.t2 a_1600_n11917.n3 0.00019127316817337f
CMODEL4694 a_12800_83.t2 a_1600_n11917.n4 0.000280436594746232f
CMODEL4695 a_12800_83.t3 a_1600_n11917.t5 1.38641544774133e-06f
CMODEL4696 a_12800_83.t3 a_1600_n11917.t4 2.20374411629095e-06f
CMODEL4697 a_12800_83.t3 a_1600_n11917.n0 3.83646855375138e-05f
CMODEL4698 a_12800_83.t3 a_1600_n11917.t6 4.06840828530447e-06f
CMODEL4699 a_12800_83.t3 a_1600_n11917.n1 0.000226017656063954f
CMODEL4700 a_12800_83.t3 a_1600_n11917.t2 2.84166679793905e-07f
CMODEL4701 a_12800_83.t3 a_1600_n11917.t3 2.84166679793905e-07f
CMODEL4702 a_12800_83.t3 a_1600_n11917.n2 6.89331231956732e-05f
CMODEL4703 a_12800_83.t3 a_1600_n11917.t1 1.00393162219142e-06f
CMODEL4704 a_12800_83.t3 a_1600_n11917.t0 1.37986003917904e-06f
CMODEL4705 a_12800_83.t3 a_1600_n11917.n3 0.00019127316817337f
CMODEL4706 a_12800_83.t3 a_1600_n11917.n4 0.000280436594746232f
CMODEL4707 a_12800_83.n1 a_1600_n11917.t5 0.000582593161657982f
CMODEL4708 a_12800_83.n1 a_1600_n11917.t4 0.000926047278459538f
CMODEL4709 a_12800_83.n1 a_1600_n11917.n0 0.0161214327781239f
CMODEL4710 a_12800_83.n1 a_1600_n11917.t6 0.00170960793152767f
CMODEL4711 a_12800_83.n1 a_1600_n11917.n1 0.0949761062251181f
CMODEL4712 a_12800_83.n1 a_1600_n11917.t2 0.000119411223157311f
CMODEL4713 a_12800_83.n1 a_1600_n11917.t3 0.000119411223157311f
CMODEL4714 a_12800_83.n1 a_1600_n11917.n2 0.0289667619117724f
CMODEL4715 a_12800_83.n1 a_1600_n11917.t1 0.000421867556953282f
CMODEL4716 a_12800_83.n1 a_1600_n11917.t0 0.000579838477839014f
CMODEL4717 a_12800_83.n1 a_1600_n11917.n3 0.0803759363529923f
CMODEL4718 a_12800_83.n1 a_1600_n11917.n4 0.117843783870106f
CMODEL4719 a a_0_83.t1 0.000190214864792352f
CMODEL4720 a a_0_83.n0 0.00187920746338638f
CMODEL4721 a a_0_83.t0 4.31834636123178e-05f
CMODEL4722 a a_0_83.t2 0.000198008550813334f
CMODEL4723 a a_0_83.t3 8.5086814869937e-05f
CMODEL4724 a.t3 a_0_83.t1 0.00107084470155443f
CMODEL4725 a.t3 a_0_83.n0 0.0105792959844942f
CMODEL4726 a.t3 a_0_83.t0 0.000243108146434823f
CMODEL4727 a.t3 a_0_83.t2 0.0011147204911267f
CMODEL4728 a.t3 a_0_83.t3 0.000479009697665217f
CMODEL4729 a.t0 a_0_83.t1 0.00110800293850124f
CMODEL4730 a.t0 a_0_83.n0 0.0109463968221336f
CMODEL4731 a.t0 a_0_83.t0 0.000251543982271534f
CMODEL4732 a.t0 a_0_83.t2 0.00115340121493158f
CMODEL4733 a.t0 a_0_83.t3 0.000495631300984379f
CMODEL4734 a.n0 a_0_83.t1 0.0676484151567252f
CMODEL4735 a.n0 a_0_83.n0 0.66832530037836f
CMODEL4736 a.n0 a_0_83.t0 0.0153578579546895f
CMODEL4737 a.n0 a_0_83.t2 0.0704201780687565f
CMODEL4738 a.n0 a_0_83.t3 0.0302604540553044f
CMODEL4739 a.t2 a_0_83.t1 0.00211370616458279f
CMODEL4740 a.t2 a_0_83.n0 0.0208821345493997f
CMODEL4741 a.t2 a_0_83.t0 0.000479863407862657f
CMODEL4742 a.t2 a_0_83.t2 0.00220031118467601f
CMODEL4743 a.t2 a_0_83.t3 0.000945501947556157f
CMODEL4744 a.t1 a_0_83.t1 0.00129821329967429f
CMODEL4745 a.t1 a_0_83.n0 0.0128255597924935f
CMODEL4746 a.t1 a_0_83.t0 0.000294726423451244f
CMODEL4747 a.t1 a_0_83.t2 0.00135140507759853f
CMODEL4748 a.t1 a_0_83.t3 0.000580716101297661f
CMODEL4749 a_1600_n11917.t5 a_20800_n23917.t0 0.000434201742157136f
CMODEL4750 a_1600_n11917.t5 a_20800_n23917.t1 0.000434037540441041f
CMODEL4751 a_1600_n11917.t4 a_20800_n23917.t0 0.000690175182425259f
CMODEL4752 a_1600_n11917.t4 a_20800_n23917.t1 0.000689914179443564f
CMODEL4753 a_1600_n11917.n0 a_20800_n23917.t0 0.012015167116637f
CMODEL4754 a_1600_n11917.n0 a_20800_n23917.t1 0.0120106233507601f
CMODEL4755 a_1600_n11917.t6 a_20800_n23917.t0 0.00127415629143748f
CMODEL4756 a_1600_n11917.t6 a_20800_n23917.t1 0.00127367444479959f
CMODEL4757 a_1600_n11917.n1 a_20800_n23917.t0 0.0707848864358233f
CMODEL4758 a_1600_n11917.n1 a_20800_n23917.t1 0.0707581177734762f
CMODEL4759 a_1600_n11917.t2 a_20800_n23917.t0 8.89961718405083e-05f
CMODEL4760 a_1600_n11917.t2 a_20800_n23917.t1 8.8962516231322e-05f
CMODEL4761 a_1600_n11917.t3 a_20800_n23917.t0 8.89961718405083e-05f
CMODEL4762 a_1600_n11917.t3 a_20800_n23917.t1 8.8962516231322e-05f
CMODEL4763 a_1600_n11917.n2 a_20800_n23917.t0 0.0215886819731095f
CMODEL4764 a_1600_n11917.n2 a_20800_n23917.t1 0.0215805177989848f
CMODEL4765 a_1600_n11917.t1 a_20800_n23917.t0 0.000314414312154637f
CMODEL4766 a_1600_n11917.t1 a_20800_n23917.t1 0.00031429541035253f
CMODEL4767 a_1600_n11917.t0 a_20800_n23917.t0 0.000432148699670533f
CMODEL4768 a_1600_n11917.t0 a_20800_n23917.t1 0.000431985274351829f
CMODEL4769 a_1600_n11917.n3 a_20800_n23917.t0 0.0599035036605329f
CMODEL4770 a_1600_n11917.n3 a_20800_n23917.t1 0.0598808500017698f
CMODEL4771 a_1600_n11917.n4 a_20800_n23917.t0 0.0878279726338907f
CMODEL4772 a_1600_n11917.n4 a_20800_n23917.t1 0.0877947588016385f
CMODEL4773 a_16000_n24000.t0 a_1600_n11917.t5 0.000516913229453078f
CMODEL4774 a_16000_n24000.t0 a_1600_n11917.t4 0.000821647284654832f
CMODEL4775 a_16000_n24000.t0 a_1600_n11917.n0 0.0143039472983773f
CMODEL4776 a_16000_n24000.t0 a_1600_n11917.t6 0.00151687148965089f
CMODEL4777 a_16000_n24000.t0 a_1600_n11917.n1 0.0842687642436247f
CMODEL4778 a_16000_n24000.t0 a_1600_n11917.t2 0.000105949134074155f
CMODEL4779 a_16000_n24000.t0 a_1600_n11917.t3 0.000105949134074155f
CMODEL4780 a_16000_n24000.t0 a_1600_n11917.n2 0.0257011297626644f
CMODEL4781 a_16000_n24000.t0 a_1600_n11917.t1 0.00037430738226588f
CMODEL4782 a_16000_n24000.t0 a_1600_n11917.t0 0.000514469101024017f
CMODEL4783 a_16000_n24000.t0 a_1600_n11917.n3 0.0713145769035498f
CMODEL4784 a_16000_n24000.t0 a_1600_n11917.n4 0.104558403531396f
CMODEL4785 a_16000_n24000.t1 a_1600_n11917.t5 0.000516811484724863f
CMODEL4786 a_16000_n24000.t1 a_1600_n11917.t4 0.000821485558711477f
CMODEL4787 a_16000_n24000.t1 a_1600_n11917.n0 0.014301131833136f
CMODEL4788 a_16000_n24000.t1 a_1600_n11917.t6 0.00151657292178948f
CMODEL4789 a_16000_n24000.t1 a_1600_n11917.n1 0.0842521775090889f
CMODEL4790 a_16000_n24000.t1 a_1600_n11917.t2 0.000105928279963181f
CMODEL4791 a_16000_n24000.t1 a_1600_n11917.t3 0.000105928279963181f
CMODEL4792 a_16000_n24000.t1 a_1600_n11917.n2 0.0256960709746251f
CMODEL4793 a_16000_n24000.t1 a_1600_n11917.t1 0.000374233706838927f
CMODEL4794 a_16000_n24000.t1 a_1600_n11917.t0 0.000514367837376898f
CMODEL4795 a_16000_n24000.t1 a_1600_n11917.n3 0.071300539959182f
CMODEL4796 a_16000_n24000.t1 a_1600_n11917.n4 0.104537823159791f
CMODEL4797 a_0_n11917.t2 we 2.43245171789966e-07f
CMODEL4798 a_0_n11917.t2 we.t1 1.39071831199916e-06f
CMODEL4799 a_0_n11917.t2 we.t3 1.41690645698264e-06f
CMODEL4800 a_0_n11917.t2 we.n0 4.84143472435515e-05f
CMODEL4801 a_0_n11917.t2 we.t0 1.71734947440475e-06f
CMODEL4802 a_0_n11917.t2 we.n1 0.000132212739955411f
CMODEL4803 a_0_n11917.t2 we.t2 2.58433208106969e-06f
CMODEL4804 a_0_n11917.t1 we 3.80523356435402e-07f
CMODEL4805 a_0_n11917.t1 we.t1 2.17558603956605e-06f
CMODEL4806 a_0_n11917.t1 we.t3 2.21655376260285e-06f
CMODEL4807 a_0_n11917.t1 we.n0 7.57375358251826e-05f
CMODEL4808 a_0_n11917.t1 we.t0 2.68655522066163e-06f
CMODEL4809 a_0_n11917.t1 we.n1 0.000206828506404209f
CMODEL4810 a_0_n11917.t1 we.t2 4.04282934126009e-06f
CMODEL4811 a_0_n11917.n0 we 1.03761829496055e-05f
CMODEL4812 a_0_n11917.n0 we.t1 5.93242921554469e-05f
CMODEL4813 a_0_n11917.n0 we.t3 6.04414077859846e-05f
CMODEL4814 a_0_n11917.n0 we.n0 0.00206522547061525f
CMODEL4815 a_0_n11917.n0 we.t0 7.32574965566803e-05f
CMODEL4816 a_0_n11917.n0 we.n1 0.00563983888334079f
CMODEL4817 a_0_n11917.n0 we.t2 0.000110240636138374f
CMODEL4818 a_0_n11917.t6 we 6.48315130080159e-07f
CMODEL4819 a_0_n11917.t6 we.t1 3.70664591906932e-06f
CMODEL4820 a_0_n11917.t6 we.t3 3.77644451156177e-06f
CMODEL4821 a_0_n11917.t6 we.n0 0.000129037520457143f
CMODEL4822 a_0_n11917.t6 we.t0 4.57720759552496e-06f
CMODEL4823 a_0_n11917.t6 we.n1 0.00035238323158356f
CMODEL4824 a_0_n11917.t6 we.t2 6.88795414511137e-06f
CMODEL4825 a_0_n11917.n1 we 4.02264197159785e-05f
CMODEL4826 a_0_n11917.n1 we.t1 0.000229988608256861f
CMODEL4827 a_0_n11917.n1 we.t3 0.000234319445756887f
CMODEL4828 a_0_n11917.n1 we.n0 0.00800647280339795f
CMODEL4829 a_0_n11917.n1 we.t0 0.000284004900274325f
CMODEL4830 a_0_n11917.n1 we.n1 0.0218645456767305f
CMODEL4831 a_0_n11917.n1 we.t2 0.000427381255765858f
CMODEL4832 a_0_n11917.t4 we 5.14680474546524e-08f
CMODEL4833 a_0_n11917.t4 we.t1 2.94260953059457e-07f
CMODEL4834 a_0_n11917.t4 we.t3 2.99802081291687e-07f
CMODEL4835 a_0_n11917.t4 we.n0 1.02439522358483e-05f
CMODEL4836 a_0_n11917.t4 we.t0 3.63372574240472e-07f
CMODEL4837 a_0_n11917.t4 we.n1 2.79747857853078e-05f
CMODEL4838 a_0_n11917.t4 we.t2 5.46816716682563e-07f
CMODEL4839 a_0_n11917.t5 we 5.19637014567342e-08f
CMODEL4840 a_0_n11917.t5 we.t1 2.97094781546322e-07f
CMODEL4841 a_0_n11917.t5 we.t3 3.02689272641925e-07f
CMODEL4842 a_0_n11917.t5 we.n0 1.03426048207809e-05f
CMODEL4843 a_0_n11917.t5 we.t0 3.66871970071017e-07f
CMODEL4844 a_0_n11917.t5 we.n1 2.8244192052256e-05f
CMODEL4845 a_0_n11917.t5 we.t2 5.5208273914568e-07f
CMODEL4846 a_0_n11917.n2 we 1.30681904202856e-05f
CMODEL4847 a_0_n11917.n2 we.t1 7.47154469231394e-05f
CMODEL4848 a_0_n11917.n2 we.t3 7.61223881704406e-05f
CMODEL4849 a_0_n11917.n2 we.n0 0.00260102966976407f
CMODEL4850 a_0_n11917.n2 we.t0 9.22634960626355e-05f
CMODEL4851 a_0_n11917.n2 we.n1 0.00710304442637361f
CMODEL4852 a_0_n11917.n2 we.t2 0.000138841579037931f
CMODEL4853 a_0_n11917.t0 we 1.02999308311537e-07f
CMODEL4854 a_0_n11917.t0 we.t1 5.88883319401658e-07f
CMODEL4855 a_0_n11917.t0 we.t3 5.99972381517101e-07f
CMODEL4856 a_0_n11917.t0 we.n0 2.05004861627682e-05f
CMODEL4857 a_0_n11917.t0 we.t0 7.27191445121902e-07f
CMODEL4858 a_0_n11917.t0 we.n1 5.59839303907703e-05f
CMODEL4859 a_0_n11917.t0 we.t2 1.0943050373363e-06f
CMODEL4860 a_0_n11917.t3 we 1.84973077433349e-07f
CMODEL4861 a_0_n11917.t3 we.t1 1.05755622658574e-06f
CMODEL4862 a_0_n11917.t3 we.t3 1.07747070930381e-06f
CMODEL4863 a_0_n11917.t3 we.n0 3.68161502884798e-05f
CMODEL4864 a_0_n11917.t3 we.t0 1.30593925039335e-06f
CMODEL4865 a_0_n11917.t3 we.n1 0.000100539703236388f
CMODEL4866 a_0_n11917.t3 we.t2 1.96522650224669e-06f
CMODEL4867 a_0_n11917.n3 we 2.86789305033709e-05f
CMODEL4868 a_0_n11917.n3 we.t1 0.000163967545691011f
CMODEL4869 a_0_n11917.n3 we.t3 0.000167055162947571f
CMODEL4870 a_0_n11917.n3 we.n0 0.00570811617655777f
CMODEL4871 a_0_n11917.n3 we.t0 0.0002024777958141f
CMODEL4872 a_0_n11917.n3 we.n1 0.015588058554007f
CMODEL4873 a_0_n11917.n3 we.t2 0.000304696202622373f
CMODEL4874 a_0_n11917.n4 we 5.2239555604789e-05f
CMODEL4875 a_0_n11917.n4 we.t1 0.000298671936859695f
CMODEL4876 a_0_n11917.n4 we.t3 0.000304296126832238f
CMODEL4877 a_0_n11917.n4 we.n0 0.0103975095015777f
CMODEL4878 a_0_n11917.n4 we.t0 0.00036881954408734f
CMODEL4879 a_0_n11917.n4 we.n1 0.028394128975871f
CMODEL4880 a_0_n11917.n4 we.t2 0.000555013521776505f
CMODEL4881 a_20000_6483.t1 a_6400_83.t1 9.02668354587427e-06f
CMODEL4882 a_20000_6483.t1 a_6400_83.n0 0.000101829478820024f
CMODEL4883 a_20000_6483.t1 a_6400_83.t0 2.04927536704887e-06f
CMODEL4884 a_20000_6483.t1 a_6400_83.t3 2.0210714065605e-06f
CMODEL4885 a_20000_6483.t1 a_6400_83.t2 2.0210714065605e-06f
CMODEL4886 a_20000_6483.t1 a_6400_83.n1 0.000744267548298841f
CMODEL4887 a_20000_6483.t0 a_6400_83.t1 4.27378087787204e-06f
CMODEL4888 a_20000_6483.t0 a_6400_83.n0 4.82122672377945e-05f
CMODEL4889 a_20000_6483.t0 a_6400_83.t0 9.70251569436117e-07f
CMODEL4890 a_20000_6483.t0 a_6400_83.t3 9.56898099537357e-07f
CMODEL4891 a_20000_6483.t0 a_6400_83.t2 9.56898099537357e-07f
CMODEL4892 a_20000_6483.t0 a_6400_83.n1 0.000352381514182374f
CMODEL4893 a_20000_6483.n0 a_6400_83.t1 1.16005150107074e-05f
CMODEL4894 a_20000_6483.n0 a_6400_83.n0 0.00013086471809728f
CMODEL4895 a_20000_6483.n0 a_6400_83.t0 2.63359732682652e-06f
CMODEL4896 a_20000_6483.n0 a_6400_83.t3 2.5973514049058e-06f
CMODEL4897 a_20000_6483.n0 a_6400_83.t2 2.5973514049058e-06f
CMODEL4898 a_20000_6483.n0 a_6400_83.n1 0.000956484939584407f
CMODEL4899 a_20000_6483.t2 a_6400_83.t1 3.87469031469305e-06f
CMODEL4900 a_20000_6483.t2 a_6400_83.n0 4.37101503923358e-05f
CMODEL4901 a_20000_6483.t2 a_6400_83.t0 8.79648364373259e-07f
CMODEL4902 a_20000_6483.t2 a_6400_83.t3 8.67541856818752e-07f
CMODEL4903 a_20000_6483.t2 a_6400_83.t2 8.67541856818752e-07f
CMODEL4904 a_20000_6483.t2 a_6400_83.n1 0.000319475723977489f
CMODEL4905 a_20000_6483.t3 a_6400_83.t1 4.0817966201319e-06f
CMODEL4906 a_20000_6483.t3 a_6400_83.n0 4.6046504274246e-05f
CMODEL4907 a_20000_6483.t3 a_6400_83.t0 9.26666502091217e-07f
CMODEL4908 a_20000_6483.t3 a_6400_83.t3 9.13912888872065e-07f
CMODEL4909 a_20000_6483.t3 a_6400_83.t2 9.13912888872065e-07f
CMODEL4910 a_20000_6483.t3 a_6400_83.n1 0.000336552040146416f
CMODEL4911 a_20000_6483.t4 a_6400_83.t1 3.99258334023022e-06f
CMODEL4912 a_20000_6483.t4 a_6400_83.n0 4.50400945834614e-05f
CMODEL4913 a_20000_6483.t4 a_6400_83.t0 9.06412930999792e-07f
CMODEL4914 a_20000_6483.t4 a_6400_83.t3 8.93938065540944e-07f
CMODEL4915 a_20000_6483.t4 a_6400_83.t2 8.93938065540944e-07f
CMODEL4916 a_20000_6483.t4 a_6400_83.n1 0.000329196232360458f
CMODEL4917 a_20000_6483.n1 a_6400_83.t1 0.000101753016906415f
CMODEL4918 a_20000_6483.n1 a_6400_83.n0 0.00114786971619062f
CMODEL4919 a_20000_6483.n1 a_6400_83.t0 2.31003945147195e-05f
CMODEL4920 a_20000_6483.n1 a_6400_83.t3 2.27824662242443e-05f
CMODEL4921 a_20000_6483.n1 a_6400_83.t2 2.27824662242443e-05f
CMODEL4922 a_20000_6483.n1 a_6400_83.n1 0.00838973339876987f
CMODEL4923 a_1600_n11917.t5 vdd 6.01005004455446e-06f
CMODEL4924 a_1600_n11917.t5 vdd.n0 0.00201686095709311f
CMODEL4925 a_1600_n11917.t5 vdd.n1 0.000186904033483813f
CMODEL4926 a_1600_n11917.t5 vdd.t7 1.54076960029058e-05f
CMODEL4927 a_1600_n11917.t5 vdd.t6 0.000121789853827261f
CMODEL4928 a_1600_n11917.t5 vdd.n2 0.000167604367555448f
CMODEL4929 a_1600_n11917.t5 vdd.t27 1.54076960029058e-05f
CMODEL4930 a_1600_n11917.t5 vdd.t26 0.000121789853827261f
CMODEL4931 a_1600_n11917.t5 vdd.n3 0.000314363684598139f
CMODEL4932 a_1600_n11917.t5 vdd.n4 0.000167604367555448f
CMODEL4933 a_1600_n11917.t5 vdd.t36 1.54076960029058e-05f
CMODEL4934 a_1600_n11917.t5 vdd.t35 0.000121789853827261f
CMODEL4935 a_1600_n11917.t5 vdd.n5 0.000239145088986873f
CMODEL4936 a_1600_n11917.t5 vdd.t3 2.45435298203891e-05f
CMODEL4937 a_1600_n11917.t5 vdd.n6 0.000234820834770821f
CMODEL4938 a_1600_n11917.t5 vdd.t2 0.000307748874052893f
CMODEL4939 a_1600_n11917.t5 vdd.n7 0.000314787077634959f
CMODEL4940 a_1600_n11917.t5 vdd.t25 2.45435298203891e-05f
CMODEL4941 a_1600_n11917.t5 vdd.n8 0.000141833844714355f
CMODEL4942 a_1600_n11917.t5 vdd.t24 0.000307748874052893f
CMODEL4943 a_1600_n11917.t5 vdd.n9 0.000314787077634959f
CMODEL4944 a_1600_n11917.t5 vdd.t5 2.45435298203891e-05f
CMODEL4945 a_1600_n11917.t5 vdd.n10 0.000419983311563182f
CMODEL4946 a_1600_n11917.t5 vdd.t4 0.00030791823126762f
CMODEL4947 a_1600_n11917.t5 vdd.n11 0.0010154489237869f
CMODEL4948 a_1600_n11917.t5 vdd.n12 0.00250372061013209f
CMODEL4949 a_1600_n11917.t5 vdd.n13 0.000189778872203818f
CMODEL4950 a_1600_n11917.t5 vdd.t42 1.54076960029058e-05f
CMODEL4951 a_1600_n11917.t5 vdd.t41 0.000121789853827261f
CMODEL4952 a_1600_n11917.t5 vdd.n14 0.000170625982528218f
CMODEL4953 a_1600_n11917.t5 vdd.t9 1.54076960029058e-05f
CMODEL4954 a_1600_n11917.t5 vdd.t8 0.000121789853827261f
CMODEL4955 a_1600_n11917.t5 vdd.n15 0.000327579192587405f
CMODEL4956 a_1600_n11917.t5 vdd.t15 2.59480656545324e-05f
CMODEL4957 a_1600_n11917.t5 vdd.n16 0.000204102258639429f
CMODEL4958 a_1600_n11917.t5 vdd.t14 0.000350023257469217f
CMODEL4959 a_1600_n11917.t5 vdd.n17 0.000285903204663118f
CMODEL4960 a_1600_n11917.t5 vdd.t32 0.000350023257469217f
CMODEL4961 a_1600_n11917.t5 vdd.n18 0.000282225330483278f
CMODEL4962 a_1600_n11917.t5 vdd.t34 2.59480656545324e-05f
CMODEL4963 a_1600_n11917.t5 vdd.n19 0.000284203987275349f
CMODEL4964 a_1600_n11917.t5 vdd.t33 0.000350023257469217f
CMODEL4965 a_1600_n11917.t5 vdd.n20 0.000567170255573061f
CMODEL4966 a_1600_n11917.t5 vdd.t48 0.000350692218467392f
CMODEL4967 a_1600_n11917.t5 vdd.n21 0.00100678912487382f
CMODEL4968 a_1600_n11917.t5 vdd.n22 0.00441212238429322f
CMODEL4969 a_1600_n11917.t5 vdd.t47 4.98823328949379e-06f
CMODEL4970 a_1600_n11917.t5 vdd.t45 4.93701684513984e-06f
CMODEL4971 a_1600_n11917.t5 vdd.n23 5.63750651145681e-05f
CMODEL4972 a_1600_n11917.t5 vdd.t46 0.000134542169834246f
CMODEL4973 a_1600_n11917.t5 vdd.n24 0.00014455343932086f
CMODEL4974 a_1600_n11917.t5 vdd.t44 0.000134542169834246f
CMODEL4975 a_1600_n11917.t5 vdd.n25 0.000227974569365447f
CMODEL4976 a_1600_n11917.t5 vdd.t43 0.000134833605374591f
CMODEL4977 a_1600_n11917.t5 vdd.n26 0.00121979251645732f
CMODEL4978 a_1600_n11917.t5 vdd.n27 0.000815456400224872f
CMODEL4979 a_1600_n11917.t5 vdd.n28 0.000184197140668412f
CMODEL4980 a_1600_n11917.t5 vdd.t29 1.54076960029058e-05f
CMODEL4981 a_1600_n11917.t5 vdd.t28 0.000121789853827261f
CMODEL4982 a_1600_n11917.t5 vdd.n29 2.74959905971452e-05f
CMODEL4983 a_1600_n11917.t5 vdd.n30 8.77182871062816e-06f
CMODEL4984 a_1600_n11917.t5 vdd.t38 4.03874617822315e-06f
CMODEL4985 a_1600_n11917.t5 vdd.t40 4.03874617822315e-06f
CMODEL4986 a_1600_n11917.t5 vdd.t37 8.16109836811697e-05f
CMODEL4987 a_1600_n11917.t5 vdd.t39 8.16109836811697e-05f
CMODEL4988 a_1600_n11917.t5 vdd.n31 2.6431862764605e-05f
CMODEL4989 a_1600_n11917.t5 vdd.n32 0.000318977257389351f
CMODEL4990 a_1600_n11917.t5 vdd.n33 0.000161626057875554f
CMODEL4991 a_1600_n11917.t5 vdd.t17 1.54076960029058e-05f
CMODEL4992 a_1600_n11917.t5 vdd.t16 0.000121789853827261f
CMODEL4993 a_1600_n11917.t5 vdd.n34 2.74959905971452e-05f
CMODEL4994 a_1600_n11917.t5 vdd.n35 8.77182871062816e-06f
CMODEL4995 a_1600_n11917.t5 vdd.t1 4.03874617822315e-06f
CMODEL4996 a_1600_n11917.t5 vdd.t31 4.03874617822315e-06f
CMODEL4997 a_1600_n11917.t5 vdd.t0 8.16109836811697e-05f
CMODEL4998 a_1600_n11917.t5 vdd.t30 8.16109836811697e-05f
CMODEL4999 a_1600_n11917.t5 vdd.n36 2.6431862764605e-05f
CMODEL5000 a_1600_n11917.t5 vdd.n37 0.000309345065801703f
CMODEL5001 a_1600_n11917.t5 vdd.n38 0.000178444640608155f
CMODEL5002 a_1600_n11917.t5 vdd.t19 1.54076960029058e-05f
CMODEL5003 a_1600_n11917.t5 vdd.t18 0.000121789853827261f
CMODEL5004 a_1600_n11917.t5 vdd.n39 0.000150582556165173f
CMODEL5005 a_1600_n11917.t5 vdd.t21 1.54078371339181e-05f
CMODEL5006 a_1600_n11917.t5 vdd.t20 0.000121789853827261f
CMODEL5007 a_1600_n11917.t5 vdd.n40 0.000150582556165173f
CMODEL5008 a_1600_n11917.t5 vdd.t11 1.54076960029058e-05f
CMODEL5009 a_1600_n11917.t5 vdd.t10 0.000121789853827261f
CMODEL5010 a_1600_n11917.t5 vdd.n41 0.000647833685637829f
CMODEL5011 a_1600_n11917.t5 vdd.n42 0.00124092406292499f
CMODEL5012 a_1600_n11917.t5 vdd.n43 0.000150582556165173f
CMODEL5013 a_1600_n11917.t5 vdd.t13 1.54076960029058e-05f
CMODEL5014 a_1600_n11917.t5 vdd.t12 0.000121789853827261f
CMODEL5015 a_1600_n11917.t5 vdd.n44 0.000150582556165173f
CMODEL5016 a_1600_n11917.t5 vdd.t23 1.54076960029058e-05f
CMODEL5017 a_1600_n11917.t5 vdd.t22 0.000121789853827261f
CMODEL5018 a_1600_n11917.t5 vdd.n45 0.000185887890195445f
CMODEL5019 a_1600_n11917.t5 vdd.n46 0.00306827288542748f
CMODEL5020 a_1600_n11917.t4 vdd 9.55313390793392e-06f
CMODEL5021 a_1600_n11917.t4 vdd.n0 0.00320585397025967f
CMODEL5022 a_1600_n11917.t4 vdd.n1 0.000297088917158291f
CMODEL5023 a_1600_n11917.t4 vdd.t7 2.44909413461314e-05f
CMODEL5024 a_1600_n11917.t4 vdd.t6 0.00019358820203065f
CMODEL5025 a_1600_n11917.t4 vdd.n2 0.00026641158641641f
CMODEL5026 a_1600_n11917.t4 vdd.t27 2.44909413461314e-05f
CMODEL5027 a_1600_n11917.t4 vdd.t26 0.00019358820203065f
CMODEL5028 a_1600_n11917.t4 vdd.n3 0.000499689412316725f
CMODEL5029 a_1600_n11917.t4 vdd.n4 0.00026641158641641f
CMODEL5030 a_1600_n11917.t4 vdd.t36 2.44909413461314e-05f
CMODEL5031 a_1600_n11917.t4 vdd.t35 0.00019358820203065f
CMODEL5032 a_1600_n11917.t4 vdd.n5 0.000380127460100997f
CMODEL5033 a_1600_n11917.t4 vdd.t3 3.90125914442245e-05f
CMODEL5034 a_1600_n11917.t4 vdd.n6 0.000373253943362926f
CMODEL5035 a_1600_n11917.t4 vdd.t2 0.000489174995557149f
CMODEL5036 a_1600_n11917.t4 vdd.n7 0.000500362406775413f
CMODEL5037 a_1600_n11917.t4 vdd.t25 3.90125914442245e-05f
CMODEL5038 a_1600_n11917.t4 vdd.n8 0.000225448657030906f
CMODEL5039 a_1600_n11917.t4 vdd.t24 0.000489174995557149f
CMODEL5040 a_1600_n11917.t4 vdd.n9 0.000500362406775413f
CMODEL5041 a_1600_n11917.t4 vdd.t5 3.90125914442245e-05f
CMODEL5042 a_1600_n11917.t4 vdd.n10 0.000667574609981145f
CMODEL5043 a_1600_n11917.t4 vdd.t4 0.000489444193340624f
CMODEL5044 a_1600_n11917.t4 vdd.n11 0.00161408298994003f
CMODEL5045 a_1600_n11917.t4 vdd.n12 0.00397973029830552f
CMODEL5046 a_1600_n11917.t4 vdd.n13 0.000301658549532786f
CMODEL5047 a_1600_n11917.t4 vdd.t42 2.44909413461314e-05f
CMODEL5048 a_1600_n11917.t4 vdd.t41 0.00019358820203065f
CMODEL5049 a_1600_n11917.t4 vdd.n14 0.000271214523536583f
CMODEL5050 a_1600_n11917.t4 vdd.t9 2.44909413461314e-05f
CMODEL5051 a_1600_n11917.t4 vdd.t8 0.00019358820203065f
CMODEL5052 a_1600_n11917.t4 vdd.n15 0.000520695812687253f
CMODEL5053 a_1600_n11917.t4 vdd.t15 4.12451383951803e-05f
CMODEL5054 a_1600_n11917.t4 vdd.n16 0.000324425952070216f
CMODEL5055 a_1600_n11917.t4 vdd.t14 0.000556371248942328f
CMODEL5056 a_1600_n11917.t4 vdd.n17 0.000454450724803687f
CMODEL5057 a_1600_n11917.t4 vdd.t32 0.000556371248942328f
CMODEL5058 a_1600_n11917.t4 vdd.n18 0.000448604646272547f
CMODEL5059 a_1600_n11917.t4 vdd.t34 4.12451383951803e-05f
CMODEL5060 a_1600_n11917.t4 vdd.n19 0.000451749773709484f
CMODEL5061 a_1600_n11917.t4 vdd.t33 0.000556371248942328f
CMODEL5062 a_1600_n11917.t4 vdd.n20 0.000901532160284735f
CMODEL5063 a_1600_n11917.t4 vdd.t48 0.000557434580187056f
CMODEL5064 a_1600_n11917.t4 vdd.n21 0.00160031800994499f
CMODEL5065 a_1600_n11917.t4 vdd.n22 0.00701318552139784f
CMODEL5066 a_1600_n11917.t4 vdd.t47 7.92892908133521e-06f
CMODEL5067 a_1600_n11917.t4 vdd.t45 7.84751918498253e-06f
CMODEL5068 a_1600_n11917.t4 vdd.n23 8.96096608373395e-05f
CMODEL5069 a_1600_n11917.t4 vdd.t46 0.000213858346463373f
CMODEL5070 a_1600_n11917.t4 vdd.n24 0.000229771524770548f
CMODEL5071 a_1600_n11917.t4 vdd.t44 0.000213858346463373f
CMODEL5072 a_1600_n11917.t4 vdd.n25 0.000362371622965933f
CMODEL5073 a_1600_n11917.t4 vdd.t43 0.000214321590982437f
CMODEL5074 a_1600_n11917.t4 vdd.n26 0.0019388925488517f
CMODEL5075 a_1600_n11917.t4 vdd.n27 0.00129618957074882f
CMODEL5076 a_1600_n11917.t4 vdd.n28 0.00029278623925241f
CMODEL5077 a_1600_n11917.t4 vdd.t29 2.44909413461314e-05f
CMODEL5078 a_1600_n11917.t4 vdd.t28 0.00019358820203065f
CMODEL5079 a_1600_n11917.t4 vdd.n29 4.37056061361453e-05f
CMODEL5080 a_1600_n11917.t4 vdd.n30 1.394305432881e-05f
CMODEL5081 a_1600_n11917.t4 vdd.t38 6.41969414142912e-06f
CMODEL5082 a_1600_n11917.t4 vdd.t40 6.41969414142912e-06f
CMODEL5083 a_1600_n11917.t4 vdd.t37 0.000129722822553006f
CMODEL5084 a_1600_n11917.t4 vdd.t39 0.000129722822553006f
CMODEL5085 a_1600_n11917.t4 vdd.n31 4.2014146729975e-05f
CMODEL5086 a_1600_n11917.t4 vdd.n32 0.000507022808601566f
CMODEL5087 a_1600_n11917.t4 vdd.n33 0.000256908904659729f
CMODEL5088 a_1600_n11917.t4 vdd.t17 2.44909413461314e-05f
CMODEL5089 a_1600_n11917.t4 vdd.t16 0.00019358820203065f
CMODEL5090 a_1600_n11917.t4 vdd.n34 4.37056061361453e-05f
CMODEL5091 a_1600_n11917.t4 vdd.n35 1.394305432881e-05f
CMODEL5092 a_1600_n11917.t4 vdd.t1 6.41969414142912e-06f
CMODEL5093 a_1600_n11917.t4 vdd.t31 6.41969414142912e-06f
CMODEL5094 a_1600_n11917.t4 vdd.t0 0.000129722822553006f
CMODEL5095 a_1600_n11917.t4 vdd.t30 0.000129722822553006f
CMODEL5096 a_1600_n11917.t4 vdd.n36 4.2014146729975e-05f
CMODEL5097 a_1600_n11917.t4 vdd.n37 0.000491712184666404f
CMODEL5098 a_1600_n11917.t4 vdd.n38 0.000283642487873696f
CMODEL5099 a_1600_n11917.t4 vdd.t19 2.44909413461314e-05f
CMODEL5100 a_1600_n11917.t4 vdd.t18 0.00019358820203065f
CMODEL5101 a_1600_n11917.t4 vdd.n39 0.000239354965862272f
CMODEL5102 a_1600_n11917.t4 vdd.t21 2.44911656776176e-05f
CMODEL5103 a_1600_n11917.t4 vdd.t20 0.00019358820203065f
CMODEL5104 a_1600_n11917.t4 vdd.n40 0.000239354965862272f
CMODEL5105 a_1600_n11917.t4 vdd.t11 2.44909413461314e-05f
CMODEL5106 a_1600_n11917.t4 vdd.t10 0.00019358820203065f
CMODEL5107 a_1600_n11917.t4 vdd.n41 0.0010297488212392f
CMODEL5108 a_1600_n11917.t4 vdd.n42 0.00197248170228484f
CMODEL5109 a_1600_n11917.t4 vdd.n43 0.000239354965862272f
CMODEL5110 a_1600_n11917.t4 vdd.t13 2.44909413461314e-05f
CMODEL5111 a_1600_n11917.t4 vdd.t12 0.00019358820203065f
CMODEL5112 a_1600_n11917.t4 vdd.n44 0.000239354965862272f
CMODEL5113 a_1600_n11917.t4 vdd.t23 2.44909413461314e-05f
CMODEL5114 a_1600_n11917.t4 vdd.t22 0.00019358820203065f
CMODEL5115 a_1600_n11917.t4 vdd.n45 0.000295473730457439f
CMODEL5116 a_1600_n11917.t4 vdd.n46 0.0048771011095207f
CMODEL5117 a_1600_n11917.n0 vdd 0.000166309225996934f
CMODEL5118 a_1600_n11917.n0 vdd.n0 0.0558102814836804f
CMODEL5119 a_1600_n11917.n0 vdd.n1 0.00517198108401145f
CMODEL5120 a_1600_n11917.n0 vdd.t7 0.000426359510759994f
CMODEL5121 a_1600_n11917.n0 vdd.t6 0.00337015102605407f
CMODEL5122 a_1600_n11917.n0 vdd.n2 0.00463792355058809f
CMODEL5123 a_1600_n11917.n0 vdd.t27 0.000426359510759994f
CMODEL5124 a_1600_n11917.n0 vdd.t26 0.00337015102605407f
CMODEL5125 a_1600_n11917.n0 vdd.n3 0.0086990259115116f
CMODEL5126 a_1600_n11917.n0 vdd.n4 0.00463792355058809f
CMODEL5127 a_1600_n11917.n0 vdd.t36 0.000426359510759994f
CMODEL5128 a_1600_n11917.n0 vdd.t35 0.00337015102605407f
CMODEL5129 a_1600_n11917.n0 vdd.n5 0.00661758793280117f
CMODEL5130 a_1600_n11917.n0 vdd.t3 0.000679164968245147f
CMODEL5131 a_1600_n11917.n0 vdd.n6 0.00649792780246046f
CMODEL5132 a_1600_n11917.n0 vdd.t2 0.00851598184137227f
CMODEL5133 a_1600_n11917.n0 vdd.n7 0.00871074198171467f
CMODEL5134 a_1600_n11917.n0 vdd.t25 0.000679164968245147f
CMODEL5135 a_1600_n11917.n0 vdd.n8 0.00392480541089444f
CMODEL5136 a_1600_n11917.n0 vdd.t24 0.00851598184137227f
CMODEL5137 a_1600_n11917.n0 vdd.n9 0.00871074198171467f
CMODEL5138 a_1600_n11917.n0 vdd.t5 0.000679164968245147f
CMODEL5139 a_1600_n11917.n0 vdd.n10 0.0116217167843699f
CMODEL5140 a_1600_n11917.n0 vdd.t4 0.0085206682694535f
CMODEL5141 a_1600_n11917.n0 vdd.n11 0.0280993541322398f
CMODEL5142 a_1600_n11917.n0 vdd.n12 0.0692825906101929f
CMODEL5143 a_1600_n11917.n0 vdd.n13 0.00525153320069032f
CMODEL5144 a_1600_n11917.n0 vdd.t42 0.000426359510759994f
CMODEL5145 a_1600_n11917.n0 vdd.t41 0.00337015102605407f
CMODEL5146 a_1600_n11917.n0 vdd.n14 0.00472153723827068f
CMODEL5147 a_1600_n11917.n0 vdd.t9 0.000426359510759994f
CMODEL5148 a_1600_n11917.n0 vdd.t8 0.00337015102605407f
CMODEL5149 a_1600_n11917.n0 vdd.n15 0.00906472351611682f
CMODEL5150 a_1600_n11917.n0 vdd.t15 0.000718031078465472f
CMODEL5151 a_1600_n11917.n0 vdd.n16 0.00564788785566024f
CMODEL5152 a_1600_n11917.n0 vdd.t14 0.00968579239758167f
CMODEL5153 a_1600_n11917.n0 vdd.n17 0.0079114716724611f
CMODEL5154 a_1600_n11917.n0 vdd.t32 0.00968579239758167f
CMODEL5155 a_1600_n11917.n0 vdd.n18 0.00780969807596375f
CMODEL5156 a_1600_n11917.n0 vdd.t34 0.000718031078465472f
CMODEL5157 a_1600_n11917.n0 vdd.n19 0.00786445117737944f
CMODEL5158 a_1600_n11917.n0 vdd.t33 0.00968579239758167f
CMODEL5159 a_1600_n11917.n0 vdd.n20 0.0156946523761986f
CMODEL5160 a_1600_n11917.n0 vdd.t48 0.00970430378850252f
CMODEL5161 a_1600_n11917.n0 vdd.n21 0.0278597214430196f
CMODEL5162 a_1600_n11917.n0 vdd.n22 0.12209160544352f
CMODEL5163 a_1600_n11917.n0 vdd.t47 0.00013803366216884f
CMODEL5164 a_1600_n11917.n0 vdd.t45 0.000136616408209942f
CMODEL5165 a_1600_n11917.n0 vdd.n23 0.00156000255825251f
CMODEL5166 a_1600_n11917.n0 vdd.t46 0.00372303124985713f
CMODEL5167 a_1600_n11917.n0 vdd.n24 0.0040000616351655f
CMODEL5168 a_1600_n11917.n0 vdd.t44 0.00372303124985713f
CMODEL5169 a_1600_n11917.n0 vdd.n25 0.00630847894727678f
CMODEL5170 a_1600_n11917.n0 vdd.t43 0.00373109581151358f
CMODEL5171 a_1600_n11917.n0 vdd.n26 0.0337539201479158f
CMODEL5172 a_1600_n11917.n0 vdd.n27 0.0225651902646841f
CMODEL5173 a_1600_n11917.n0 vdd.n28 0.00509707634184648f
CMODEL5174 a_1600_n11917.n0 vdd.t29 0.000426359510759994f
CMODEL5175 a_1600_n11917.n0 vdd.t28 0.00337015102605407f
CMODEL5176 a_1600_n11917.n0 vdd.n29 0.000760865031127903f
CMODEL5177 a_1600_n11917.n0 vdd.n30 0.000242732761395899f
CMODEL5178 a_1600_n11917.n0 vdd.t38 0.000111759593667104f
CMODEL5179 a_1600_n11917.n0 vdd.t40 0.000111759593667104f
CMODEL5180 a_1600_n11917.n0 vdd.t37 0.00225832720663641f
CMODEL5181 a_1600_n11917.n0 vdd.t39 0.00225832720663641f
CMODEL5182 a_1600_n11917.n0 vdd.n31 0.000731418641350849f
CMODEL5183 a_1600_n11917.n0 vdd.n32 0.00882669202315774f
CMODEL5184 a_1600_n11917.n0 vdd.n33 0.00447249263932071f
CMODEL5185 a_1600_n11917.n0 vdd.t17 0.000426359510759994f
CMODEL5186 a_1600_n11917.n0 vdd.t16 0.00337015102605407f
CMODEL5187 a_1600_n11917.n0 vdd.n34 0.000760865031127903f
CMODEL5188 a_1600_n11917.n0 vdd.n35 0.000242732761395899f
CMODEL5189 a_1600_n11917.n0 vdd.t1 0.000111759593667104f
CMODEL5190 a_1600_n11917.n0 vdd.t31 0.000111759593667104f
CMODEL5191 a_1600_n11917.n0 vdd.t0 0.00225832720663641f
CMODEL5192 a_1600_n11917.n0 vdd.t30 0.00225832720663641f
CMODEL5193 a_1600_n11917.n0 vdd.n36 0.000731418641350849f
CMODEL5194 a_1600_n11917.n0 vdd.n37 0.00856015142603785f
CMODEL5195 a_1600_n11917.n0 vdd.n38 0.00493789400135408f
CMODEL5196 a_1600_n11917.n0 vdd.t19 0.000426359510759994f
CMODEL5197 a_1600_n11917.n0 vdd.t18 0.00337015102605407f
CMODEL5198 a_1600_n11917.n0 vdd.n39 0.00416689847485725f
CMODEL5199 a_1600_n11917.n0 vdd.t21 0.000426363416116728f
CMODEL5200 a_1600_n11917.n0 vdd.t20 0.00337015102605407f
CMODEL5201 a_1600_n11917.n0 vdd.n40 0.00416689847485725f
CMODEL5202 a_1600_n11917.n0 vdd.t11 0.000426359510759994f
CMODEL5203 a_1600_n11917.n0 vdd.t10 0.00337015102605407f
CMODEL5204 a_1600_n11917.n0 vdd.n41 0.0179267590177205f
CMODEL5205 a_1600_n11917.n0 vdd.n42 0.0343386692117511f
CMODEL5206 a_1600_n11917.n0 vdd.n43 0.00416689847485725f
CMODEL5207 a_1600_n11917.n0 vdd.t13 0.000426359510759994f
CMODEL5208 a_1600_n11917.n0 vdd.t12 0.00337015102605407f
CMODEL5209 a_1600_n11917.n0 vdd.n44 0.00416689847485725f
CMODEL5210 a_1600_n11917.n0 vdd.t23 0.000426359510759994f
CMODEL5211 a_1600_n11917.n0 vdd.t22 0.00337015102605407f
CMODEL5212 a_1600_n11917.n0 vdd.n45 0.00514386251552408f
CMODEL5213 a_1600_n11917.n0 vdd.n46 0.0849047986189692f
CMODEL5214 a_1600_n11917.t6 vdd 1.76363711441579e-05f
CMODEL5215 a_1600_n11917.t6 vdd.n0 0.00591843797002734f
CMODEL5216 a_1600_n11917.t6 vdd.n1 0.000548466132299069f
CMODEL5217 a_1600_n11917.t6 vdd.t7 4.52135744576399e-05f
CMODEL5218 a_1600_n11917.t6 vdd.t6 0.000357389879912314f
CMODEL5219 a_1600_n11917.t6 vdd.n2 0.000491831650265212f
CMODEL5220 a_1600_n11917.t6 vdd.t27 4.52135744576399e-05f
CMODEL5221 a_1600_n11917.t6 vdd.t26 0.000357389879912314f
CMODEL5222 a_1600_n11917.t6 vdd.n3 0.000922493918472649f
CMODEL5223 a_1600_n11917.t6 vdd.n4 0.000491831650265212f
CMODEL5224 a_1600_n11917.t6 vdd.t36 4.52135744576399e-05f
CMODEL5225 a_1600_n11917.t6 vdd.t35 0.000357389879912314f
CMODEL5226 a_1600_n11917.t6 vdd.n5 0.000701766460413529f
CMODEL5227 a_1600_n11917.t6 vdd.t3 7.20224953022297e-05f
CMODEL5228 a_1600_n11917.t6 vdd.n6 0.000689077023268978f
CMODEL5229 a_1600_n11917.t6 vdd.t2 0.000903082889785798f
CMODEL5230 a_1600_n11917.t6 vdd.n7 0.000923736356835366f
CMODEL5231 a_1600_n11917.t6 vdd.t25 7.20224953022297e-05f
CMODEL5232 a_1600_n11917.t6 vdd.n8 0.000416208568587828f
CMODEL5233 a_1600_n11917.t6 vdd.t24 0.000903082889785798f
CMODEL5234 a_1600_n11917.t6 vdd.n9 0.000923736356835366f
CMODEL5235 a_1600_n11917.t6 vdd.t5 7.20224953022297e-05f
CMODEL5236 a_1600_n11917.t6 vdd.n10 0.00123243259243607f
CMODEL5237 a_1600_n11917.t6 vdd.t4 0.000903579865130885f
CMODEL5238 a_1600_n11917.t6 vdd.n11 0.00297981447160631f
CMODEL5239 a_1600_n11917.t6 vdd.n12 0.00734711784331579f
CMODEL5240 a_1600_n11917.t6 vdd.n13 0.000556902288781918f
CMODEL5241 a_1600_n11917.t6 vdd.t42 4.52135744576399e-05f
CMODEL5242 a_1600_n11917.t6 vdd.t41 0.000357389879912314f
CMODEL5243 a_1600_n11917.t6 vdd.n14 0.000500698518713803f
CMODEL5244 a_1600_n11917.t6 vdd.t9 4.52135744576399e-05f
CMODEL5245 a_1600_n11917.t6 vdd.t8 0.000357389879912314f
CMODEL5246 a_1600_n11917.t6 vdd.n15 0.000961274561234261f
CMODEL5247 a_1600_n11917.t6 vdd.t15 7.61440774974834e-05f
CMODEL5248 a_1600_n11917.t6 vdd.n16 0.000598933978592639f
CMODEL5249 a_1600_n11917.t6 vdd.t14 0.0010271362188419f
CMODEL5250 a_1600_n11917.t6 vdd.n17 0.000838977211730802f
CMODEL5251 a_1600_n11917.t6 vdd.t32 0.0010271362188419f
CMODEL5252 a_1600_n11917.t6 vdd.n18 0.000828184563819999f
CMODEL5253 a_1600_n11917.t6 vdd.t34 7.61440774974834e-05f
CMODEL5254 a_1600_n11917.t6 vdd.n19 0.000833990892435098f
CMODEL5255 a_1600_n11917.t6 vdd.t33 0.0010271362188419f
CMODEL5256 a_1600_n11917.t6 vdd.n20 0.00166434972338985f
CMODEL5257 a_1600_n11917.t6 vdd.t48 0.00102909927145499f
CMODEL5258 a_1600_n11917.t6 vdd.n21 0.00295440246562753f
CMODEL5259 a_1600_n11917.t6 vdd.n22 0.0129472845194271f
CMODEL5260 a_1600_n11917.t6 vdd.t47 1.46378703995763e-05f
CMODEL5261 a_1600_n11917.t6 vdd.t45 1.44875767722996e-05f
CMODEL5262 a_1600_n11917.t6 vdd.n23 0.000165431496288031f
CMODEL5263 a_1600_n11917.t6 vdd.t46 0.000394811295105113f
CMODEL5264 a_1600_n11917.t6 vdd.n24 0.000424189164337681f
CMODEL5265 a_1600_n11917.t6 vdd.t44 0.000394811295105113f
CMODEL5266 a_1600_n11917.t6 vdd.n25 0.000668986794943842f
CMODEL5267 a_1600_n11917.t6 vdd.t43 0.000395666506844783f
CMODEL5268 a_1600_n11917.t6 vdd.n26 0.0035794566400657f
CMODEL5269 a_1600_n11917.t6 vdd.n27 0.00239294042805444f
CMODEL5270 a_1600_n11917.t6 vdd.n28 0.000540522809700097f
CMODEL5271 a_1600_n11917.t6 vdd.t29 4.52135744576399e-05f
CMODEL5272 a_1600_n11917.t6 vdd.t28 0.000357389879912314f
CMODEL5273 a_1600_n11917.t6 vdd.n29 8.06864321515773e-05f
CMODEL5274 a_1600_n11917.t6 vdd.n30 2.57407551695498e-05f
CMODEL5275 a_1600_n11917.t6 vdd.t38 1.18516195419589e-05f
CMODEL5276 a_1600_n11917.t6 vdd.t40 1.18516195419589e-05f
CMODEL5277 a_1600_n11917.t6 vdd.t37 0.000239485792459424f
CMODEL5278 a_1600_n11917.t6 vdd.t39 0.000239485792459424f
CMODEL5279 a_1600_n11917.t6 vdd.n31 7.75637703999482e-05f
CMODEL5280 a_1600_n11917.t6 vdd.n32 0.000936032355165057f
CMODEL5281 a_1600_n11917.t6 vdd.n33 0.000474288420583646f
CMODEL5282 a_1600_n11917.t6 vdd.t17 4.52135744576399e-05f
CMODEL5283 a_1600_n11917.t6 vdd.t16 0.000357389879912314f
CMODEL5284 a_1600_n11917.t6 vdd.n34 8.06864321515773e-05f
CMODEL5285 a_1600_n11917.t6 vdd.n35 2.57407551695498e-05f
CMODEL5286 a_1600_n11917.t6 vdd.t1 1.18516195419589e-05f
CMODEL5287 a_1600_n11917.t6 vdd.t31 1.18516195419589e-05f
CMODEL5288 a_1600_n11917.t6 vdd.t0 0.000239485792459424f
CMODEL5289 a_1600_n11917.t6 vdd.t30 0.000239485792459424f
CMODEL5290 a_1600_n11917.t6 vdd.n36 7.75637703999482e-05f
CMODEL5291 a_1600_n11917.t6 vdd.n37 0.000907766882413242f
CMODEL5292 a_1600_n11917.t6 vdd.n38 0.00052364221381198f
CMODEL5293 a_1600_n11917.t6 vdd.t19 4.52135744576399e-05f
CMODEL5294 a_1600_n11917.t6 vdd.t18 0.000357389879912314f
CMODEL5295 a_1600_n11917.t6 vdd.n39 0.000441881486622773f
CMODEL5296 a_1600_n11917.t6 vdd.t21 4.52139886037608e-05f
CMODEL5297 a_1600_n11917.t6 vdd.t20 0.000357389879912314f
CMODEL5298 a_1600_n11917.t6 vdd.n40 0.000441881486622773f
CMODEL5299 a_1600_n11917.t6 vdd.t11 4.52135744576399e-05f
CMODEL5300 a_1600_n11917.t6 vdd.t10 0.000357389879912314f
CMODEL5301 a_1600_n11917.t6 vdd.n41 0.00190105493879351f
CMODEL5302 a_1600_n11917.t6 vdd.n42 0.00364146673874891f
CMODEL5303 a_1600_n11917.t6 vdd.n43 0.000441881486622773f
CMODEL5304 a_1600_n11917.t6 vdd.t13 4.52135744576399e-05f
CMODEL5305 a_1600_n11917.t6 vdd.t12 0.000357389879912314f
CMODEL5306 a_1600_n11917.t6 vdd.n44 0.000441881486622773f
CMODEL5307 a_1600_n11917.t6 vdd.t23 4.52135744576399e-05f
CMODEL5308 a_1600_n11917.t6 vdd.t22 0.000357389879912314f
CMODEL5309 a_1600_n11917.t6 vdd.n45 0.000545484280228548f
CMODEL5310 a_1600_n11917.t6 vdd.n46 0.00900378515616284f
CMODEL5311 a_1600_n11917.n1 vdd 0.000979776607444943f
CMODEL5312 a_1600_n11917.n1 vdd.n0 0.3287947973111f
CMODEL5313 a_1600_n11917.n1 vdd.n1 0.0304696630622019f
CMODEL5314 a_1600_n11917.n1 vdd.t7 0.00251180938700306f
CMODEL5315 a_1600_n11917.n1 vdd.t6 0.0198545517790169f
CMODEL5316 a_1600_n11917.n1 vdd.n2 0.0273233729202009f
CMODEL5317 a_1600_n11917.n1 vdd.t27 0.00251180938700306f
CMODEL5318 a_1600_n11917.n1 vdd.t26 0.0198545517790169f
CMODEL5319 a_1600_n11917.n1 vdd.n3 0.0512485224109793f
CMODEL5320 a_1600_n11917.n1 vdd.n4 0.0273233729202009f
CMODEL5321 a_1600_n11917.n1 vdd.t36 0.00251180938700306f
CMODEL5322 a_1600_n11917.n1 vdd.t35 0.0198545517790169f
CMODEL5323 a_1600_n11917.n1 vdd.n5 0.0389861585573614f
CMODEL5324 a_1600_n11917.n1 vdd.t3 0.00400116075637891f
CMODEL5325 a_1600_n11917.n1 vdd.n6 0.038281205504704f
CMODEL5326 a_1600_n11917.n1 vdd.t2 0.05017015591039f
CMODEL5327 a_1600_n11917.n1 vdd.n7 0.051317545229451f
CMODEL5328 a_1600_n11917.n1 vdd.t25 0.00400116075637891f
CMODEL5329 a_1600_n11917.n1 vdd.n8 0.0231221840358911f
CMODEL5330 a_1600_n11917.n1 vdd.t24 0.05017015591039f
CMODEL5331 a_1600_n11917.n1 vdd.n9 0.051317545229451f
CMODEL5332 a_1600_n11917.n1 vdd.t5 0.00400116075637891f
CMODEL5333 a_1600_n11917.n1 vdd.n10 0.0684669547069257f
CMODEL5334 a_1600_n11917.n1 vdd.t4 0.0501977650377787f
CMODEL5335 a_1600_n11917.n1 vdd.n11 0.165541566909749f
CMODEL5336 a_1600_n11917.n1 vdd.n12 0.408164136271689f
CMODEL5337 a_1600_n11917.n1 vdd.n13 0.0309383279996246f
CMODEL5338 a_1600_n11917.n1 vdd.t42 0.00251180938700306f
CMODEL5339 a_1600_n11917.n1 vdd.t41 0.0198545517790169f
CMODEL5340 a_1600_n11917.n1 vdd.n14 0.0278159657680272f
CMODEL5341 a_1600_n11917.n1 vdd.t9 0.00251180938700306f
CMODEL5342 a_1600_n11917.n1 vdd.t8 0.0198545517790169f
CMODEL5343 a_1600_n11917.n1 vdd.n15 0.0534029546515421f
CMODEL5344 a_1600_n11917.n1 vdd.t15 0.00423013245285564f
CMODEL5345 a_1600_n11917.n1 vdd.n16 0.0332733699485217f
CMODEL5346 a_1600_n11917.n1 vdd.t14 0.0570618542587261f
CMODEL5347 a_1600_n11917.n1 vdd.n17 0.0466088085533127f
CMODEL5348 a_1600_n11917.n1 vdd.t32 0.0570618542587261f
CMODEL5349 a_1600_n11917.n1 vdd.n18 0.0460092303368553f
CMODEL5350 a_1600_n11917.n1 vdd.t34 0.00423013245285564f
CMODEL5351 a_1600_n11917.n1 vdd.n19 0.0463317969751797f
CMODEL5352 a_1600_n11917.n1 vdd.t33 0.0570618542587261f
CMODEL5353 a_1600_n11917.n1 vdd.n20 0.0924618172443604f
CMODEL5354 a_1600_n11917.n1 vdd.t48 0.0571709103119114f
CMODEL5355 a_1600_n11917.n1 vdd.n21 0.164129820195941f
CMODEL5356 a_1600_n11917.n1 vdd.n22 0.719277588250959f
CMODEL5357 a_1600_n11917.n1 vdd.t47 0.00081319693734538f
CMODEL5358 a_1600_n11917.n1 vdd.t45 0.000804847477070922f
CMODEL5359 a_1600_n11917.n1 vdd.n23 0.00919043429471708f
CMODEL5360 a_1600_n11917.n1 vdd.t46 0.0219334730561717f
CMODEL5361 a_1600_n11917.n1 vdd.n24 0.0235655406065409f
CMODEL5362 a_1600_n11917.n1 vdd.t44 0.0219334730561717f
CMODEL5363 a_1600_n11917.n1 vdd.n25 0.0371651065300168f
CMODEL5364 a_1600_n11917.n1 vdd.t43 0.0219809837628864f
CMODEL5365 a_1600_n11917.n1 vdd.n26 0.198854279864799f
CMODEL5366 a_1600_n11917.n1 vdd.n27 0.132938178452526f
CMODEL5367 a_1600_n11917.n1 vdd.n28 0.0300283771761063f
CMODEL5368 a_1600_n11917.n1 vdd.t29 0.00251180938700306f
CMODEL5369 a_1600_n11917.n1 vdd.t28 0.0198545517790169f
CMODEL5370 a_1600_n11917.n1 vdd.n29 0.00448247987718812f
CMODEL5371 a_1600_n11917.n1 vdd.n30 0.00143001015157512f
CMODEL5372 a_1600_n11917.n1 vdd.t38 0.000658408665401397f
CMODEL5373 a_1600_n11917.n1 vdd.t40 0.000658408665401397f
CMODEL5374 a_1600_n11917.n1 vdd.t37 0.0133044703669034f
CMODEL5375 a_1600_n11917.n1 vdd.t39 0.0133044703669034f
CMODEL5376 a_1600_n11917.n1 vdd.n31 0.00430900252676262f
CMODEL5377 a_1600_n11917.n1 vdd.n32 0.0520006410562591f
CMODEL5378 a_1600_n11917.n1 vdd.n33 0.0263487707233808f
CMODEL5379 a_1600_n11917.n1 vdd.t17 0.00251180938700306f
CMODEL5380 a_1600_n11917.n1 vdd.t16 0.0198545517790169f
CMODEL5381 a_1600_n11917.n1 vdd.n34 0.00448247987718812f
CMODEL5382 a_1600_n11917.n1 vdd.n35 0.00143001015157512f
CMODEL5383 a_1600_n11917.n1 vdd.t1 0.000658408665401397f
CMODEL5384 a_1600_n11917.n1 vdd.t31 0.000658408665401397f
CMODEL5385 a_1600_n11917.n1 vdd.t0 0.0133044703669034f
CMODEL5386 a_1600_n11917.n1 vdd.t30 0.0133044703669034f
CMODEL5387 a_1600_n11917.n1 vdd.n36 0.00430900252676262f
CMODEL5388 a_1600_n11917.n1 vdd.n37 0.0504303719360283f
CMODEL5389 a_1600_n11917.n1 vdd.n38 0.0290905871491376f
CMODEL5390 a_1600_n11917.n1 vdd.t19 0.00251180938700306f
CMODEL5391 a_1600_n11917.n1 vdd.t18 0.0198545517790169f
CMODEL5392 a_1600_n11917.n1 vdd.n39 0.0245484255415777f
CMODEL5393 a_1600_n11917.n1 vdd.t21 0.00251183239460922f
CMODEL5394 a_1600_n11917.n1 vdd.t20 0.0198545517790169f
CMODEL5395 a_1600_n11917.n1 vdd.n40 0.0245484255415777f
CMODEL5396 a_1600_n11917.n1 vdd.t11 0.00251180938700306f
CMODEL5397 a_1600_n11917.n1 vdd.t10 0.0198545517790169f
CMODEL5398 a_1600_n11917.n1 vdd.n41 0.105611814543524f
CMODEL5399 a_1600_n11917.n1 vdd.n42 0.202299208734721f
CMODEL5400 a_1600_n11917.n1 vdd.n43 0.0245484255415777f
CMODEL5401 a_1600_n11917.n1 vdd.t13 0.00251180938700306f
CMODEL5402 a_1600_n11917.n1 vdd.t12 0.0198545517790169f
CMODEL5403 a_1600_n11917.n1 vdd.n44 0.0245484255415777f
CMODEL5404 a_1600_n11917.n1 vdd.t23 0.00251180938700306f
CMODEL5405 a_1600_n11917.n1 vdd.t22 0.0198545517790169f
CMODEL5406 a_1600_n11917.n1 vdd.n45 0.0303040082978699f
CMODEL5407 a_1600_n11917.n1 vdd.n46 0.500199162421833f
CMODEL5408 a_1600_n11917.t2 vdd 1.23185007014932e-06f
CMODEL5409 a_1600_n11917.t2 vdd.n0 0.000413385960692237f
CMODEL5410 a_1600_n11917.t2 vdd.n1 3.83087902848391e-05f
CMODEL5411 a_1600_n11917.t2 vdd.t7 3.1580388285146e-06f
CMODEL5412 a_1600_n11917.t2 vdd.t6 2.4962660688079e-05f
CMODEL5413 a_1600_n11917.t2 vdd.n2 3.43530337351485e-05f
CMODEL5414 a_1600_n11917.t2 vdd.t27 3.1580388285146e-06f
CMODEL5415 a_1600_n11917.t2 vdd.t26 2.4962660688079e-05f
CMODEL5416 a_1600_n11917.t2 vdd.n3 6.44335611274137e-05f
CMODEL5417 a_1600_n11917.t2 vdd.n4 3.43530337351485e-05f
CMODEL5418 a_1600_n11917.t2 vdd.t36 3.1580388285146e-06f
CMODEL5419 a_1600_n11917.t2 vdd.t35 2.4962660688079e-05f
CMODEL5420 a_1600_n11917.t2 vdd.n5 4.90163796408426e-05f
CMODEL5421 a_1600_n11917.t2 vdd.t3 5.03056525433633e-06f
CMODEL5422 a_1600_n11917.t2 vdd.n6 4.81300587583379e-05f
CMODEL5423 a_1600_n11917.t2 vdd.t2 6.30777563048616e-05f
CMODEL5424 a_1600_n11917.t2 vdd.n7 6.4520341892672e-05f
CMODEL5425 a_1600_n11917.t2 vdd.t25 5.03056525433633e-06f
CMODEL5426 a_1600_n11917.t2 vdd.n8 2.90709778230937e-05f
CMODEL5427 a_1600_n11917.t2 vdd.t24 6.30777563048616e-05f
CMODEL5428 a_1600_n11917.t2 vdd.n9 6.4520341892672e-05f
CMODEL5429 a_1600_n11917.t2 vdd.t5 5.03056525433633e-06f
CMODEL5430 a_1600_n11917.t2 vdd.n10 8.60818908287479e-05f
CMODEL5431 a_1600_n11917.t2 vdd.t4 6.31124686109649e-05f
CMODEL5432 a_1600_n11917.t2 vdd.n11 0.000208131516164884f
CMODEL5433 a_1600_n11917.t2 vdd.n12 0.00051317516266275f
CMODEL5434 a_1600_n11917.t2 vdd.n13 3.8898031680943e-05f
CMODEL5435 a_1600_n11917.t2 vdd.t42 3.1580388285146e-06f
CMODEL5436 a_1600_n11917.t2 vdd.t41 2.4962660688079e-05f
CMODEL5437 a_1600_n11917.t2 vdd.n14 3.49723591298752e-05f
CMODEL5438 a_1600_n11917.t2 vdd.t9 3.1580388285146e-06f
CMODEL5439 a_1600_n11917.t2 vdd.t8 2.4962660688079e-05f
CMODEL5440 a_1600_n11917.t2 vdd.n15 6.71422780803426e-05f
CMODEL5441 a_1600_n11917.t2 vdd.t15 5.31844597961985e-06f
CMODEL5442 a_1600_n11917.t2 vdd.n16 4.18338249696311e-05f
CMODEL5443 a_1600_n11917.t2 vdd.t14 7.17425264466848e-05f
CMODEL5444 a_1600_n11917.t2 vdd.n17 5.86001580867511e-05f
CMODEL5445 a_1600_n11917.t2 vdd.t32 7.17425264466848e-05f
CMODEL5446 a_1600_n11917.t2 vdd.n18 5.78463225058741e-05f
CMODEL5447 a_1600_n11917.t2 vdd.t34 5.31844597961985e-06f
CMODEL5448 a_1600_n11917.t2 vdd.n19 5.82518779488478e-05f
CMODEL5449 a_1600_n11917.t2 vdd.t33 7.17425264466848e-05f
CMODEL5450 a_1600_n11917.t2 vdd.n20 0.000116250066793924f
CMODEL5451 a_1600_n11917.t2 vdd.t48 7.18796400557929e-05f
CMODEL5452 a_1600_n11917.t2 vdd.n21 0.000206356560246134f
CMODEL5453 a_1600_n11917.t2 vdd.n22 0.000904330783987988f
CMODEL5454 a_1600_n11917.t2 vdd.t47 1.02241337127495e-06f
CMODEL5455 a_1600_n11917.t2 vdd.t45 1.01191579137087e-06f
CMODEL5456 a_1600_n11917.t2 vdd.n23 1.15549167479854e-05f
CMODEL5457 a_1600_n11917.t2 vdd.t46 2.75764394838153e-05f
CMODEL5458 a_1600_n11917.t2 vdd.n24 2.96283996052694e-05f
CMODEL5459 a_1600_n11917.t2 vdd.t44 2.75764394838153e-05f
CMODEL5460 a_1600_n11917.t2 vdd.n25 4.67268137841112e-05f
CMODEL5461 a_1600_n11917.t2 vdd.t43 2.76361735772348e-05f
CMODEL5462 a_1600_n11917.t2 vdd.n26 0.000250014806170712f
CMODEL5463 a_1600_n11917.t2 vdd.n27 0.000167140043156693f
CMODEL5464 a_1600_n11917.t2 vdd.n28 3.77539719256211e-05f
CMODEL5465 a_1600_n11917.t2 vdd.t29 3.1580388285146e-06f
CMODEL5466 a_1600_n11917.t2 vdd.t28 2.4962660688079e-05f
CMODEL5467 a_1600_n11917.t2 vdd.n29 5.63571645740417e-06f
CMODEL5468 a_1600_n11917.t2 vdd.n30 1.797918109237e-06f
CMODEL5469 a_1600_n11917.t2 vdd.t38 8.27801719798873e-07f
CMODEL5470 a_1600_n11917.t2 vdd.t40 8.27801719798873e-07f
CMODEL5471 a_1600_n11917.t2 vdd.t37 1.67273974804408e-05f
CMODEL5472 a_1600_n11917.t2 vdd.t39 1.67273974804408e-05f
CMODEL5473 a_1600_n11917.t2 vdd.n31 5.41760746738833e-06f
CMODEL5474 a_1600_n11917.t2 vdd.n32 6.53791821995116e-05f
CMODEL5475 a_1600_n11917.t2 vdd.n33 3.31276893297014e-05f
CMODEL5476 a_1600_n11917.t2 vdd.t17 3.1580388285146e-06f
CMODEL5477 a_1600_n11917.t2 vdd.t16 2.4962660688079e-05f
CMODEL5478 a_1600_n11917.t2 vdd.n34 5.63571645740417e-06f
CMODEL5479 a_1600_n11917.t2 vdd.n35 1.797918109237e-06f
CMODEL5480 a_1600_n11917.t2 vdd.t1 8.27801719798873e-07f
CMODEL5481 a_1600_n11917.t2 vdd.t31 8.27801719798873e-07f
CMODEL5482 a_1600_n11917.t2 vdd.t0 1.67273974804408e-05f
CMODEL5483 a_1600_n11917.t2 vdd.t30 1.67273974804408e-05f
CMODEL5484 a_1600_n11917.t2 vdd.n36 5.41760746738833e-06f
CMODEL5485 a_1600_n11917.t2 vdd.n37 6.34049197898854e-05f
CMODEL5486 a_1600_n11917.t2 vdd.n38 3.65749105949784e-05f
CMODEL5487 a_1600_n11917.t2 vdd.t19 3.1580388285146e-06f
CMODEL5488 a_1600_n11917.t2 vdd.t18 2.4962660688079e-05f
CMODEL5489 a_1600_n11917.t2 vdd.n39 3.08641577025476e-05f
CMODEL5490 a_1600_n11917.t2 vdd.t21 3.15806775543635e-06f
CMODEL5491 a_1600_n11917.t2 vdd.t20 2.4962660688079e-05f
CMODEL5492 a_1600_n11917.t2 vdd.n40 3.08641577025476e-05f
CMODEL5493 a_1600_n11917.t2 vdd.t11 3.1580388285146e-06f
CMODEL5494 a_1600_n11917.t2 vdd.t10 2.4962660688079e-05f
CMODEL5495 a_1600_n11917.t2 vdd.n41 0.000132783248921717f
CMODEL5496 a_1600_n11917.t2 vdd.n42 0.000254346034164753f
CMODEL5497 a_1600_n11917.t2 vdd.n43 3.08641577025476e-05f
CMODEL5498 a_1600_n11917.t2 vdd.t13 3.1580388285146e-06f
CMODEL5499 a_1600_n11917.t2 vdd.t12 2.4962660688079e-05f
CMODEL5500 a_1600_n11917.t2 vdd.n44 3.08641577025476e-05f
CMODEL5501 a_1600_n11917.t2 vdd.t23 3.1580388285146e-06f
CMODEL5502 a_1600_n11917.t2 vdd.t22 2.4962660688079e-05f
CMODEL5503 a_1600_n11917.t2 vdd.n45 3.81005164482192e-05f
CMODEL5504 a_1600_n11917.t2 vdd.n46 0.00062888863505816f
CMODEL5505 a_1600_n11917.t3 vdd 1.23185007014932e-06f
CMODEL5506 a_1600_n11917.t3 vdd.n0 0.000413385960692237f
CMODEL5507 a_1600_n11917.t3 vdd.n1 3.83087902848391e-05f
CMODEL5508 a_1600_n11917.t3 vdd.t7 3.1580388285146e-06f
CMODEL5509 a_1600_n11917.t3 vdd.t6 2.4962660688079e-05f
CMODEL5510 a_1600_n11917.t3 vdd.n2 3.43530337351485e-05f
CMODEL5511 a_1600_n11917.t3 vdd.t27 3.1580388285146e-06f
CMODEL5512 a_1600_n11917.t3 vdd.t26 2.4962660688079e-05f
CMODEL5513 a_1600_n11917.t3 vdd.n3 6.44335611274137e-05f
CMODEL5514 a_1600_n11917.t3 vdd.n4 3.43530337351485e-05f
CMODEL5515 a_1600_n11917.t3 vdd.t36 3.1580388285146e-06f
CMODEL5516 a_1600_n11917.t3 vdd.t35 2.4962660688079e-05f
CMODEL5517 a_1600_n11917.t3 vdd.n5 4.90163796408426e-05f
CMODEL5518 a_1600_n11917.t3 vdd.t3 5.03056525433633e-06f
CMODEL5519 a_1600_n11917.t3 vdd.n6 4.81300587583379e-05f
CMODEL5520 a_1600_n11917.t3 vdd.t2 6.30777563048616e-05f
CMODEL5521 a_1600_n11917.t3 vdd.n7 6.4520341892672e-05f
CMODEL5522 a_1600_n11917.t3 vdd.t25 5.03056525433633e-06f
CMODEL5523 a_1600_n11917.t3 vdd.n8 2.90709778230937e-05f
CMODEL5524 a_1600_n11917.t3 vdd.t24 6.30777563048616e-05f
CMODEL5525 a_1600_n11917.t3 vdd.n9 6.4520341892672e-05f
CMODEL5526 a_1600_n11917.t3 vdd.t5 5.03056525433633e-06f
CMODEL5527 a_1600_n11917.t3 vdd.n10 8.60818908287479e-05f
CMODEL5528 a_1600_n11917.t3 vdd.t4 6.31124686109649e-05f
CMODEL5529 a_1600_n11917.t3 vdd.n11 0.000208131516164884f
CMODEL5530 a_1600_n11917.t3 vdd.n12 0.00051317516266275f
CMODEL5531 a_1600_n11917.t3 vdd.n13 3.8898031680943e-05f
CMODEL5532 a_1600_n11917.t3 vdd.t42 3.1580388285146e-06f
CMODEL5533 a_1600_n11917.t3 vdd.t41 2.4962660688079e-05f
CMODEL5534 a_1600_n11917.t3 vdd.n14 3.49723591298752e-05f
CMODEL5535 a_1600_n11917.t3 vdd.t9 3.1580388285146e-06f
CMODEL5536 a_1600_n11917.t3 vdd.t8 2.4962660688079e-05f
CMODEL5537 a_1600_n11917.t3 vdd.n15 6.71422780803426e-05f
CMODEL5538 a_1600_n11917.t3 vdd.t15 5.31844597961985e-06f
CMODEL5539 a_1600_n11917.t3 vdd.n16 4.18338249696311e-05f
CMODEL5540 a_1600_n11917.t3 vdd.t14 7.17425264466848e-05f
CMODEL5541 a_1600_n11917.t3 vdd.n17 5.86001580867511e-05f
CMODEL5542 a_1600_n11917.t3 vdd.t32 7.17425264466848e-05f
CMODEL5543 a_1600_n11917.t3 vdd.n18 5.78463225058741e-05f
CMODEL5544 a_1600_n11917.t3 vdd.t34 5.31844597961985e-06f
CMODEL5545 a_1600_n11917.t3 vdd.n19 5.82518779488478e-05f
CMODEL5546 a_1600_n11917.t3 vdd.t33 7.17425264466848e-05f
CMODEL5547 a_1600_n11917.t3 vdd.n20 0.000116250066793924f
CMODEL5548 a_1600_n11917.t3 vdd.t48 7.18796400557929e-05f
CMODEL5549 a_1600_n11917.t3 vdd.n21 0.000206356560246134f
CMODEL5550 a_1600_n11917.t3 vdd.n22 0.000904330783987988f
CMODEL5551 a_1600_n11917.t3 vdd.t47 1.02241337127495e-06f
CMODEL5552 a_1600_n11917.t3 vdd.t45 1.01191579137087e-06f
CMODEL5553 a_1600_n11917.t3 vdd.n23 1.15549167479854e-05f
CMODEL5554 a_1600_n11917.t3 vdd.t46 2.75764394838153e-05f
CMODEL5555 a_1600_n11917.t3 vdd.n24 2.96283996052694e-05f
CMODEL5556 a_1600_n11917.t3 vdd.t44 2.75764394838153e-05f
CMODEL5557 a_1600_n11917.t3 vdd.n25 4.67268137841112e-05f
CMODEL5558 a_1600_n11917.t3 vdd.t43 2.76361735772348e-05f
CMODEL5559 a_1600_n11917.t3 vdd.n26 0.000250014806170712f
CMODEL5560 a_1600_n11917.t3 vdd.n27 0.000167140043156693f
CMODEL5561 a_1600_n11917.t3 vdd.n28 3.77539719256211e-05f
CMODEL5562 a_1600_n11917.t3 vdd.t29 3.1580388285146e-06f
CMODEL5563 a_1600_n11917.t3 vdd.t28 2.4962660688079e-05f
CMODEL5564 a_1600_n11917.t3 vdd.n29 5.63571645740417e-06f
CMODEL5565 a_1600_n11917.t3 vdd.n30 1.797918109237e-06f
CMODEL5566 a_1600_n11917.t3 vdd.t38 8.27801719798873e-07f
CMODEL5567 a_1600_n11917.t3 vdd.t40 8.27801719798873e-07f
CMODEL5568 a_1600_n11917.t3 vdd.t37 1.67273974804408e-05f
CMODEL5569 a_1600_n11917.t3 vdd.t39 1.67273974804408e-05f
CMODEL5570 a_1600_n11917.t3 vdd.n31 5.41760746738833e-06f
CMODEL5571 a_1600_n11917.t3 vdd.n32 6.53791821995116e-05f
CMODEL5572 a_1600_n11917.t3 vdd.n33 3.31276893297014e-05f
CMODEL5573 a_1600_n11917.t3 vdd.t17 3.1580388285146e-06f
CMODEL5574 a_1600_n11917.t3 vdd.t16 2.4962660688079e-05f
CMODEL5575 a_1600_n11917.t3 vdd.n34 5.63571645740417e-06f
CMODEL5576 a_1600_n11917.t3 vdd.n35 1.797918109237e-06f
CMODEL5577 a_1600_n11917.t3 vdd.t1 8.27801719798873e-07f
CMODEL5578 a_1600_n11917.t3 vdd.t31 8.27801719798873e-07f
CMODEL5579 a_1600_n11917.t3 vdd.t0 1.67273974804408e-05f
CMODEL5580 a_1600_n11917.t3 vdd.t30 1.67273974804408e-05f
CMODEL5581 a_1600_n11917.t3 vdd.n36 5.41760746738833e-06f
CMODEL5582 a_1600_n11917.t3 vdd.n37 6.34049197898854e-05f
CMODEL5583 a_1600_n11917.t3 vdd.n38 3.65749105949784e-05f
CMODEL5584 a_1600_n11917.t3 vdd.t19 3.1580388285146e-06f
CMODEL5585 a_1600_n11917.t3 vdd.t18 2.4962660688079e-05f
CMODEL5586 a_1600_n11917.t3 vdd.n39 3.08641577025476e-05f
CMODEL5587 a_1600_n11917.t3 vdd.t21 3.15806775543635e-06f
CMODEL5588 a_1600_n11917.t3 vdd.t20 2.4962660688079e-05f
CMODEL5589 a_1600_n11917.t3 vdd.n40 3.08641577025476e-05f
CMODEL5590 a_1600_n11917.t3 vdd.t11 3.1580388285146e-06f
CMODEL5591 a_1600_n11917.t3 vdd.t10 2.4962660688079e-05f
CMODEL5592 a_1600_n11917.t3 vdd.n41 0.000132783248921717f
CMODEL5593 a_1600_n11917.t3 vdd.n42 0.000254346034164753f
CMODEL5594 a_1600_n11917.t3 vdd.n43 3.08641577025476e-05f
CMODEL5595 a_1600_n11917.t3 vdd.t13 3.1580388285146e-06f
CMODEL5596 a_1600_n11917.t3 vdd.t12 2.4962660688079e-05f
CMODEL5597 a_1600_n11917.t3 vdd.n44 3.08641577025476e-05f
CMODEL5598 a_1600_n11917.t3 vdd.t23 3.1580388285146e-06f
CMODEL5599 a_1600_n11917.t3 vdd.t22 2.4962660688079e-05f
CMODEL5600 a_1600_n11917.t3 vdd.n45 3.81005164482192e-05f
CMODEL5601 a_1600_n11917.t3 vdd.n46 0.00062888863505816f
CMODEL5602 a_1600_n11917.n2 vdd 0.000298822060016985f
CMODEL5603 a_1600_n11917.n2 vdd.n0 0.100279122719197f
CMODEL5604 a_1600_n11917.n2 vdd.n1 0.00929294230448571f
CMODEL5605 a_1600_n11917.n2 vdd.t7 0.000766076725746316f
CMODEL5606 a_1600_n11917.n2 vdd.t6 0.00605543959534993f
CMODEL5607 a_1600_n11917.n2 vdd.n2 0.00833335529812142f
CMODEL5608 a_1600_n11917.n2 vdd.t27 0.000766076725746316f
CMODEL5609 a_1600_n11917.n2 vdd.t26 0.00605543959534993f
CMODEL5610 a_1600_n11917.n2 vdd.n3 0.0156302864584731f
CMODEL5611 a_1600_n11917.n2 vdd.n4 0.00833335529812142f
CMODEL5612 a_1600_n11917.n2 vdd.t36 0.000766076725746316f
CMODEL5613 a_1600_n11917.n2 vdd.t35 0.00605543959534993f
CMODEL5614 a_1600_n11917.n2 vdd.n5 0.0118903882004697f
CMODEL5615 a_1600_n11917.n2 vdd.t3 0.00122031398851034f
CMODEL5616 a_1600_n11917.n2 vdd.n6 0.0116753845743271f
CMODEL5617 a_1600_n11917.n2 vdd.t2 0.0153013954676995f
CMODEL5618 a_1600_n11917.n2 vdd.n7 0.0156513377273513f
CMODEL5619 a_1600_n11917.n2 vdd.t25 0.00122031398851034f
CMODEL5620 a_1600_n11917.n2 vdd.n8 0.00705203473240208f
CMODEL5621 a_1600_n11917.n2 vdd.t24 0.0153013954676995f
CMODEL5622 a_1600_n11917.n2 vdd.n9 0.0156513377273513f
CMODEL5623 a_1600_n11917.n2 vdd.t5 0.00122031398851034f
CMODEL5624 a_1600_n11917.n2 vdd.n10 0.0208817359928271f
CMODEL5625 a_1600_n11917.n2 vdd.t4 0.0153098159752508f
CMODEL5626 a_1600_n11917.n2 vdd.n11 0.0504885212267026f
CMODEL5627 a_1600_n11917.n2 vdd.n12 0.124485976802231f
CMODEL5628 a_1600_n11917.n2 vdd.n13 0.00943588042016864f
CMODEL5629 a_1600_n11917.n2 vdd.t42 0.000766076725746316f
CMODEL5630 a_1600_n11917.n2 vdd.t41 0.00605543959534993f
CMODEL5631 a_1600_n11917.n2 vdd.n14 0.00848359118701546f
CMODEL5632 a_1600_n11917.n2 vdd.t9 0.000766076725746316f
CMODEL5633 a_1600_n11917.n2 vdd.t8 0.00605543959534993f
CMODEL5634 a_1600_n11917.n2 vdd.n15 0.0162873667310578f
CMODEL5635 a_1600_n11917.n2 vdd.t15 0.00129014806446893f
CMODEL5636 a_1600_n11917.n2 vdd.n16 0.0101480448463179f
CMODEL5637 a_1600_n11917.n2 vdd.t14 0.0174032944942908f
CMODEL5638 a_1600_n11917.n2 vdd.n17 0.014215220164481f
CMODEL5639 a_1600_n11917.n2 vdd.t32 0.0174032944942908f
CMODEL5640 a_1600_n11917.n2 vdd.n18 0.0140323548088258f
CMODEL5641 a_1600_n11917.n2 vdd.t34 0.00129014806446893f
CMODEL5642 a_1600_n11917.n2 vdd.n19 0.0141307344053832f
CMODEL5643 a_1600_n11917.n2 vdd.t33 0.0174032944942908f
CMODEL5644 a_1600_n11917.n2 vdd.n20 0.0281999289347458f
CMODEL5645 a_1600_n11917.n2 vdd.t48 0.0174365554991184f
CMODEL5646 a_1600_n11917.n2 vdd.n21 0.0500579526072473f
CMODEL5647 a_1600_n11917.n2 vdd.n22 0.219372466143797f
CMODEL5648 a_1600_n11917.n2 vdd.t47 0.000248016927706354f
CMODEL5649 a_1600_n11917.n2 vdd.t45 0.000245470425881055f
CMODEL5650 a_1600_n11917.n2 vdd.n23 0.00280299048531063f
CMODEL5651 a_1600_n11917.n2 vdd.t46 0.00668948977978184f
CMODEL5652 a_1600_n11917.n2 vdd.n24 0.00718725404949634f
CMODEL5653 a_1600_n11917.n2 vdd.t44 0.00668948977978184f
CMODEL5654 a_1600_n11917.n2 vdd.n25 0.0113349855565667f
CMODEL5655 a_1600_n11917.n2 vdd.t43 0.00670398006985967f
CMODEL5656 a_1600_n11917.n2 vdd.n26 0.0606485652962811f
CMODEL5657 a_1600_n11917.n2 vdd.n27 0.0405448140302957f
CMODEL5658 a_1600_n11917.n2 vdd.n28 0.0091583545254578f
CMODEL5659 a_1600_n11917.n2 vdd.t29 0.000766076725746316f
CMODEL5660 a_1600_n11917.n2 vdd.t28 0.00605543959534993f
CMODEL5661 a_1600_n11917.n2 vdd.n29 0.0013671115034876f
CMODEL5662 a_1600_n11917.n2 vdd.n30 0.000436138785200474f
CMODEL5663 a_1600_n11917.n2 vdd.t38 0.000200808053829082f
CMODEL5664 a_1600_n11917.n2 vdd.t40 0.000200808053829082f
CMODEL5665 a_1600_n11917.n2 vdd.t37 0.00405773031552644f
CMODEL5666 a_1600_n11917.n2 vdd.t39 0.00405773031552644f
CMODEL5667 a_1600_n11917.n2 vdd.n31 0.00131420264770708f
CMODEL5668 a_1600_n11917.n2 vdd.n32 0.0158596751183492f
CMODEL5669 a_1600_n11917.n2 vdd.n33 0.00803611138156134f
CMODEL5670 a_1600_n11917.n2 vdd.t17 0.000766076725746316f
CMODEL5671 a_1600_n11917.n2 vdd.t16 0.00605543959534993f
CMODEL5672 a_1600_n11917.n2 vdd.n34 0.0013671115034876f
CMODEL5673 a_1600_n11917.n2 vdd.n35 0.000436138785200474f
CMODEL5674 a_1600_n11917.n2 vdd.t1 0.000200808053829082f
CMODEL5675 a_1600_n11917.n2 vdd.t31 0.000200808053829082f
CMODEL5676 a_1600_n11917.n2 vdd.t0 0.00405773031552644f
CMODEL5677 a_1600_n11917.n2 vdd.t30 0.00405773031552644f
CMODEL5678 a_1600_n11917.n2 vdd.n36 0.00131420264770708f
CMODEL5679 a_1600_n11917.n2 vdd.n37 0.0153807587513703f
CMODEL5680 a_1600_n11917.n2 vdd.n38 0.00887233795229942f
CMODEL5681 a_1600_n11917.n2 vdd.t19 0.000766076725746316f
CMODEL5682 a_1600_n11917.n2 vdd.t18 0.00605543959534993f
CMODEL5683 a_1600_n11917.n2 vdd.n39 0.00748702411832181f
CMODEL5684 a_1600_n11917.n2 vdd.t21 0.000766083742835942f
CMODEL5685 a_1600_n11917.n2 vdd.t20 0.00605543959534993f
CMODEL5686 a_1600_n11917.n2 vdd.n40 0.00748702411832181f
CMODEL5687 a_1600_n11917.n2 vdd.t11 0.000766076725746316f
CMODEL5688 a_1600_n11917.n2 vdd.t10 0.00605543959534993f
CMODEL5689 a_1600_n11917.n2 vdd.n41 0.0322105465105229f
CMODEL5690 a_1600_n11917.n2 vdd.n42 0.0616992341259917f
CMODEL5691 a_1600_n11917.n2 vdd.n43 0.00748702411832181f
CMODEL5692 a_1600_n11917.n2 vdd.t13 0.000766076725746316f
CMODEL5693 a_1600_n11917.n2 vdd.t12 0.00605543959534993f
CMODEL5694 a_1600_n11917.n2 vdd.n44 0.00748702411832181f
CMODEL5695 a_1600_n11917.n2 vdd.t23 0.000766076725746316f
CMODEL5696 a_1600_n11917.n2 vdd.t22 0.00605543959534993f
CMODEL5697 a_1600_n11917.n2 vdd.n45 0.00924241925917805f
CMODEL5698 a_1600_n11917.n2 vdd.n46 0.152555738724413f
CMODEL5699 a_1600_n11917.t1 vdd 4.35199946777202e-06f
CMODEL5700 a_1600_n11917.t1 vdd.n0 0.0014604500373158f
CMODEL5701 a_1600_n11917.t1 vdd.n1 0.000135341011841158f
CMODEL5702 a_1600_n11917.t1 vdd.t7 1.11570260325861e-05f
CMODEL5703 a_1600_n11917.t1 vdd.t6 8.81905100801147e-05f
CMODEL5704 a_1600_n11917.t1 vdd.n2 0.000121365731231885f
CMODEL5705 a_1600_n11917.t1 vdd.t27 1.11570260325861e-05f
CMODEL5706 a_1600_n11917.t1 vdd.t26 8.81905100801147e-05f
CMODEL5707 a_1600_n11917.t1 vdd.n3 0.000227637137447393f
CMODEL5708 a_1600_n11917.t1 vdd.n4 0.000121365731231885f
CMODEL5709 a_1600_n11917.t1 vdd.t36 1.11570260325861e-05f
CMODEL5710 a_1600_n11917.t1 vdd.t35 8.81905100801147e-05f
CMODEL5711 a_1600_n11917.t1 vdd.n5 0.000173169822593103f
CMODEL5712 a_1600_n11917.t1 vdd.t3 1.77724691015445e-05f
CMODEL5713 a_1600_n11917.t1 vdd.n6 0.000170038542169935f
CMODEL5714 a_1600_n11917.t1 vdd.t2 0.00022284721860164f
CMODEL5715 a_1600_n11917.t1 vdd.n7 0.000227943724956188f
CMODEL5716 a_1600_n11917.t1 vdd.t25 1.77724691015445e-05f
CMODEL5717 a_1600_n11917.t1 vdd.n8 0.00010270477152985f
CMODEL5718 a_1600_n11917.t1 vdd.t24 0.00022284721860164f
CMODEL5719 a_1600_n11917.t1 vdd.n9 0.000227943724956188f
CMODEL5720 a_1600_n11917.t1 vdd.t5 1.77724691015445e-05f
CMODEL5721 a_1600_n11917.t1 vdd.n10 0.00030411845739158f
CMODEL5722 a_1600_n11917.t1 vdd.t4 0.000222969853605159f
CMODEL5723 a_1600_n11917.t1 vdd.n11 0.000735307217595371f
CMODEL5724 a_1600_n11917.t1 vdd.n12 0.00181299501368003f
CMODEL5725 a_1600_n11917.t1 vdd.n13 0.000137422741025881f
CMODEL5726 a_1600_n11917.t1 vdd.t42 1.11570260325861e-05f
CMODEL5727 a_1600_n11917.t1 vdd.t41 8.81905100801147e-05f
CMODEL5728 a_1600_n11917.t1 vdd.n14 0.000123553744086324f
CMODEL5729 a_1600_n11917.t1 vdd.t9 1.11570260325861e-05f
CMODEL5730 a_1600_n11917.t1 vdd.t8 8.81905100801147e-05f
CMODEL5731 a_1600_n11917.t1 vdd.n15 0.000237206755555271f
CMODEL5732 a_1600_n11917.t1 vdd.t15 1.87895220640562e-05f
CMODEL5733 a_1600_n11917.t1 vdd.n16 0.000147794596448441f
CMODEL5734 a_1600_n11917.t1 vdd.t14 0.000253458959396533f
CMODEL5735 a_1600_n11917.t1 vdd.n17 0.000207028325106142f
CMODEL5736 a_1600_n11917.t1 vdd.t32 0.000253458959396533f
CMODEL5737 a_1600_n11917.t1 vdd.n18 0.00020436510161307f
CMODEL5738 a_1600_n11917.t1 vdd.t34 1.87895220640562e-05f
CMODEL5739 a_1600_n11917.t1 vdd.n19 0.000205797887237509f
CMODEL5740 a_1600_n11917.t1 vdd.t33 0.000253458959396533f
CMODEL5741 a_1600_n11917.t1 vdd.n20 0.000410699516990971f
CMODEL5742 a_1600_n11917.t1 vdd.t48 0.00025394336766043f
CMODEL5743 a_1600_n11917.t1 vdd.n21 0.000729036481082136f
CMODEL5744 a_1600_n11917.t1 vdd.n22 0.00319490755082599f
CMODEL5745 a_1600_n11917.t1 vdd.t47 3.61208117404436e-06f
CMODEL5746 a_1600_n11917.t1 vdd.t45 3.5749943050637e-06f
CMODEL5747 a_1600_n11917.t1 vdd.n23 4.08223311878264e-05f
CMODEL5748 a_1600_n11917.t1 vdd.t46 9.742472145337e-05f
CMODEL5749 a_1600_n11917.t1 vdd.n24 0.000104674085294682f
CMODEL5750 a_1600_n11917.t1 vdd.t44 9.742472145337e-05f
CMODEL5751 a_1600_n11917.t1 vdd.n25 0.000165081022152708f
CMODEL5752 a_1600_n11917.t1 vdd.t43 9.76357558552578e-05f
CMODEL5753 a_1600_n11917.t1 vdd.n26 0.000883276568923826f
CMODEL5754 a_1600_n11917.t1 vdd.n27 0.000590488563898974f
CMODEL5755 a_1600_n11917.t1 vdd.n28 0.00013338089570159f
CMODEL5756 a_1600_n11917.t1 vdd.t29 1.11570260325861e-05f
CMODEL5757 a_1600_n11917.t1 vdd.t28 8.81905100801147e-05f
CMODEL5758 a_1600_n11917.t1 vdd.n29 1.99104059962135e-05f
CMODEL5759 a_1600_n11917.t1 vdd.n30 6.35185956806306e-06f
CMODEL5760 a_1600_n11917.t1 vdd.t38 2.92453824640264e-06f
CMODEL5761 a_1600_n11917.t1 vdd.t40 2.92453824640264e-06f
CMODEL5762 a_1600_n11917.t1 vdd.t37 5.90961730620882e-05f
CMODEL5763 a_1600_n11917.t1 vdd.t39 5.90961730620882e-05f
CMODEL5764 a_1600_n11917.t1 vdd.n31 1.91398493907735e-05f
CMODEL5765 a_1600_n11917.t1 vdd.n32 0.000230977919334904f
CMODEL5766 a_1600_n11917.t1 vdd.n33 0.000117036715607689f
CMODEL5767 a_1600_n11917.t1 vdd.t17 1.11570260325861e-05f
CMODEL5768 a_1600_n11917.t1 vdd.t16 8.81905100801147e-05f
CMODEL5769 a_1600_n11917.t1 vdd.n34 1.99104059962135e-05f
CMODEL5770 a_1600_n11917.t1 vdd.n35 6.35185956806306e-06f
CMODEL5771 a_1600_n11917.t1 vdd.t1 2.92453824640264e-06f
CMODEL5772 a_1600_n11917.t1 vdd.t31 2.92453824640264e-06f
CMODEL5773 a_1600_n11917.t1 vdd.t0 5.90961730620882e-05f
CMODEL5774 a_1600_n11917.t1 vdd.t30 5.90961730620882e-05f
CMODEL5775 a_1600_n11917.t1 vdd.n36 1.91398493907735e-05f
CMODEL5776 a_1600_n11917.t1 vdd.n37 0.0002240030535098f
CMODEL5777 a_1600_n11917.t1 vdd.n38 0.000129215393415419f
CMODEL5778 a_1600_n11917.t1 vdd.t19 1.11570260325861e-05f
CMODEL5779 a_1600_n11917.t1 vdd.t18 8.81905100801147e-05f
CMODEL5780 a_1600_n11917.t1 vdd.n39 0.000109039891419933f
CMODEL5781 a_1600_n11917.t1 vdd.t21 1.11571282284223e-05f
CMODEL5782 a_1600_n11917.t1 vdd.t20 8.81905100801147e-05f
CMODEL5783 a_1600_n11917.t1 vdd.n40 0.000109039891419933f
CMODEL5784 a_1600_n11917.t1 vdd.t11 1.11570260325861e-05f
CMODEL5785 a_1600_n11917.t1 vdd.t10 8.81905100801147e-05f
CMODEL5786 a_1600_n11917.t1 vdd.n41 0.000469109547208375f
CMODEL5787 a_1600_n11917.t1 vdd.n42 0.000898578351487822f
CMODEL5788 a_1600_n11917.t1 vdd.n43 0.000109039891419933f
CMODEL5789 a_1600_n11917.t1 vdd.t13 1.11570260325861e-05f
CMODEL5790 a_1600_n11917.t1 vdd.t12 8.81905100801147e-05f
CMODEL5791 a_1600_n11917.t1 vdd.n44 0.000109039891419933f
CMODEL5792 a_1600_n11917.t1 vdd.t23 1.11570260325861e-05f
CMODEL5793 a_1600_n11917.t1 vdd.t22 8.81905100801147e-05f
CMODEL5794 a_1600_n11917.t1 vdd.n45 0.000134605201820048f
CMODEL5795 a_1600_n11917.t1 vdd.n46 0.00222179879790828f
CMODEL5796 a_1600_n11917.t0 vdd 5.98163263649254e-06f
CMODEL5797 a_1600_n11917.t0 vdd.n0 0.00200732460375213f
CMODEL5798 a_1600_n11917.t0 vdd.n1 0.000186020292392049f
CMODEL5799 a_1600_n11917.t0 vdd.t7 1.53348435671752e-05f
CMODEL5800 a_1600_n11917.t0 vdd.t6 0.000121213993069305f
CMODEL5801 a_1600_n11917.t0 vdd.n2 0.000166811881358083f
CMODEL5802 a_1600_n11917.t0 vdd.t27 1.53348435671752e-05f
CMODEL5803 a_1600_n11917.t0 vdd.t26 0.000121213993069305f
CMODEL5804 a_1600_n11917.t0 vdd.n3 0.000312877274162477f
CMODEL5805 a_1600_n11917.t0 vdd.n4 0.000166811881358083f
CMODEL5806 a_1600_n11917.t0 vdd.t36 1.53348435671752e-05f
CMODEL5807 a_1600_n11917.t0 vdd.t35 0.000121213993069305f
CMODEL5808 a_1600_n11917.t0 vdd.n5 0.000238014335743661f
CMODEL5809 a_1600_n11917.t0 vdd.t3 2.4427480287188e-05f
CMODEL5810 a_1600_n11917.t0 vdd.n6 0.000233710527962449f
CMODEL5811 a_1600_n11917.t0 vdd.t2 0.000306293740523267f
CMODEL5812 a_1600_n11917.t0 vdd.n7 0.000313298665263771f
CMODEL5813 a_1600_n11917.t0 vdd.t25 2.4427480287188e-05f
CMODEL5814 a_1600_n11917.t0 vdd.n8 0.000141163209659346f
CMODEL5815 a_1600_n11917.t0 vdd.t24 0.000306293740523267f
CMODEL5816 a_1600_n11917.t0 vdd.n9 0.000313298665263771f
CMODEL5817 a_1600_n11917.t0 vdd.t5 2.4427480287188e-05f
CMODEL5818 a_1600_n11917.t0 vdd.n10 0.000417997498291177f
CMODEL5819 a_1600_n11917.t0 vdd.t4 0.000306462296963784f
CMODEL5820 a_1600_n11917.t0 vdd.n11 0.00101064756169851f
CMODEL5821 a_1600_n11917.t0 vdd.n12 0.00249188223112963f
CMODEL5822 a_1600_n11917.t0 vdd.n13 0.000188881537969833f
CMODEL5823 a_1600_n11917.t0 vdd.t42 1.53348435671752e-05f
CMODEL5824 a_1600_n11917.t0 vdd.t41 0.000121213993069305f
CMODEL5825 a_1600_n11917.t0 vdd.n14 0.000169819209184315f
CMODEL5826 a_1600_n11917.t0 vdd.t9 1.53348435671752e-05f
CMODEL5827 a_1600_n11917.t0 vdd.t8 0.000121213993069305f
CMODEL5828 a_1600_n11917.t0 vdd.n15 0.000326030295070855f
CMODEL5829 a_1600_n11917.t0 vdd.t15 2.58253750338793e-05f
CMODEL5830 a_1600_n11917.t0 vdd.n16 0.000203137198926595f
CMODEL5831 a_1600_n11917.t0 vdd.t14 0.000348368237350428f
CMODEL5832 a_1600_n11917.t0 vdd.n17 0.000284551364333522f
CMODEL5833 a_1600_n11917.t0 vdd.t32 0.000348368237350428f
CMODEL5834 a_1600_n11917.t0 vdd.n18 0.000280890880300285f
CMODEL5835 a_1600_n11917.t0 vdd.t34 2.58253750338793e-05f
CMODEL5836 a_1600_n11917.t0 vdd.n19 0.00028286018138033f
CMODEL5837 a_1600_n11917.t0 vdd.t33 0.000348368237350428f
CMODEL5838 a_1600_n11917.t0 vdd.n20 0.000564488496107879f
CMODEL5839 a_1600_n11917.t0 vdd.t48 0.000349034035290472f
CMODEL5840 a_1600_n11917.t0 vdd.n21 0.00100202870904005f
CMODEL5841 a_1600_n11917.t0 vdd.n22 0.00439126048110038f
CMODEL5842 a_1600_n11917.t0 vdd.t47 4.96464735263058e-06f
CMODEL5843 a_1600_n11917.t0 vdd.t45 4.9136730757441e-06f
CMODEL5844 a_1600_n11917.t0 vdd.n23 5.61085060646431e-05f
CMODEL5845 a_1600_n11917.t0 vdd.t46 0.000133906012112867f
CMODEL5846 a_1600_n11917.t0 vdd.n24 0.000143869945166655f
CMODEL5847 a_1600_n11917.t0 vdd.t44 0.000133906012112867f
CMODEL5848 a_1600_n11917.t0 vdd.n25 0.000226896633854532f
CMODEL5849 a_1600_n11917.t0 vdd.t43 0.000134196069654258f
CMODEL5850 a_1600_n11917.t0 vdd.n26 0.00121402495355284f
CMODEL5851 a_1600_n11917.t0 vdd.n27 0.000811600665728469f
CMODEL5852 a_1600_n11917.t0 vdd.n28 0.000183326198617779f
CMODEL5853 a_1600_n11917.t0 vdd.t29 1.53348435671752e-05f
CMODEL5854 a_1600_n11917.t0 vdd.t28 0.000121213993069305f
CMODEL5855 a_1600_n11917.t0 vdd.n29 2.73659809002087e-05f
CMODEL5856 a_1600_n11917.t0 vdd.n30 8.73035274386062e-06f
CMODEL5857 a_1600_n11917.t0 vdd.t38 4.0196497152396e-06f
CMODEL5858 a_1600_n11917.t0 vdd.t40 4.0196497152396e-06f
CMODEL5859 a_1600_n11917.t0 vdd.t37 8.12251012661465e-05f
CMODEL5860 a_1600_n11917.t0 vdd.t39 8.12251012661465e-05f
CMODEL5861 a_1600_n11917.t0 vdd.n31 2.63068845989574e-05f
CMODEL5862 a_1600_n11917.t0 vdd.n32 0.000317469032529573f
CMODEL5863 a_1600_n11917.t0 vdd.n33 0.000160861839007817f
CMODEL5864 a_1600_n11917.t0 vdd.t17 1.53348435671752e-05f
CMODEL5865 a_1600_n11917.t0 vdd.t16 0.000121213993069305f
CMODEL5866 a_1600_n11917.t0 vdd.n34 2.73659809002087e-05f
CMODEL5867 a_1600_n11917.t0 vdd.n35 8.73035274386062e-06f
CMODEL5868 a_1600_n11917.t0 vdd.t1 4.0196497152396e-06f
CMODEL5869 a_1600_n11917.t0 vdd.t31 4.0196497152396e-06f
CMODEL5870 a_1600_n11917.t0 vdd.t0 8.12251012661465e-05f
CMODEL5871 a_1600_n11917.t0 vdd.t30 8.12251012661465e-05f
CMODEL5872 a_1600_n11917.t0 vdd.n36 2.63068845989574e-05f
CMODEL5873 a_1600_n11917.t0 vdd.n37 0.000307882384975144f
CMODEL5874 a_1600_n11917.t0 vdd.n38 0.000177600898188203f
CMODEL5875 a_1600_n11917.t0 vdd.t19 1.53348435671752e-05f
CMODEL5876 a_1600_n11917.t0 vdd.t18 0.000121213993069305f
CMODEL5877 a_1600_n11917.t0 vdd.n39 0.000149870554449076f
CMODEL5878 a_1600_n11917.t0 vdd.t21 1.53349840308757e-05f
CMODEL5879 a_1600_n11917.t0 vdd.t20 0.000121213993069305f
CMODEL5880 a_1600_n11917.t0 vdd.n40 0.000149870554449076f
CMODEL5881 a_1600_n11917.t0 vdd.t11 1.53348435671752e-05f
CMODEL5882 a_1600_n11917.t0 vdd.t10 0.000121213993069305f
CMODEL5883 a_1600_n11917.t0 vdd.n41 0.00064477052408933f
CMODEL5884 a_1600_n11917.t0 vdd.n42 0.0012350565834184f
CMODEL5885 a_1600_n11917.t0 vdd.n43 0.000149870554449076f
CMODEL5886 a_1600_n11917.t0 vdd.t13 1.53348435671752e-05f
CMODEL5887 a_1600_n11917.t0 vdd.t12 0.000121213993069305f
CMODEL5888 a_1600_n11917.t0 vdd.n44 0.000149870554449076f
CMODEL5889 a_1600_n11917.t0 vdd.t23 1.53348435671752e-05f
CMODEL5890 a_1600_n11917.t0 vdd.t22 0.000121213993069305f
CMODEL5891 a_1600_n11917.t0 vdd.n45 0.000185008953748944f
CMODEL5892 a_1600_n11917.t0 vdd.n46 0.00305376512559451f
CMODEL5893 a_1600_n11917.n3 vdd 0.000829160779169935f
CMODEL5894 a_1600_n11917.n3 vdd.n0 0.278250928072716f
CMODEL5895 a_1600_n11917.n3 vdd.n1 0.0257857243924048f
CMODEL5896 a_1600_n11917.n3 vdd.t7 0.00212568233679824f
CMODEL5897 a_1600_n11917.n3 vdd.t6 0.0168024175083039f
CMODEL5898 a_1600_n11917.n3 vdd.n2 0.0231230966405142f
CMODEL5899 a_1600_n11917.n3 vdd.t27 0.00212568233679824f
CMODEL5900 a_1600_n11917.n3 vdd.t26 0.0168024175083039f
CMODEL5901 a_1600_n11917.n3 vdd.n3 0.0433703606012898f
CMODEL5902 a_1600_n11917.n3 vdd.n4 0.0231230966405142f
CMODEL5903 a_1600_n11917.n3 vdd.t36 0.00212568233679824f
CMODEL5904 a_1600_n11917.n3 vdd.t35 0.0168024175083039f
CMODEL5905 a_1600_n11917.n3 vdd.n5 0.0329930244921478f
CMODEL5906 a_1600_n11917.n3 vdd.t3 0.00338608366961826f
CMODEL5907 a_1600_n11917.n3 vdd.n6 0.0323964401095669f
CMODEL5908 a_1600_n11917.n3 vdd.t2 0.042457765627022f
CMODEL5909 a_1600_n11917.n3 vdd.n7 0.0434287729102892f
CMODEL5910 a_1600_n11917.n3 vdd.t25 0.00338608366961826f
CMODEL5911 a_1600_n11917.n3 vdd.n8 0.0195677340994156f
CMODEL5912 a_1600_n11917.n3 vdd.t24 0.042457765627022f
CMODEL5913 a_1600_n11917.n3 vdd.n9 0.0434287729102892f
CMODEL5914 a_1600_n11917.n3 vdd.t5 0.00338608366961826f
CMODEL5915 a_1600_n11917.n3 vdd.n10 0.0579418952042875f
CMODEL5916 a_1600_n11917.n3 vdd.t4 0.0424811305506218f
CMODEL5917 a_1600_n11917.n3 vdd.n11 0.140093745411872f
CMODEL5918 a_1600_n11917.n3 vdd.n12 0.34541924219116f
CMODEL5919 a_1600_n11917.n3 vdd.n13 0.026182343970511f
CMODEL5920 a_1600_n11917.n3 vdd.t42 0.00212568233679824f
CMODEL5921 a_1600_n11917.n3 vdd.t41 0.0168024175083039f
CMODEL5922 a_1600_n11917.n3 vdd.n14 0.0235399658190734f
CMODEL5923 a_1600_n11917.n3 vdd.t9 0.00212568233679824f
CMODEL5924 a_1600_n11917.n3 vdd.t8 0.0168024175083039f
CMODEL5925 a_1600_n11917.n3 vdd.n15 0.0451936034728586f
CMODEL5926 a_1600_n11917.n3 vdd.t15 0.00357985676933904f
CMODEL5927 a_1600_n11917.n3 vdd.n16 0.0281584323839617f
CMODEL5928 a_1600_n11917.n3 vdd.t14 0.0482900399729184f
CMODEL5929 a_1600_n11917.n3 vdd.n17 0.0394438851903481f
CMODEL5930 a_1600_n11917.n3 vdd.t32 0.0482900399729184f
CMODEL5931 a_1600_n11917.n3 vdd.n18 0.0389364769328397f
CMODEL5932 a_1600_n11917.n3 vdd.t34 0.00357985676933904f
CMODEL5933 a_1600_n11917.n3 vdd.n19 0.0392094571235637f
CMODEL5934 a_1600_n11917.n3 vdd.t33 0.0482900399729184f
CMODEL5935 a_1600_n11917.n3 vdd.n20 0.0782481555971525f
CMODEL5936 a_1600_n11917.n3 vdd.t48 0.0483823314211375f
CMODEL5937 a_1600_n11917.n3 vdd.n21 0.138899018985137f
CMODEL5938 a_1600_n11917.n3 vdd.n22 0.608706883775188f
CMODEL5939 a_1600_n11917.n3 vdd.t47 0.000688188512630712f
CMODEL5940 a_1600_n11917.n3 vdd.t45 0.000681122570318748f
CMODEL5941 a_1600_n11917.n3 vdd.n23 0.00777763788481337f
CMODEL5942 a_1600_n11917.n3 vdd.t46 0.0185617573138274f
CMODEL5943 a_1600_n11917.n3 vdd.n24 0.0199429358308886f
CMODEL5944 a_1600_n11917.n3 vdd.t44 0.0185617573138274f
CMODEL5945 a_1600_n11917.n3 vdd.n25 0.0314519130730462f
CMODEL5946 a_1600_n11917.n3 vdd.t43 0.0186019644531887f
CMODEL5947 a_1600_n11917.n3 vdd.n26 0.168285472811963f
CMODEL5948 a_1600_n11917.n3 vdd.n27 0.112502301840598f
CMODEL5949 a_1600_n11917.n3 vdd.n28 0.0254122750302018f
CMODEL5950 a_1600_n11917.n3 vdd.t29 0.00212568233679824f
CMODEL5951 a_1600_n11917.n3 vdd.t28 0.0168024175083039f
CMODEL5952 a_1600_n11917.n3 vdd.n29 0.00379341217104095f
CMODEL5953 a_1600_n11917.n3 vdd.n30 0.00121018232369625f
CMODEL5954 a_1600_n11917.n3 vdd.t38 0.000557195015545558f
CMODEL5955 a_1600_n11917.n3 vdd.t40 0.000557195015545558f
CMODEL5956 a_1600_n11917.n3 vdd.t37 0.0112592451504154f
CMODEL5957 a_1600_n11917.n3 vdd.t39 0.0112592451504154f
CMODEL5958 a_1600_n11917.n3 vdd.n31 0.00364660256775572f
CMODEL5959 a_1600_n11917.n3 vdd.n32 0.0440068600616869f
CMODEL5960 a_1600_n11917.n3 vdd.n33 0.0222983148374422f
CMODEL5961 a_1600_n11917.n3 vdd.t17 0.00212568233679824f
CMODEL5962 a_1600_n11917.n3 vdd.t16 0.0168024175083039f
CMODEL5963 a_1600_n11917.n3 vdd.n34 0.00379341217104095f
CMODEL5964 a_1600_n11917.n3 vdd.n35 0.00121018232369625f
CMODEL5965 a_1600_n11917.n3 vdd.t1 0.000557195015545558f
CMODEL5966 a_1600_n11917.n3 vdd.t31 0.000557195015545558f
CMODEL5967 a_1600_n11917.n3 vdd.t0 0.0112592451504154f
CMODEL5968 a_1600_n11917.n3 vdd.t30 0.0112592451504154f
CMODEL5969 a_1600_n11917.n3 vdd.n36 0.00364660256775572f
CMODEL5970 a_1600_n11917.n3 vdd.n37 0.0426779800319499f
CMODEL5971 a_1600_n11917.n3 vdd.n38 0.0246186464585962f
CMODEL5972 a_1600_n11917.n3 vdd.t19 0.00212568233679824f
CMODEL5973 a_1600_n11917.n3 vdd.t18 0.0168024175083039f
CMODEL5974 a_1600_n11917.n3 vdd.n39 0.0207747271110404f
CMODEL5975 a_1600_n11917.n3 vdd.t21 0.00212570180756791f
CMODEL5976 a_1600_n11917.n3 vdd.t20 0.0168024175083039f
CMODEL5977 a_1600_n11917.n3 vdd.n40 0.0207747271110404f
CMODEL5978 a_1600_n11917.n3 vdd.t11 0.00212568233679824f
CMODEL5979 a_1600_n11917.n3 vdd.t10 0.0168024175083039f
CMODEL5980 a_1600_n11917.n3 vdd.n41 0.0893766740000271f
CMODEL5981 a_1600_n11917.n3 vdd.n42 0.171200831154125f
CMODEL5982 a_1600_n11917.n3 vdd.n43 0.0207747271110404f
CMODEL5983 a_1600_n11917.n3 vdd.t13 0.00212568233679824f
CMODEL5984 a_1600_n11917.n3 vdd.t12 0.0168024175083039f
CMODEL5985 a_1600_n11917.n3 vdd.n44 0.0207747271110404f
CMODEL5986 a_1600_n11917.n3 vdd.t23 0.00212568233679824f
CMODEL5987 a_1600_n11917.n3 vdd.t22 0.0168024175083039f
CMODEL5988 a_1600_n11917.n3 vdd.n45 0.0256455348508062f
CMODEL5989 a_1600_n11917.n3 vdd.n46 0.423306215010999f
CMODEL5990 a_1600_n11917.n4 vdd 0.00121568031537381f
CMODEL5991 a_1600_n11917.n4 vdd.n0 0.407959691884035f
CMODEL5992 a_1600_n11917.n4 vdd.n1 0.0378059338417841f
CMODEL5993 a_1600_n11917.n4 vdd.t7 0.0031165851527256f
CMODEL5994 a_1600_n11917.n4 vdd.t6 0.0246349908590538f
CMODEL5995 a_1600_n11917.n4 vdd.n2 0.0339021021284921f
CMODEL5996 a_1600_n11917.n4 vdd.t27 0.0031165851527256f
CMODEL5997 a_1600_n11917.n4 vdd.t26 0.0246349908590538f
CMODEL5998 a_1600_n11917.n4 vdd.n3 0.0635877805344744f
CMODEL5999 a_1600_n11917.n4 vdd.n4 0.0339021021284921f
CMODEL6000 a_1600_n11917.n4 vdd.t36 0.0031165851527256f
CMODEL6001 a_1600_n11917.n4 vdd.t35 0.0246349908590538f
CMODEL6002 a_1600_n11917.n4 vdd.n5 0.0483729711141217f
CMODEL6003 a_1600_n11917.n4 vdd.t3 0.00496453205068926f
CMODEL6004 a_1600_n11917.n4 vdd.n6 0.0474982844326206f
CMODEL6005 a_1600_n11917.n4 vdd.t2 0.06224977254616f
CMODEL6006 a_1600_n11917.n4 vdd.n7 0.0636734221808355f
CMODEL6007 a_1600_n11917.n4 vdd.t25 0.00496453205068926f
CMODEL6008 a_1600_n11917.n4 vdd.n8 0.0286893805866485f
CMODEL6009 a_1600_n11917.n4 vdd.t24 0.06224977254616f
CMODEL6010 a_1600_n11917.n4 vdd.n9 0.0636734221808355f
CMODEL6011 a_1600_n11917.n4 vdd.t5 0.00496453205068926f
CMODEL6012 a_1600_n11917.n4 vdd.n10 0.0849519456357063f
CMODEL6013 a_1600_n11917.n4 vdd.t4 0.0622840292047044f
CMODEL6014 a_1600_n11917.n4 vdd.n11 0.20539949896653f
CMODEL6015 a_1600_n11917.n4 vdd.n12 0.506439021034627f
CMODEL6016 a_1600_n11917.n4 vdd.n13 0.0383874406205758f
CMODEL6017 a_1600_n11917.n4 vdd.t42 0.0031165851527256f
CMODEL6018 a_1600_n11917.n4 vdd.t41 0.0246349908590538f
CMODEL6019 a_1600_n11917.n4 vdd.n14 0.0345132980113556f
CMODEL6020 a_1600_n11917.n4 vdd.t9 0.0031165851527256f
CMODEL6021 a_1600_n11917.n4 vdd.t8 0.0246349908590538f
CMODEL6022 a_1600_n11917.n4 vdd.n15 0.0662609417895578f
CMODEL6023 a_1600_n11917.n4 vdd.t15 0.00524863393888438f
CMODEL6024 a_1600_n11917.n4 vdd.n16 0.0412846975169707f
CMODEL6025 a_1600_n11917.n4 vdd.t14 0.070800805463158f
CMODEL6026 a_1600_n11917.n4 vdd.n17 0.0578309490660834f
CMODEL6027 a_1600_n11917.n4 vdd.t32 0.070800805463158f
CMODEL6028 a_1600_n11917.n4 vdd.n18 0.0570870086313603f
CMODEL6029 a_1600_n11917.n4 vdd.t34 0.00524863393888438f
CMODEL6030 a_1600_n11917.n4 vdd.n19 0.057487240592021f
CMODEL6031 a_1600_n11917.n4 vdd.t33 0.070800805463158f
CMODEL6032 a_1600_n11917.n4 vdd.n20 0.114724122104513f
CMODEL6033 a_1600_n11917.n4 vdd.t48 0.0709361192644085f
CMODEL6034 a_1600_n11917.n4 vdd.n21 0.203647841826291f
CMODEL6035 a_1600_n11917.n4 vdd.n22 0.892460177842502f
CMODEL6036 a_1600_n11917.n4 vdd.t47 0.00100899276604601f
CMODEL6037 a_1600_n11917.n4 vdd.t45 0.000998632981557862f
CMODEL6038 a_1600_n11917.n4 vdd.n23 0.011403242307407f
CMODEL6039 a_1600_n11917.n4 vdd.t46 0.0272144601530182f
CMODEL6040 a_1600_n11917.n4 vdd.n24 0.0292394854284411f
CMODEL6041 a_1600_n11917.n4 vdd.t44 0.0272144601530182f
CMODEL6042 a_1600_n11917.n4 vdd.n25 0.0461134590109622f
CMODEL6043 a_1600_n11917.n4 vdd.t43 0.0272734101529301f
CMODEL6044 a_1600_n11917.n4 vdd.n26 0.246733012221926f
CMODEL6045 a_1600_n11917.n4 vdd.n27 0.16494609636357f
CMODEL6046 a_1600_n11917.n4 vdd.n28 0.0372583982493824f
CMODEL6047 a_1600_n11917.n4 vdd.t29 0.0031165851527256f
CMODEL6048 a_1600_n11917.n4 vdd.t28 0.0246349908590538f
CMODEL6049 a_1600_n11917.n4 vdd.n29 0.00556173979798044f
CMODEL6050 a_1600_n11917.n4 vdd.n30 0.0017743179198655f
CMODEL6051 a_1600_n11917.n4 vdd.t38 0.000816935664638222f
CMODEL6052 a_1600_n11917.n4 vdd.t40 0.000816935664638222f
CMODEL6053 a_1600_n11917.n4 vdd.t37 0.0165078269971121f
CMODEL6054 a_1600_n11917.n4 vdd.t39 0.0165078269971121f
CMODEL6055 a_1600_n11917.n4 vdd.n31 0.00534649379345962f
CMODEL6056 a_1600_n11917.n4 vdd.n32 0.0645209890076555f
CMODEL6057 a_1600_n11917.n4 vdd.n33 0.0326928420818739f
CMODEL6058 a_1600_n11917.n4 vdd.t17 0.0031165851527256f
CMODEL6059 a_1600_n11917.n4 vdd.t16 0.0246349908590538f
CMODEL6060 a_1600_n11917.n4 vdd.n34 0.00556173979798044f
CMODEL6061 a_1600_n11917.n4 vdd.n35 0.0017743179198655f
CMODEL6062 a_1600_n11917.n4 vdd.t1 0.000816935664638222f
CMODEL6063 a_1600_n11917.n4 vdd.t31 0.000816935664638222f
CMODEL6064 a_1600_n11917.n4 vdd.t0 0.0165078269971121f
CMODEL6065 a_1600_n11917.n4 vdd.t30 0.0165078269971121f
CMODEL6066 a_1600_n11917.n4 vdd.n36 0.00534649379345962f
CMODEL6067 a_1600_n11917.n4 vdd.n37 0.0625726415529412f
CMODEL6068 a_1600_n11917.n4 vdd.n38 0.03609481374749f
CMODEL6069 a_1600_n11917.n4 vdd.t19 0.0031165851527256f
CMODEL6070 a_1600_n11917.n4 vdd.t18 0.0246349908590538f
CMODEL6071 a_1600_n11917.n4 vdd.n39 0.0304590224726227f
CMODEL6072 a_1600_n11917.n4 vdd.t21 0.00311661369994106f
CMODEL6073 a_1600_n11917.n4 vdd.t20 0.0246349908590538f
CMODEL6074 a_1600_n11917.n4 vdd.n40 0.0304590224726227f
CMODEL6075 a_1600_n11917.n4 vdd.t11 0.0031165851527256f
CMODEL6076 a_1600_n11917.n4 vdd.t10 0.0246349908590538f
CMODEL6077 a_1600_n11917.n4 vdd.n41 0.131040283097069f
CMODEL6078 a_1600_n11917.n4 vdd.n42 0.251007386791807f
CMODEL6079 a_1600_n11917.n4 vdd.n43 0.0304590224726227f
CMODEL6080 a_1600_n11917.n4 vdd.t13 0.0031165851527256f
CMODEL6081 a_1600_n11917.n4 vdd.t12 0.0246349908590538f
CMODEL6082 a_1600_n11917.n4 vdd.n44 0.0304590224726227f
CMODEL6083 a_1600_n11917.n4 vdd.t23 0.0031165851527256f
CMODEL6084 a_1600_n11917.n4 vdd.t22 0.0246349908590538f
CMODEL6085 a_1600_n11917.n4 vdd.n45 0.0376003938905176f
CMODEL6086 a_1600_n11917.n4 vdd.n46 0.620633592292474f
CMODEL6087 a_12800_83.t1 vdd 5.67222695539788e-06f
CMODEL6088 a_12800_83.t1 vdd.n0 0.0019034938147443f
CMODEL6089 a_12800_83.t1 vdd.n1 0.000176398214480768f
CMODEL6090 a_12800_83.t1 vdd.t7 1.45416340862994e-05f
CMODEL6091 a_12800_83.t1 vdd.t6 0.000114944083102751f
CMODEL6092 a_12800_83.t1 vdd.n2 0.000158183376917438f
CMODEL6093 a_12800_83.t1 vdd.t27 1.45416340862994e-05f
CMODEL6094 a_12800_83.t1 vdd.t26 0.000114944083102751f
CMODEL6095 a_12800_83.t1 vdd.n3 0.000296693397285671f
CMODEL6096 a_12800_83.t1 vdd.n4 0.000158183376917438f
CMODEL6097 a_12800_83.t1 vdd.t36 1.45416340862994e-05f
CMODEL6098 a_12800_83.t1 vdd.t35 0.000114944083102751f
CMODEL6099 a_12800_83.t1 vdd.n5 0.000225702816107403f
CMODEL6100 a_12800_83.t1 vdd.t3 2.31639454573199e-05f
CMODEL6101 a_12800_83.t1 vdd.n6 0.00022162162690857f
CMODEL6102 a_12800_83.t1 vdd.t2 0.0002904504032338f
CMODEL6103 a_12800_83.t1 vdd.n7 0.000297092991528376f
CMODEL6104 a_12800_83.t1 vdd.t25 2.31639454573199e-05f
CMODEL6105 a_12800_83.t1 vdd.n8 0.000133861407344757f
CMODEL6106 a_12800_83.t1 vdd.t24 0.0002904504032338f
CMODEL6107 a_12800_83.t1 vdd.n9 0.000297092991528376f
CMODEL6108 a_12800_83.t1 vdd.t5 2.31639454573199e-05f
CMODEL6109 a_12800_83.t1 vdd.n10 0.000396376177071009f
CMODEL6110 a_12800_83.t1 vdd.t4 0.000290610240930882f
CMODEL6111 a_12800_83.t1 vdd.n11 0.000958370847935399f
CMODEL6112 a_12800_83.t1 vdd.n12 0.00236298723443147f
CMODEL6113 a_12800_83.t1 vdd.n13 0.000179111459388739f
CMODEL6114 a_12800_83.t1 vdd.t42 1.45416340862994e-05f
CMODEL6115 a_12800_83.t1 vdd.t41 0.000114944083102751f
CMODEL6116 a_12800_83.t1 vdd.n14 0.000161035147829547f
CMODEL6117 a_12800_83.t1 vdd.t9 1.45416340862994e-05f
CMODEL6118 a_12800_83.t1 vdd.t8 0.000114944083102751f
CMODEL6119 a_12800_83.t1 vdd.n15 0.000309166065581321f
CMODEL6120 a_12800_83.t1 vdd.t15 2.44895327584553e-05f
CMODEL6121 a_12800_83.t1 vdd.n16 0.00019262973261947f
CMODEL6122 a_12800_83.t1 vdd.t14 0.000330348556387145f
CMODEL6123 a_12800_83.t1 vdd.n17 0.000269832672291f
CMODEL6124 a_12800_83.t1 vdd.t32 0.000330348556387145f
CMODEL6125 a_12800_83.t1 vdd.n18 0.000266361530302698f
CMODEL6126 a_12800_83.t1 vdd.t34 2.44895327584553e-05f
CMODEL6127 a_12800_83.t1 vdd.n19 0.000268228967396942f
CMODEL6128 a_12800_83.t1 vdd.t33 0.000330348556387145f
CMODEL6129 a_12800_83.t1 vdd.n20 0.000535289787624374f
CMODEL6130 a_12800_83.t1 vdd.t48 0.00033097991529062f
CMODEL6131 a_12800_83.t1 vdd.n21 0.00095019781369126f
CMODEL6132 a_12800_83.t1 vdd.n22 0.00416411832400268f
CMODEL6133 a_12800_83.t1 vdd.t47 4.70784621005219e-06f
CMODEL6134 a_12800_83.t1 vdd.t45 4.6595086264929e-06f
CMODEL6135 a_12800_83.t1 vdd.n23 5.32062398124122e-05f
CMODEL6136 a_12800_83.t1 vdd.t46 0.000126979595296882f
CMODEL6137 a_12800_83.t1 vdd.n24 0.000136428134363736f
CMODEL6138 a_12800_83.t1 vdd.t44 0.000126979595296882f
CMODEL6139 a_12800_83.t1 vdd.n25 0.00021516018800402f
CMODEL6140 a_12800_83.t1 vdd.t43 0.000127254649333944f
CMODEL6141 a_12800_83.t1 vdd.n26 0.00115122834927321f
CMODEL6142 a_12800_83.t1 vdd.n27 0.000769619843431791f
CMODEL6143 a_12800_83.t1 vdd.n28 0.000173843475289071f
CMODEL6144 a_12800_83.t1 vdd.t29 1.45416340862994e-05f
CMODEL6145 a_12800_83.t1 vdd.t28 0.000114944083102751f
CMODEL6146 a_12800_83.t1 vdd.n29 2.5950449309787e-05f
CMODEL6147 a_12800_83.t1 vdd.n30 8.2787668807584e-06f
CMODEL6148 a_12800_83.t1 vdd.t38 3.8117294811687e-06f
CMODEL6149 a_12800_83.t1 vdd.t40 3.8117294811687e-06f
CMODEL6150 a_12800_83.t1 vdd.t37 7.70236550546367e-05f
CMODEL6151 a_12800_83.t1 vdd.t39 7.70236550546367e-05f
CMODEL6152 a_12800_83.t1 vdd.n31 2.49461357797869e-05f
CMODEL6153 a_12800_83.t1 vdd.n32 0.000301047642550353f
CMODEL6154 a_12800_83.t1 vdd.n33 0.000152541106210435f
CMODEL6155 a_12800_83.t1 vdd.t17 1.45416340862994e-05f
CMODEL6156 a_12800_83.t1 vdd.t16 0.000114944083102751f
CMODEL6157 a_12800_83.t1 vdd.n34 2.5950449309787e-05f
CMODEL6158 a_12800_83.t1 vdd.n35 8.2787668807584e-06f
CMODEL6159 a_12800_83.t1 vdd.t1 3.8117294811687e-06f
CMODEL6160 a_12800_83.t1 vdd.t31 3.8117294811687e-06f
CMODEL6161 a_12800_83.t1 vdd.t0 7.70236550546367e-05f
CMODEL6162 a_12800_83.t1 vdd.t30 7.70236550546367e-05f
CMODEL6163 a_12800_83.t1 vdd.n36 2.49461357797869e-05f
CMODEL6164 a_12800_83.t1 vdd.n37 0.0002919568735288f
CMODEL6165 a_12800_83.t1 vdd.n38 0.00016841432151151f
CMODEL6166 a_12800_83.t1 vdd.t19 1.45416340862994e-05f
CMODEL6167 a_12800_83.t1 vdd.t18 0.000114944083102751f
CMODEL6168 a_12800_83.t1 vdd.n39 0.000142118356379864f
CMODEL6169 a_12800_83.t1 vdd.t21 1.45417672843803e-05f
CMODEL6170 a_12800_83.t1 vdd.t20 0.000114944083102751f
CMODEL6171 a_12800_83.t1 vdd.n40 0.000142118356379864f
CMODEL6172 a_12800_83.t1 vdd.t11 1.45416340862994e-05f
CMODEL6173 a_12800_83.t1 vdd.t10 0.000114944083102751f
CMODEL6174 a_12800_83.t1 vdd.n41 0.000611419150763836f
CMODEL6175 a_12800_83.t1 vdd.n42 0.00117117209792665f
CMODEL6176 a_12800_83.t1 vdd.n43 0.000142118356379864f
CMODEL6177 a_12800_83.t1 vdd.t13 1.45416340862994e-05f
CMODEL6178 a_12800_83.t1 vdd.t12 0.000114944083102751f
CMODEL6179 a_12800_83.t1 vdd.n44 0.000142118356379864f
CMODEL6180 a_12800_83.t1 vdd.t23 1.45416340862994e-05f
CMODEL6181 a_12800_83.t1 vdd.t22 0.000114944083102751f
CMODEL6182 a_12800_83.t1 vdd.n45 0.000175439188298275f
CMODEL6183 a_12800_83.t1 vdd.n46 0.00289580619765511f
CMODEL6184 a_12800_83.n0 vdd 7.89906855384537e-05f
CMODEL6185 a_12800_83.n0 vdd.n0 0.0265078041705952f
CMODEL6186 a_12800_83.n0 vdd.n1 0.00245649830289939f
CMODEL6187 a_12800_83.n0 vdd.t7 0.000202504881126634f
CMODEL6188 a_12800_83.n0 vdd.t6 0.00160069616294794f
CMODEL6189 a_12800_83.n0 vdd.n2 0.00220284087391909f
CMODEL6190 a_12800_83.n0 vdd.t27 0.000202504881126634f
CMODEL6191 a_12800_83.n0 vdd.t26 0.00160069616294794f
CMODEL6192 a_12800_83.n0 vdd.n3 0.00413171317555012f
CMODEL6193 a_12800_83.n0 vdd.n4 0.00220284087391909f
CMODEL6194 a_12800_83.n0 vdd.t36 0.000202504881126634f
CMODEL6195 a_12800_83.n0 vdd.t35 0.00160069616294794f
CMODEL6196 a_12800_83.n0 vdd.n5 0.00314310769164785f
CMODEL6197 a_12800_83.n0 vdd.t3 0.000322578053705664f
CMODEL6198 a_12800_83.n0 vdd.n6 0.0030862735883648f
CMODEL6199 a_12800_83.n0 vdd.t2 0.00404477406259723f
CMODEL6200 a_12800_83.n0 vdd.n7 0.00413727787234676f
CMODEL6201 a_12800_83.n0 vdd.t25 0.000322578053705664f
CMODEL6202 a_12800_83.n0 vdd.n8 0.00186413632889675f
CMODEL6203 a_12800_83.n0 vdd.t24 0.00404477406259723f
CMODEL6204 a_12800_83.n0 vdd.n9 0.00413727787234676f
CMODEL6205 a_12800_83.n0 vdd.t5 0.000322578053705664f
CMODEL6206 a_12800_83.n0 vdd.n10 0.00551988243844067f
CMODEL6207 a_12800_83.n0 vdd.t4 0.00404699994131589f
CMODEL6208 a_12800_83.n0 vdd.n11 0.0133461462091966f
CMODEL6209 a_12800_83.n0 vdd.n12 0.032906649017055f
CMODEL6210 a_12800_83.n0 vdd.n13 0.0024942825941486f
CMODEL6211 a_12800_83.n0 vdd.t42 0.000202504881126634f
CMODEL6212 a_12800_83.n0 vdd.t41 0.00160069616294794f
CMODEL6213 a_12800_83.n0 vdd.n14 0.00224255426005779f
CMODEL6214 a_12800_83.n0 vdd.t9 0.000202504881126634f
CMODEL6215 a_12800_83.n0 vdd.t8 0.00160069616294794f
CMODEL6216 a_12800_83.n0 vdd.n15 0.00430540591156266f
CMODEL6217 a_12800_83.n0 vdd.t15 0.000341038007879061f
CMODEL6218 a_12800_83.n0 vdd.n16 0.00268253628677903f
CMODEL6219 a_12800_83.n0 vdd.t14 0.00460039048875271f
CMODEL6220 a_12800_83.n0 vdd.n17 0.00375765425687977f
CMODEL6221 a_12800_83.n0 vdd.t32 0.00460039048875271f
CMODEL6222 a_12800_83.n0 vdd.n18 0.00370931559070627f
CMODEL6223 a_12800_83.n0 vdd.t34 0.000341038007879061f
CMODEL6224 a_12800_83.n0 vdd.n19 0.00373532127373591f
CMODEL6225 a_12800_83.n0 vdd.t33 0.00460039048875271f
CMODEL6226 a_12800_83.n0 vdd.n20 0.00745437508383631f
CMODEL6227 a_12800_83.n0 vdd.t48 0.0046091827096914f
CMODEL6228 a_12800_83.n0 vdd.n21 0.013232329610716f
CMODEL6229 a_12800_83.n0 vdd.n22 0.0579889633582435f
CMODEL6230 a_12800_83.n0 vdd.t47 6.55608462894356e-05f
CMODEL6231 a_12800_83.n0 vdd.t45 6.4887703466935e-05f
CMODEL6232 a_12800_83.n0 vdd.n23 0.000740943088270876f
CMODEL6233 a_12800_83.n0 vdd.t46 0.00176830112066496f
CMODEL6234 a_12800_83.n0 vdd.n24 0.00189988023132052f
CMODEL6235 a_12800_83.n0 vdd.t44 0.00176830112066496f
CMODEL6236 a_12800_83.n0 vdd.n25 0.00299629244116308f
CMODEL6237 a_12800_83.n0 vdd.t43 0.00177213148695999f
CMODEL6238 a_12800_83.n0 vdd.n26 0.0160318543731497f
CMODEL6239 a_12800_83.n0 vdd.n27 0.0107176245793237f
CMODEL6240 a_12800_83.n0 vdd.n28 0.00242092134137952f
CMODEL6241 a_12800_83.n0 vdd.t29 0.000202504881126634f
CMODEL6242 a_12800_83.n0 vdd.t28 0.00160069616294794f
CMODEL6243 a_12800_83.n0 vdd.n29 0.000361382539367588f
CMODEL6244 a_12800_83.n0 vdd.n30 0.000115289017253063f
CMODEL6245 a_12800_83.n0 vdd.t38 5.30816427431773e-05f
CMODEL6246 a_12800_83.n0 vdd.t40 5.30816427431773e-05f
CMODEL6247 a_12800_83.n0 vdd.t37 0.00107262127613798f
CMODEL6248 a_12800_83.n0 vdd.t39 0.00107262127613798f
CMODEL6249 a_12800_83.n0 vdd.n31 0.000347396601418692f
CMODEL6250 a_12800_83.n0 vdd.n32 0.0041923498216442f
CMODEL6251 a_12800_83.n0 vdd.n33 0.00212426735515049f
CMODEL6252 a_12800_83.n0 vdd.t17 0.000202504881126634f
CMODEL6253 a_12800_83.n0 vdd.t16 0.00160069616294794f
CMODEL6254 a_12800_83.n0 vdd.n34 0.000361382539367588f
CMODEL6255 a_12800_83.n0 vdd.n35 0.000115289017253063f
CMODEL6256 a_12800_83.n0 vdd.t1 5.30816427431773e-05f
CMODEL6257 a_12800_83.n0 vdd.t31 5.30816427431773e-05f
CMODEL6258 a_12800_83.n0 vdd.t0 0.00107262127613798f
CMODEL6259 a_12800_83.n0 vdd.t30 0.00107262127613798f
CMODEL6260 a_12800_83.n0 vdd.n36 0.000347396601418692f
CMODEL6261 a_12800_83.n0 vdd.n37 0.00406575296952057f
CMODEL6262 a_12800_83.n0 vdd.n38 0.00234531566090247f
CMODEL6263 a_12800_83.n0 vdd.t19 0.000202504881126634f
CMODEL6264 a_12800_83.n0 vdd.t18 0.00160069616294794f
CMODEL6265 a_12800_83.n0 vdd.n39 0.00197912151370472f
CMODEL6266 a_12800_83.n0 vdd.t21 0.000202506736025567f
CMODEL6267 a_12800_83.n0 vdd.t20 0.00160069616294794f
CMODEL6268 a_12800_83.n0 vdd.n40 0.00197912151370472f
CMODEL6269 a_12800_83.n0 vdd.t11 0.000202504881126634f
CMODEL6270 a_12800_83.n0 vdd.t10 0.00160069616294794f
CMODEL6271 a_12800_83.n0 vdd.n41 0.00851454256854341f
CMODEL6272 a_12800_83.n0 vdd.n42 0.0163095883902702f
CMODEL6273 a_12800_83.n0 vdd.n43 0.00197912151370472f
CMODEL6274 a_12800_83.n0 vdd.t13 0.000202504881126634f
CMODEL6275 a_12800_83.n0 vdd.t12 0.00160069616294794f
CMODEL6276 a_12800_83.n0 vdd.n44 0.00197912151370472f
CMODEL6277 a_12800_83.n0 vdd.t23 0.000202504881126634f
CMODEL6278 a_12800_83.n0 vdd.t22 0.00160069616294794f
CMODEL6279 a_12800_83.n0 vdd.n45 0.00244314303058745f
CMODEL6280 a_12800_83.n0 vdd.n46 0.0403266157256987f
CMODEL6281 a_12800_83.t0 vdd 1.28773568282102e-06f
CMODEL6282 a_12800_83.t0 vdd.n0 0.000432140132358897f
CMODEL6283 a_12800_83.t0 vdd.n1 4.00467535870782e-05f
CMODEL6284 a_12800_83.t0 vdd.t7 3.30131026961716e-06f
CMODEL6285 a_12800_83.t0 vdd.t6 2.60951471978213e-05f
CMODEL6286 a_12800_83.t0 vdd.n2 3.59115353612335e-05f
CMODEL6287 a_12800_83.t0 vdd.t27 3.30131026961716e-06f
CMODEL6288 a_12800_83.t0 vdd.t26 2.60951471978213e-05f
CMODEL6289 a_12800_83.t0 vdd.n3 6.7356732645997e-05f
CMODEL6290 a_12800_83.t0 vdd.n4 3.59115353612335e-05f
CMODEL6291 a_12800_83.t0 vdd.t36 3.30131026961716e-06f
CMODEL6292 a_12800_83.t0 vdd.t35 2.60951471978213e-05f
CMODEL6293 a_12800_83.t0 vdd.n5 5.12401165009991e-05f
CMODEL6294 a_12800_83.t0 vdd.t3 5.25878801304389e-06f
CMODEL6295 a_12800_83.t0 vdd.n6 5.03135857043638e-05f
CMODEL6296 a_12800_83.t0 vdd.t2 6.5939418728298e-05f
CMODEL6297 a_12800_83.t0 vdd.n7 6.74474504132916e-05f
CMODEL6298 a_12800_83.t0 vdd.t25 5.25878801304389e-06f
CMODEL6299 a_12800_83.t0 vdd.n8 3.03898472585699e-05f
CMODEL6300 a_12800_83.t0 vdd.t24 6.5939418728298e-05f
CMODEL6301 a_12800_83.t0 vdd.n9 6.74474504132916e-05f
CMODEL6302 a_12800_83.t0 vdd.t5 5.25878801304389e-06f
CMODEL6303 a_12800_83.t0 vdd.n10 8.99871868753036e-05f
CMODEL6304 a_12800_83.t0 vdd.t4 6.59757058352158e-05f
CMODEL6305 a_12800_83.t0 vdd.n11 0.000217573864368635f
CMODEL6306 a_12800_83.t0 vdd.n12 0.000536456492970938f
CMODEL6307 a_12800_83.t0 vdd.n13 4.06627272270084e-05f
CMODEL6308 a_12800_83.t0 vdd.t42 3.30131026961716e-06f
CMODEL6309 a_12800_83.t0 vdd.t41 2.60951471978213e-05f
CMODEL6310 a_12800_83.t0 vdd.n14 3.65589578271591e-05f
CMODEL6311 a_12800_83.t0 vdd.t9 3.30131026961716e-06f
CMODEL6312 a_12800_83.t0 vdd.t8 2.60951471978213e-05f
CMODEL6313 a_12800_83.t0 vdd.n15 7.01883365558186e-05f
CMODEL6314 a_12800_83.t0 vdd.t15 5.55972908641579e-06f
CMODEL6315 a_12800_83.t0 vdd.n16 4.37317092945841e-05f
CMODEL6316 a_12800_83.t0 vdd.t14 7.49972854001044e-05f
CMODEL6317 a_12800_83.t0 vdd.n17 6.12586843284551e-05f
CMODEL6318 a_12800_83.t0 vdd.t32 7.49972854001044e-05f
CMODEL6319 a_12800_83.t0 vdd.n18 6.04706493232229e-05f
CMODEL6320 a_12800_83.t0 vdd.t34 5.55972908641579e-06f
CMODEL6321 a_12800_83.t0 vdd.n19 6.08946036890462e-05f
CMODEL6322 a_12800_83.t0 vdd.t33 7.49972854001044e-05f
CMODEL6323 a_12800_83.t0 vdd.n20 0.000121524009105035f
CMODEL6324 a_12800_83.t0 vdd.t48 7.51406194724298e-05f
CMODEL6325 a_12800_83.t0 vdd.n21 0.000215718383634903f
CMODEL6326 a_12800_83.t0 vdd.n22 0.000945357757274539f
CMODEL6327 a_12800_83.t0 vdd.t47 1.06879742323228e-06f
CMODEL6328 a_12800_83.t0 vdd.t45 1.05782359731521e-06f
CMODEL6329 a_12800_83.t0 vdd.n23 1.20791311937852e-05f
CMODEL6330 a_12800_83.t0 vdd.t46 2.88275058702226e-05f
CMODEL6331 a_12800_83.t0 vdd.n24 3.09725577171587e-05f
CMODEL6332 a_12800_83.t0 vdd.t44 2.88275058702226e-05f
CMODEL6333 a_12800_83.t0 vdd.n25 4.88466794072104e-05f
CMODEL6334 a_12800_83.t0 vdd.t43 2.8889949933377e-05f
CMODEL6335 a_12800_83.t0 vdd.n26 0.000261357282790577f
CMODEL6336 a_12800_83.t0 vdd.n27 0.000174722722201924f
CMODEL6337 a_12800_83.t0 vdd.n28 3.94667646615082e-05f
CMODEL6338 a_12800_83.t0 vdd.t29 3.30131026961716e-06f
CMODEL6339 a_12800_83.t0 vdd.t28 2.60951471978213e-05f
CMODEL6340 a_12800_83.t0 vdd.n29 5.89139324364478e-06f
CMODEL6341 a_12800_83.t0 vdd.n30 1.87948465495801e-06f
CMODEL6342 a_12800_83.t0 vdd.t38 8.65356782223023e-07f
CMODEL6343 a_12800_83.t0 vdd.t40 8.65356782223023e-07f
CMODEL6344 a_12800_83.t0 vdd.t37 1.74862729956115e-05f
CMODEL6345 a_12800_83.t0 vdd.t39 1.74862729956115e-05f
CMODEL6346 a_12800_83.t0 vdd.n31 5.66338925517773e-06f
CMODEL6347 a_12800_83.t0 vdd.n32 6.83452539169503e-05f
CMODEL6348 a_12800_83.t0 vdd.n33 3.4630600487034e-05f
CMODEL6349 a_12800_83.t0 vdd.t17 3.30131026961716e-06f
CMODEL6350 a_12800_83.t0 vdd.t16 2.60951471978213e-05f
CMODEL6351 a_12800_83.t0 vdd.n34 5.89139324364478e-06f
CMODEL6352 a_12800_83.t0 vdd.n35 1.87948465495801e-06f
CMODEL6353 a_12800_83.t0 vdd.t1 8.65356782223023e-07f
CMODEL6354 a_12800_83.t0 vdd.t31 8.65356782223023e-07f
CMODEL6355 a_12800_83.t0 vdd.t0 1.74862729956115e-05f
CMODEL6356 a_12800_83.t0 vdd.t30 1.74862729956115e-05f
CMODEL6357 a_12800_83.t0 vdd.n36 5.66338925517773e-06f
CMODEL6358 a_12800_83.t0 vdd.n37 6.62814247109985e-05f
CMODEL6359 a_12800_83.t0 vdd.n38 3.82342125965324e-05f
CMODEL6360 a_12800_83.t0 vdd.t19 3.30131026961716e-06f
CMODEL6361 a_12800_83.t0 vdd.t18 2.60951471978213e-05f
CMODEL6362 a_12800_83.t0 vdd.n39 3.22643787234336e-05f
CMODEL6363 a_12800_83.t0 vdd.t21 3.30134050887292e-06f
CMODEL6364 a_12800_83.t0 vdd.t20 2.60951471978213e-05f
CMODEL6365 a_12800_83.t0 vdd.n40 3.22643787234336e-05f
CMODEL6366 a_12800_83.t0 vdd.t11 3.30131026961716e-06f
CMODEL6367 a_12800_83.t0 vdd.t10 2.60951471978213e-05f
CMODEL6368 a_12800_83.t0 vdd.n41 0.000138807255737441f
CMODEL6369 a_12800_83.t0 vdd.n42 0.00026588500655625f
CMODEL6370 a_12800_83.t0 vdd.n43 3.22643787234336e-05f
CMODEL6371 a_12800_83.t0 vdd.t13 3.30131026961716e-06f
CMODEL6372 a_12800_83.t0 vdd.t12 2.60951471978213e-05f
CMODEL6373 a_12800_83.t0 vdd.n44 3.22643787234336e-05f
CMODEL6374 a_12800_83.t0 vdd.t23 3.30131026961716e-06f
CMODEL6375 a_12800_83.t0 vdd.t22 2.60951471978213e-05f
CMODEL6376 a_12800_83.t0 vdd.n45 3.98290309455712e-05f
CMODEL6377 a_12800_83.t0 vdd.n46 0.000657419563881534f
CMODEL6378 a_12800_83.t2 vdd 1.27000950612294e-06f
CMODEL6379 a_12800_83.t2 vdd.n0 0.000426191557316117f
CMODEL6380 a_12800_83.t2 vdd.n1 3.9495494629406e-05f
CMODEL6381 a_12800_83.t2 vdd.t7 3.25586646468489e-06f
CMODEL6382 a_12800_83.t2 vdd.t6 2.57359374652947e-05f
CMODEL6383 a_12800_83.t2 vdd.n2 3.54171992720772e-05f
CMODEL6384 a_12800_83.t2 vdd.t27 3.25586646468489e-06f
CMODEL6385 a_12800_83.t2 vdd.t26 2.57359374652947e-05f
CMODEL6386 a_12800_83.t2 vdd.n3 6.64295413282315e-05f
CMODEL6387 a_12800_83.t2 vdd.n4 3.54171992720772e-05f
CMODEL6388 a_12800_83.t2 vdd.t36 3.25586646468489e-06f
CMODEL6389 a_12800_83.t2 vdd.t35 2.57359374652947e-05f
CMODEL6390 a_12800_83.t2 vdd.n5 5.05347765999277e-05f
CMODEL6391 a_12800_83.t2 vdd.t3 5.18639877449086e-06f
CMODEL6392 a_12800_83.t2 vdd.n6 4.96209998558797e-05f
CMODEL6393 a_12800_83.t2 vdd.t2 6.50317372814453e-05f
CMODEL6394 a_12800_83.t2 vdd.n7 6.6519010330586e-05f
CMODEL6395 a_12800_83.t2 vdd.t25 5.18639877449086e-06f
CMODEL6396 a_12800_83.t2 vdd.n8 2.99715193287628e-05f
CMODEL6397 a_12800_83.t2 vdd.t24 6.50317372814453e-05f
CMODEL6398 a_12800_83.t2 vdd.n9 6.6519010330586e-05f
CMODEL6399 a_12800_83.t2 vdd.t5 5.18639877449086e-06f
CMODEL6400 a_12800_83.t2 vdd.n10 8.87484786556007e-05f
CMODEL6401 a_12800_83.t2 vdd.t4 6.50675248823872e-05f
CMODEL6402 a_12800_83.t2 vdd.n11 0.000214578876487089f
CMODEL6403 a_12800_83.t2 vdd.n12 0.000529071963123628f
CMODEL6404 a_12800_83.t2 vdd.n13 4.01029891553935e-05f
CMODEL6405 a_12800_83.t2 vdd.t42 3.25586646468489e-06f
CMODEL6406 a_12800_83.t2 vdd.t41 2.57359374652947e-05f
CMODEL6407 a_12800_83.t2 vdd.n14 3.60557097188809e-05f
CMODEL6408 a_12800_83.t2 vdd.t9 3.25586646468489e-06f
CMODEL6409 a_12800_83.t2 vdd.t8 2.57359374652947e-05f
CMODEL6410 a_12800_83.t2 vdd.n15 6.92221671217252e-05f
CMODEL6411 a_12800_83.t2 vdd.t15 5.48319727830173e-06f
CMODEL6412 a_12800_83.t2 vdd.n16 4.31297255050484e-05f
CMODEL6413 a_12800_83.t2 vdd.t14 7.39649189365406e-05f
CMODEL6414 a_12800_83.t2 vdd.n17 6.04154349899577e-05f
CMODEL6415 a_12800_83.t2 vdd.t32 7.39649189365406e-05f
CMODEL6416 a_12800_83.t2 vdd.n18 5.96382475895044e-05f
CMODEL6417 a_12800_83.t2 vdd.t34 5.48319727830173e-06f
CMODEL6418 a_12800_83.t2 vdd.n19 6.00563660605081e-05f
CMODEL6419 a_12800_83.t2 vdd.t33 7.39649189365406e-05f
CMODEL6420 a_12800_83.t2 vdd.n20 0.000119851184404133f
CMODEL6421 a_12800_83.t2 vdd.t48 7.41062799602608e-05f
CMODEL6422 a_12800_83.t2 vdd.n21 0.00021274893715893f
CMODEL6423 a_12800_83.t2 vdd.n22 0.000932344544336584f
CMODEL6424 a_12800_83.t2 vdd.t47 1.05408501584044e-06f
CMODEL6425 a_12800_83.t2 vdd.t45 1.04326224885561e-06f
CMODEL6426 a_12800_83.t2 vdd.n23 1.19128573095116e-05f
CMODEL6427 a_12800_83.t2 vdd.t46 2.84306841702125e-05f
CMODEL6428 a_12800_83.t2 vdd.n24 3.0546208553887e-05f
CMODEL6429 a_12800_83.t2 vdd.t44 2.84306841702125e-05f
CMODEL6430 a_12800_83.t2 vdd.n25 4.81742860878065e-05f
CMODEL6431 a_12800_83.t2 vdd.t43 2.84922686668333e-05f
CMODEL6432 a_12800_83.t2 vdd.n26 0.00025775959932348f
CMODEL6433 a_12800_83.t2 vdd.n27 0.000172317596764896f
CMODEL6434 a_12800_83.t2 vdd.n28 3.89234894743525e-05f
CMODEL6435 a_12800_83.t2 vdd.t29 3.25586646468489e-06f
CMODEL6436 a_12800_83.t2 vdd.t28 2.57359374652947e-05f
CMODEL6437 a_12800_83.t2 vdd.n29 5.81029595091001e-06f
CMODEL6438 a_12800_83.t2 vdd.n30 1.85361282618167e-06f
CMODEL6439 a_12800_83.t2 vdd.t38 8.53444813460174e-07f
CMODEL6440 a_12800_83.t2 vdd.t40 8.53444813460174e-07f
CMODEL6441 a_12800_83.t2 vdd.t37 1.7245567725853e-05f
CMODEL6442 a_12800_83.t2 vdd.t39 1.7245567725853e-05f
CMODEL6443 a_12800_83.t2 vdd.n31 5.58543052499221e-06f
CMODEL6444 a_12800_83.t2 vdd.n32 6.74044552238883e-05f
CMODEL6445 a_12800_83.t2 vdd.n33 3.41538969588308e-05f
CMODEL6446 a_12800_83.t2 vdd.t17 3.25586646468489e-06f
CMODEL6447 a_12800_83.t2 vdd.t16 2.57359374652947e-05f
CMODEL6448 a_12800_83.t2 vdd.n34 5.81029595091001e-06f
CMODEL6449 a_12800_83.t2 vdd.n35 1.85361282618167e-06f
CMODEL6450 a_12800_83.t2 vdd.t1 8.53444813460174e-07f
CMODEL6451 a_12800_83.t2 vdd.t31 8.53444813460174e-07f
CMODEL6452 a_12800_83.t2 vdd.t0 1.7245567725853e-05f
CMODEL6453 a_12800_83.t2 vdd.t30 1.7245567725853e-05f
CMODEL6454 a_12800_83.t2 vdd.n36 5.58543052499221e-06f
CMODEL6455 a_12800_83.t2 vdd.n37 6.5369035420322e-05f
CMODEL6456 a_12800_83.t2 vdd.n38 3.77079039623619e-05f
CMODEL6457 a_12800_83.t2 vdd.t19 3.25586646468489e-06f
CMODEL6458 a_12800_83.t2 vdd.t18 2.57359374652947e-05f
CMODEL6459 a_12800_83.t2 vdd.n39 3.18202471474159e-05f
CMODEL6460 a_12800_83.t2 vdd.t21 3.25589628768568e-06f
CMODEL6461 a_12800_83.t2 vdd.t20 2.57359374652947e-05f
CMODEL6462 a_12800_83.t2 vdd.n40 3.18202471474159e-05f
CMODEL6463 a_12800_83.t2 vdd.t11 3.25586646468489e-06f
CMODEL6464 a_12800_83.t2 vdd.t10 2.57359374652947e-05f
CMODEL6465 a_12800_83.t2 vdd.n41 0.000136896520502716f
CMODEL6466 a_12800_83.t2 vdd.n42 0.000262224997230996f
CMODEL6467 a_12800_83.t2 vdd.n43 3.18202471474159e-05f
CMODEL6468 a_12800_83.t2 vdd.t13 3.25586646468489e-06f
CMODEL6469 a_12800_83.t2 vdd.t12 2.57359374652947e-05f
CMODEL6470 a_12800_83.t2 vdd.n44 3.18202471474159e-05f
CMODEL6471 a_12800_83.t2 vdd.t23 3.25586646468489e-06f
CMODEL6472 a_12800_83.t2 vdd.t22 2.57359374652947e-05f
CMODEL6473 a_12800_83.t2 vdd.n45 3.92807690237551e-05f
CMODEL6474 a_12800_83.t2 vdd.n46 0.000648369930863202f
CMODEL6475 a_12800_83.t3 vdd 1.27000950612294e-06f
CMODEL6476 a_12800_83.t3 vdd.n0 0.000426191557316117f
CMODEL6477 a_12800_83.t3 vdd.n1 3.9495494629406e-05f
CMODEL6478 a_12800_83.t3 vdd.t7 3.25586646468489e-06f
CMODEL6479 a_12800_83.t3 vdd.t6 2.57359374652947e-05f
CMODEL6480 a_12800_83.t3 vdd.n2 3.54171992720772e-05f
CMODEL6481 a_12800_83.t3 vdd.t27 3.25586646468489e-06f
CMODEL6482 a_12800_83.t3 vdd.t26 2.57359374652947e-05f
CMODEL6483 a_12800_83.t3 vdd.n3 6.64295413282315e-05f
CMODEL6484 a_12800_83.t3 vdd.n4 3.54171992720772e-05f
CMODEL6485 a_12800_83.t3 vdd.t36 3.25586646468489e-06f
CMODEL6486 a_12800_83.t3 vdd.t35 2.57359374652947e-05f
CMODEL6487 a_12800_83.t3 vdd.n5 5.05347765999277e-05f
CMODEL6488 a_12800_83.t3 vdd.t3 5.18639877449086e-06f
CMODEL6489 a_12800_83.t3 vdd.n6 4.96209998558797e-05f
CMODEL6490 a_12800_83.t3 vdd.t2 6.50317372814453e-05f
CMODEL6491 a_12800_83.t3 vdd.n7 6.6519010330586e-05f
CMODEL6492 a_12800_83.t3 vdd.t25 5.18639877449086e-06f
CMODEL6493 a_12800_83.t3 vdd.n8 2.99715193287628e-05f
CMODEL6494 a_12800_83.t3 vdd.t24 6.50317372814453e-05f
CMODEL6495 a_12800_83.t3 vdd.n9 6.6519010330586e-05f
CMODEL6496 a_12800_83.t3 vdd.t5 5.18639877449086e-06f
CMODEL6497 a_12800_83.t3 vdd.n10 8.87484786556007e-05f
CMODEL6498 a_12800_83.t3 vdd.t4 6.50675248823872e-05f
CMODEL6499 a_12800_83.t3 vdd.n11 0.000214578876487089f
CMODEL6500 a_12800_83.t3 vdd.n12 0.000529071963123628f
CMODEL6501 a_12800_83.t3 vdd.n13 4.01029891553935e-05f
CMODEL6502 a_12800_83.t3 vdd.t42 3.25586646468489e-06f
CMODEL6503 a_12800_83.t3 vdd.t41 2.57359374652947e-05f
CMODEL6504 a_12800_83.t3 vdd.n14 3.60557097188809e-05f
CMODEL6505 a_12800_83.t3 vdd.t9 3.25586646468489e-06f
CMODEL6506 a_12800_83.t3 vdd.t8 2.57359374652947e-05f
CMODEL6507 a_12800_83.t3 vdd.n15 6.92221671217252e-05f
CMODEL6508 a_12800_83.t3 vdd.t15 5.48319727830173e-06f
CMODEL6509 a_12800_83.t3 vdd.n16 4.31297255050484e-05f
CMODEL6510 a_12800_83.t3 vdd.t14 7.39649189365406e-05f
CMODEL6511 a_12800_83.t3 vdd.n17 6.04154349899577e-05f
CMODEL6512 a_12800_83.t3 vdd.t32 7.39649189365406e-05f
CMODEL6513 a_12800_83.t3 vdd.n18 5.96382475895044e-05f
CMODEL6514 a_12800_83.t3 vdd.t34 5.48319727830173e-06f
CMODEL6515 a_12800_83.t3 vdd.n19 6.00563660605081e-05f
CMODEL6516 a_12800_83.t3 vdd.t33 7.39649189365406e-05f
CMODEL6517 a_12800_83.t3 vdd.n20 0.000119851184404133f
CMODEL6518 a_12800_83.t3 vdd.t48 7.41062799602608e-05f
CMODEL6519 a_12800_83.t3 vdd.n21 0.00021274893715893f
CMODEL6520 a_12800_83.t3 vdd.n22 0.000932344544336584f
CMODEL6521 a_12800_83.t3 vdd.t47 1.05408501584044e-06f
CMODEL6522 a_12800_83.t3 vdd.t45 1.04326224885561e-06f
CMODEL6523 a_12800_83.t3 vdd.n23 1.19128573095116e-05f
CMODEL6524 a_12800_83.t3 vdd.t46 2.84306841702125e-05f
CMODEL6525 a_12800_83.t3 vdd.n24 3.0546208553887e-05f
CMODEL6526 a_12800_83.t3 vdd.t44 2.84306841702125e-05f
CMODEL6527 a_12800_83.t3 vdd.n25 4.81742860878065e-05f
CMODEL6528 a_12800_83.t3 vdd.t43 2.84922686668333e-05f
CMODEL6529 a_12800_83.t3 vdd.n26 0.00025775959932348f
CMODEL6530 a_12800_83.t3 vdd.n27 0.000172317596764896f
CMODEL6531 a_12800_83.t3 vdd.n28 3.89234894743525e-05f
CMODEL6532 a_12800_83.t3 vdd.t29 3.25586646468489e-06f
CMODEL6533 a_12800_83.t3 vdd.t28 2.57359374652947e-05f
CMODEL6534 a_12800_83.t3 vdd.n29 5.81029595091001e-06f
CMODEL6535 a_12800_83.t3 vdd.n30 1.85361282618167e-06f
CMODEL6536 a_12800_83.t3 vdd.t38 8.53444813460174e-07f
CMODEL6537 a_12800_83.t3 vdd.t40 8.53444813460174e-07f
CMODEL6538 a_12800_83.t3 vdd.t37 1.7245567725853e-05f
CMODEL6539 a_12800_83.t3 vdd.t39 1.7245567725853e-05f
CMODEL6540 a_12800_83.t3 vdd.n31 5.58543052499221e-06f
CMODEL6541 a_12800_83.t3 vdd.n32 6.74044552238883e-05f
CMODEL6542 a_12800_83.t3 vdd.n33 3.41538969588308e-05f
CMODEL6543 a_12800_83.t3 vdd.t17 3.25586646468489e-06f
CMODEL6544 a_12800_83.t3 vdd.t16 2.57359374652947e-05f
CMODEL6545 a_12800_83.t3 vdd.n34 5.81029595091001e-06f
CMODEL6546 a_12800_83.t3 vdd.n35 1.85361282618167e-06f
CMODEL6547 a_12800_83.t3 vdd.t1 8.53444813460174e-07f
CMODEL6548 a_12800_83.t3 vdd.t31 8.53444813460174e-07f
CMODEL6549 a_12800_83.t3 vdd.t0 1.7245567725853e-05f
CMODEL6550 a_12800_83.t3 vdd.t30 1.7245567725853e-05f
CMODEL6551 a_12800_83.t3 vdd.n36 5.58543052499221e-06f
CMODEL6552 a_12800_83.t3 vdd.n37 6.5369035420322e-05f
CMODEL6553 a_12800_83.t3 vdd.n38 3.77079039623619e-05f
CMODEL6554 a_12800_83.t3 vdd.t19 3.25586646468489e-06f
CMODEL6555 a_12800_83.t3 vdd.t18 2.57359374652947e-05f
CMODEL6556 a_12800_83.t3 vdd.n39 3.18202471474159e-05f
CMODEL6557 a_12800_83.t3 vdd.t21 3.25589628768568e-06f
CMODEL6558 a_12800_83.t3 vdd.t20 2.57359374652947e-05f
CMODEL6559 a_12800_83.t3 vdd.n40 3.18202471474159e-05f
CMODEL6560 a_12800_83.t3 vdd.t11 3.25586646468489e-06f
CMODEL6561 a_12800_83.t3 vdd.t10 2.57359374652947e-05f
CMODEL6562 a_12800_83.t3 vdd.n41 0.000136896520502716f
CMODEL6563 a_12800_83.t3 vdd.n42 0.000262224997230996f
CMODEL6564 a_12800_83.t3 vdd.n43 3.18202471474159e-05f
CMODEL6565 a_12800_83.t3 vdd.t13 3.25586646468489e-06f
CMODEL6566 a_12800_83.t3 vdd.t12 2.57359374652947e-05f
CMODEL6567 a_12800_83.t3 vdd.n44 3.18202471474159e-05f
CMODEL6568 a_12800_83.t3 vdd.t23 3.25586646468489e-06f
CMODEL6569 a_12800_83.t3 vdd.t22 2.57359374652947e-05f
CMODEL6570 a_12800_83.t3 vdd.n45 3.92807690237551e-05f
CMODEL6571 a_12800_83.t3 vdd.n46 0.000648369930863202f
CMODEL6572 a_12800_83.n1 vdd 0.00053367758900354f
CMODEL6573 a_12800_83.n1 vdd.n0 0.179092267944104f
CMODEL6574 a_12800_83.n1 vdd.n1 0.0165966162053934f
CMODEL6575 a_12800_83.n1 vdd.t7 0.00136816532208091f
CMODEL6576 a_12800_83.n1 vdd.t6 0.0108146379936583f
CMODEL6577 a_12800_83.n1 vdd.n2 0.014882853573657f
CMODEL6578 a_12800_83.n1 vdd.t27 0.00136816532208091f
CMODEL6579 a_12800_83.n1 vdd.t26 0.0108146379936583f
CMODEL6580 a_12800_83.n1 vdd.n3 0.027914718184188f
CMODEL6581 a_12800_83.n1 vdd.n4 0.014882853573657f
CMODEL6582 a_12800_83.n1 vdd.t36 0.00136816532208091f
CMODEL6583 a_12800_83.n1 vdd.t35 0.0108146379936583f
CMODEL6584 a_12800_83.n1 vdd.n5 0.0212354928106115f
CMODEL6585 a_12800_83.n1 vdd.t3 0.00217940478416645f
CMODEL6586 a_12800_83.n1 vdd.n6 0.020851509724422f
CMODEL6587 a_12800_83.n1 vdd.t2 0.0273273393575007f
CMODEL6588 a_12800_83.n1 vdd.n7 0.0279523144393632f
CMODEL6589 a_12800_83.n1 vdd.t25 0.00217940478416645f
CMODEL6590 a_12800_83.n1 vdd.n8 0.0125944948419928f
CMODEL6591 a_12800_83.n1 vdd.t24 0.0273273393575007f
CMODEL6592 a_12800_83.n1 vdd.n9 0.0279523144393632f
CMODEL6593 a_12800_83.n1 vdd.t5 0.00217940478416645f
CMODEL6594 a_12800_83.n1 vdd.n10 0.0372934800001948f
CMODEL6595 a_12800_83.n1 vdd.t4 0.0273423778595707f
CMODEL6596 a_12800_83.n1 vdd.n11 0.0901693545620065f
CMODEL6597 a_12800_83.n1 vdd.n12 0.222324201770074f
CMODEL6598 a_12800_83.n1 vdd.n13 0.0168518947780331f
CMODEL6599 a_12800_83.n1 vdd.t42 0.00136816532208091f
CMODEL6600 a_12800_83.n1 vdd.t41 0.0108146379936583f
CMODEL6601 a_12800_83.n1 vdd.n14 0.0151511655147573f
CMODEL6602 a_12800_83.n1 vdd.t9 0.00136816532208091f
CMODEL6603 a_12800_83.n1 vdd.t8 0.0108146379936583f
CMODEL6604 a_12800_83.n1 vdd.n15 0.0290882226290567f
CMODEL6605 a_12800_83.n1 vdd.t15 0.00230412409466766f
CMODEL6606 a_12800_83.n1 vdd.n16 0.0181237760906103f
CMODEL6607 a_12800_83.n1 vdd.t14 0.0310812001158944f
CMODEL6608 a_12800_83.n1 vdd.n17 0.0253874979113106f
CMODEL6609 a_12800_83.n1 vdd.t32 0.0310812001158944f
CMODEL6610 a_12800_83.n1 vdd.n18 0.0250609117746887f
CMODEL6611 a_12800_83.n1 vdd.t34 0.00230412409466766f
CMODEL6612 a_12800_83.n1 vdd.n19 0.0252366116072075f
CMODEL6613 a_12800_83.n1 vdd.t33 0.0310812001158944f
CMODEL6614 a_12800_83.n1 vdd.n20 0.0503633168284527f
CMODEL6615 a_12800_83.n1 vdd.t48 0.0311406021990712f
CMODEL6616 a_12800_83.n1 vdd.n21 0.089400385822823f
CMODEL6617 a_12800_83.n1 vdd.n22 0.391785562346796f
CMODEL6618 a_12800_83.n1 vdd.t47 0.000442942786763699f
CMODEL6619 a_12800_83.n1 vdd.t45 0.000438394893096004f
CMODEL6620 a_12800_83.n1 vdd.n23 0.00500596644074877f
CMODEL6621 a_12800_83.n1 vdd.t46 0.0119470121353654f
CMODEL6622 a_12800_83.n1 vdd.n24 0.0128359881210682f
CMODEL6623 a_12800_83.n1 vdd.t44 0.0119470121353654f
CMODEL6624 a_12800_83.n1 vdd.n25 0.020243578278239f
CMODEL6625 a_12800_83.n1 vdd.t43 0.011972890891011f
CMODEL6626 a_12800_83.n1 vdd.n26 0.108314560518067f
CMODEL6627 a_12800_83.n1 vdd.n27 0.0724105127882969f
CMODEL6628 a_12800_83.n1 vdd.n28 0.0163562508139733f
CMODEL6629 a_12800_83.n1 vdd.t29 0.00136816532208091f
CMODEL6630 a_12800_83.n1 vdd.t28 0.0108146379936583f
CMODEL6631 a_12800_83.n1 vdd.n29 0.00244157600358821f
CMODEL6632 a_12800_83.n1 vdd.n30 0.000778916708302902f
CMODEL6633 a_12800_83.n1 vdd.t38 0.000358630678116288f
CMODEL6634 a_12800_83.n1 vdd.t40 0.000358630678116288f
CMODEL6635 a_12800_83.n1 vdd.t37 0.00724685363421173f
CMODEL6636 a_12800_83.n1 vdd.t39 0.00724685363421173f
CMODEL6637 a_12800_83.n1 vdd.n31 0.00234708408224786f
CMODEL6638 a_12800_83.n1 vdd.n32 0.0283243920447471f
CMODEL6639 a_12800_83.n1 vdd.n33 0.0143519944505831f
CMODEL6640 a_12800_83.n1 vdd.t17 0.00136816532208091f
CMODEL6641 a_12800_83.n1 vdd.t16 0.0108146379936583f
CMODEL6642 a_12800_83.n1 vdd.n34 0.00244157600358821f
CMODEL6643 a_12800_83.n1 vdd.n35 0.000778916708302902f
CMODEL6644 a_12800_83.n1 vdd.t1 0.000358630678116288f
CMODEL6645 a_12800_83.n1 vdd.t31 0.000358630678116288f
CMODEL6646 a_12800_83.n1 vdd.t0 0.00724685363421173f
CMODEL6647 a_12800_83.n1 vdd.t30 0.00724685363421173f
CMODEL6648 a_12800_83.n1 vdd.n36 0.00234708408224786f
CMODEL6649 a_12800_83.n1 vdd.n37 0.0274690772395112f
CMODEL6650 a_12800_83.n1 vdd.n38 0.0158454430269928f
CMODEL6651 a_12800_83.n1 vdd.t19 0.00136816532208091f
CMODEL6652 a_12800_83.n1 vdd.t18 0.0108146379936583f
CMODEL6653 a_12800_83.n1 vdd.n39 0.0133713587947631f
CMODEL6654 a_12800_83.n1 vdd.t21 0.00136817785416597f
CMODEL6655 a_12800_83.n1 vdd.t20 0.0108146379936583f
CMODEL6656 a_12800_83.n1 vdd.n40 0.0133713587947631f
CMODEL6657 a_12800_83.n1 vdd.t11 0.00136816532208091f
CMODEL6658 a_12800_83.n1 vdd.t10 0.0108146379936583f
CMODEL6659 a_12800_83.n1 vdd.n41 0.0575260300435824f
CMODEL6660 a_12800_83.n1 vdd.n42 0.110190989613861f
CMODEL6661 a_12800_83.n1 vdd.n43 0.0133713587947631f
CMODEL6662 a_12800_83.n1 vdd.t13 0.00136816532208091f
CMODEL6663 a_12800_83.n1 vdd.t12 0.0108146379936583f
CMODEL6664 a_12800_83.n1 vdd.n44 0.0133713587947631f
CMODEL6665 a_12800_83.n1 vdd.t23 0.00136816532208091f
CMODEL6666 a_12800_83.n1 vdd.t22 0.0108146379936583f
CMODEL6667 a_12800_83.n1 vdd.n45 0.0165063851929729f
CMODEL6668 a_12800_83.n1 vdd.n46 0.272455048420693f
CMODEL6669 a_16000_n24000.t0 a_20800_n23917.t0 0.000147726218577769f
CMODEL6670 a_16000_n24000.t0 a_20800_n23917.t1 0.00014767035307506f
CMODEL6671 a_16000_n24000.t1 a_20800_n23917.t0 0.000147697141426899f
CMODEL6672 a_16000_n24000.t1 a_20800_n23917.t1 0.000147641286920272f
CMODEL6673 a_0_n11917.t2 a_6400_n24000.t0 0.00046682983540721f
CMODEL6674 a_0_n11917.t2 a_6400_n24000.t1 0.00046672830301233f
CMODEL6675 a_0_n11917.t1 a_6400_n24000.t0 0.000730290572865815f
CMODEL6676 a_0_n11917.t1 a_6400_n24000.t1 0.000730131739506852f
CMODEL6677 a_0_n11917.n0 a_6400_n24000.t0 0.0199137016487299f
CMODEL6678 a_0_n11917.n0 a_6400_n24000.t1 0.0199093705506167f
CMODEL6679 a_0_n11917.t6 a_6400_n24000.t0 0.00124422961097314f
CMODEL6680 a_0_n11917.t6 a_6400_n24000.t1 0.00124395899927997f
CMODEL6681 a_0_n11917.n1 a_6400_n24000.t0 0.077201503145339f
CMODEL6682 a_0_n11917.n1 a_6400_n24000.t1 0.077184712330125f
CMODEL6683 a_0_n11917.t4 a_6400_n24000.t0 9.87761440244832e-05f
CMODEL6684 a_0_n11917.t4 a_6400_n24000.t1 9.87546608678826e-05f
CMODEL6685 a_0_n11917.t5 a_6400_n24000.t0 9.9727390351422e-05f
CMODEL6686 a_0_n11917.t5 a_6400_n24000.t1 9.97057003050505e-05f
CMODEL6687 a_0_n11917.n2 a_6400_n24000.t0 0.0250801326829199f
CMODEL6688 a_0_n11917.n2 a_6400_n24000.t1 0.0250746779203018f
CMODEL6689 a_0_n11917.t0 a_6400_n24000.t0 0.00019767360557376f
CMODEL6690 a_0_n11917.t0 a_6400_n24000.t1 0.000197630612874802f
CMODEL6691 a_0_n11917.t3 a_6400_n24000.t0 0.00035499554074412f
CMODEL6692 a_0_n11917.t3 a_6400_n24000.t1 0.00035491833156705f
CMODEL6693 a_0_n11917.n3 a_6400_n24000.t0 0.055039860845023f
CMODEL6694 a_0_n11917.n3 a_6400_n24000.t1 0.0550278900401138f
CMODEL6695 a_0_n11917.n4 a_6400_n24000.t0 0.10025680248974f
CMODEL6696 a_0_n11917.n4 a_6400_n24000.t1 0.100234997299737f
CMODEL6697 a_9600_n35917.t0 a_9600_n36000.t1 0.000293277254430359f
CMODEL6698 a_9600_n35917.t0 a_9600_n36000.t2 0.000383771965516009f
CMODEL6699 a_9600_n35917.t0 a_9600_n36000.t0 0.000118499782061384f
CMODEL6700 a_9600_n35917.t0 a_9600_n36000.n0 0.00608330531079037f
CMODEL6701 a_9600_n35917.t0 a_9600_n36000.t3 0.000126803839310088f
CMODEL6702 a_9600_n35917.t0 a_9600_n36000.n1 0.00304262830165624f
CMODEL6703 a_9600_n35917.n0 a_9600_n36000.t1 0.00160986345942475f
CMODEL6704 a_9600_n35917.n0 a_9600_n36000.t2 0.00210660886482946f
CMODEL6705 a_9600_n35917.n0 a_9600_n36000.t0 0.000650471409591426f
CMODEL6706 a_9600_n35917.n0 a_9600_n36000.n0 0.033392603021287f
CMODEL6707 a_9600_n35917.n0 a_9600_n36000.t3 0.000696054209238215f
CMODEL6708 a_9600_n35917.n0 a_9600_n36000.n1 0.0167016570479082f
CMODEL6709 a_9600_n35917.t2 a_9600_n36000.t1 0.000595204139345594f
CMODEL6710 a_9600_n35917.t2 a_9600_n36000.t2 0.000778862523394783f
CMODEL6711 a_9600_n35917.t2 a_9600_n36000.t0 0.000240494479981006f
CMODEL6712 a_9600_n35917.t2 a_9600_n36000.n0 0.012346025636793f
CMODEL6713 a_9600_n35917.t2 a_9600_n36000.t3 0.000257347506164f
CMODEL6714 a_9600_n35917.t2 a_9600_n36000.n1 0.00617499288566846f
CMODEL6715 a_9600_n35917.n1 a_9600_n36000.t1 0.0188288039604937f
CMODEL6716 a_9600_n35917.n1 a_9600_n36000.t2 0.0246386891416776f
CMODEL6717 a_9600_n35917.n1 a_9600_n36000.t0 0.00760784933740863f
CMODEL6718 a_9600_n35917.n1 a_9600_n36000.n0 0.390556585614453f
CMODEL6719 a_9600_n35917.n1 a_9600_n36000.t3 0.00814098125831485f
CMODEL6720 a_9600_n35917.n1 a_9600_n36000.n1 0.195340930641926f
CMODEL6721 a_9600_n35917.t1 a_9600_n36000.t1 0.000312727390180683f
CMODEL6722 a_9600_n35917.t1 a_9600_n36000.t2 0.000409223706875746f
CMODEL6723 a_9600_n35917.t1 a_9600_n36000.t0 0.000126358682854609f
CMODEL6724 a_9600_n35917.t1 a_9600_n36000.n0 0.00648674987499757f
CMODEL6725 a_9600_n35917.t1 a_9600_n36000.t3 0.000135213464846967f
CMODEL6726 a_9600_n35917.t1 a_9600_n36000.n1 0.00324441528858074f
CMODEL6727 a_20800_n23917.t0 vdd 6.48104797213796e-07f
CMODEL6728 a_20800_n23917.t0 vdd.n0 0.000217491909703749f
CMODEL6729 a_20800_n23917.t0 vdd.n1 2.01551401105591e-05f
CMODEL6730 a_20800_n23917.t0 vdd.t7 1.66151722855335e-06f
CMODEL6731 a_20800_n23917.t0 vdd.t6 1.31334328220667e-05f
CMODEL6732 a_20800_n23917.t0 vdd.n2 1.80739251489415e-05f
CMODEL6733 a_20800_n23917.t0 vdd.t27 1.66151722855335e-06f
CMODEL6734 a_20800_n23917.t0 vdd.t26 1.31334328220667e-05f
CMODEL6735 a_20800_n23917.t0 vdd.n3 3.38999859481141e-05f
CMODEL6736 a_20800_n23917.t0 vdd.n4 1.80739251489415e-05f
CMODEL6737 a_20800_n23917.t0 vdd.t36 1.66151722855335e-06f
CMODEL6738 a_20800_n23917.t0 vdd.t35 1.31334328220667e-05f
CMODEL6739 a_20800_n23917.t0 vdd.n5 2.57886503861887e-05f
CMODEL6740 a_20800_n23917.t0 vdd.t3 2.64669666628928e-06f
CMODEL6741 a_20800_n23917.t0 vdd.n6 2.53223364818087e-05f
CMODEL6742 a_20800_n23917.t0 vdd.t2 3.3186665690337e-05f
CMODEL6743 a_20800_n23917.t0 vdd.n7 3.39456433147309e-05f
CMODEL6744 a_20800_n23917.t0 vdd.t25 2.64669666628928e-06f
CMODEL6745 a_20800_n23917.t0 vdd.n8 1.52949134341966e-05f
CMODEL6746 a_20800_n23917.t0 vdd.t24 3.3186665690337e-05f
CMODEL6747 a_20800_n23917.t0 vdd.n9 3.39456433147309e-05f
CMODEL6748 a_20800_n23917.t0 vdd.t5 2.64669666628928e-06f
CMODEL6749 a_20800_n23917.t0 vdd.n10 4.52896726243505e-05f
CMODEL6750 a_20800_n23917.t0 vdd.t4 3.32049286369837e-05f
CMODEL6751 a_20800_n23917.t0 vdd.n11 0.00010950280179916f
CMODEL6752 a_20800_n23917.t0 vdd.n12 0.000269993315576451f
CMODEL6753 a_20800_n23917.t0 vdd.n13 2.04651536298874e-05f
CMODEL6754 a_20800_n23917.t0 vdd.t42 1.66151722855335e-06f
CMODEL6755 a_20800_n23917.t0 vdd.t41 1.31334328220667e-05f
CMODEL6756 a_20800_n23917.t0 vdd.n14 1.83997665553637e-05f
CMODEL6757 a_20800_n23917.t0 vdd.t9 1.66151722855335e-06f
CMODEL6758 a_20800_n23917.t0 vdd.t8 1.31334328220667e-05f
CMODEL6759 a_20800_n23917.t0 vdd.n15 3.53251045514476e-05f
CMODEL6760 a_20800_n23917.t0 vdd.t15 2.79815737047954e-06f
CMODEL6761 a_20800_n23917.t0 vdd.n16 2.2009742342535e-05f
CMODEL6762 a_20800_n23917.t0 vdd.t14 3.77454015558062e-05f
CMODEL6763 a_20800_n23917.t0 vdd.n17 3.08308977641302e-05f
CMODEL6764 a_20800_n23917.t0 vdd.t32 3.77454015558062e-05f
CMODEL6765 a_20800_n23917.t0 vdd.n18 3.04342874394519e-05f
CMODEL6766 a_20800_n23917.t0 vdd.t34 2.79815737047954e-06f
CMODEL6767 a_20800_n23917.t0 vdd.n19 3.06476595327746e-05f
CMODEL6768 a_20800_n23917.t0 vdd.t33 3.77454015558062e-05f
CMODEL6769 a_20800_n23917.t0 vdd.n20 6.1161847363806e-05f
CMODEL6770 a_20800_n23917.t0 vdd.t48 3.78175401950608e-05f
CMODEL6771 a_20800_n23917.t0 vdd.n21 0.000108568956460623f
CMODEL6772 a_20800_n23917.t0 vdd.n22 0.000475789329865187f
CMODEL6773 a_20800_n23917.t0 vdd.t47 5.37915308620719e-07f
CMODEL6774 a_20800_n23917.t0 vdd.t45 5.32392289172302e-07f
CMODEL6775 a_20800_n23917.t0 vdd.n23 6.0793088032764e-06f
CMODEL6776 a_20800_n23917.t0 vdd.t46 1.45086022663215e-05f
CMODEL6777 a_20800_n23917.t0 vdd.n24 1.55881859190988e-05f
CMODEL6778 a_20800_n23917.t0 vdd.t44 1.45086022663215e-05f
CMODEL6779 a_20800_n23917.t0 vdd.n25 2.45840568636144e-05f
CMODEL6780 a_20800_n23917.t0 vdd.t43 1.45400297536761e-05f
CMODEL6781 a_20800_n23917.t0 vdd.n26 0.000131538568840666f
CMODEL6782 a_20800_n23917.t0 vdd.n27 8.79362402952522e-05f
CMODEL6783 a_20800_n23917.t0 vdd.n28 1.98632373466554e-05f
CMODEL6784 a_20800_n23917.t0 vdd.t29 1.66151722855335e-06f
CMODEL6785 a_20800_n23917.t0 vdd.t28 1.31334328220667e-05f
CMODEL6786 a_20800_n23917.t0 vdd.n29 2.9650807028307e-06f
CMODEL6787 a_20800_n23917.t0 vdd.n30 9.4592627774321e-07f
CMODEL6788 a_20800_n23917.t0 vdd.t38 4.35525620158018e-07f
CMODEL6789 a_20800_n23917.t0 vdd.t40 4.35525620158018e-07f
CMODEL6790 a_20800_n23917.t0 vdd.t37 8.80067048310642e-06f
CMODEL6791 a_20800_n23917.t0 vdd.t39 8.80067048310642e-06f
CMODEL6792 a_20800_n23917.t0 vdd.n31 2.85032852140038e-06f
CMODEL6793 a_20800_n23917.t0 vdd.n32 3.43974990530155e-05f
CMODEL6794 a_20800_n23917.t0 vdd.n33 1.74292431323118e-05f
CMODEL6795 a_20800_n23917.t0 vdd.t17 1.66151722855335e-06f
CMODEL6796 a_20800_n23917.t0 vdd.t16 1.31334328220667e-05f
CMODEL6797 a_20800_n23917.t0 vdd.n34 2.9650807028307e-06f
CMODEL6798 a_20800_n23917.t0 vdd.n35 9.4592627774321e-07f
CMODEL6799 a_20800_n23917.t0 vdd.t1 4.35525620158018e-07f
CMODEL6800 a_20800_n23917.t0 vdd.t31 4.35525620158018e-07f
CMODEL6801 a_20800_n23917.t0 vdd.t0 8.80067048310642e-06f
CMODEL6802 a_20800_n23917.t0 vdd.t30 8.80067048310642e-06f
CMODEL6803 a_20800_n23917.t0 vdd.n36 2.85032852140038e-06f
CMODEL6804 a_20800_n23917.t0 vdd.n37 3.33587939624825e-05f
CMODEL6805 a_20800_n23917.t0 vdd.n38 1.92429059255546e-05f
CMODEL6806 a_20800_n23917.t0 vdd.t19 1.66151722855335e-06f
CMODEL6807 a_20800_n23917.t0 vdd.t18 1.31334328220667e-05f
CMODEL6808 a_20800_n23917.t0 vdd.n39 1.62383468197226e-05f
CMODEL6809 a_20800_n23917.t0 vdd.t21 1.66153244767556e-06f
CMODEL6810 a_20800_n23917.t0 vdd.t20 1.31334328220667e-05f
CMODEL6811 a_20800_n23917.t0 vdd.n40 1.62383468197226e-05f
CMODEL6812 a_20800_n23917.t0 vdd.t11 1.66151722855335e-06f
CMODEL6813 a_20800_n23917.t0 vdd.t10 1.31334328220667e-05f
CMODEL6814 a_20800_n23917.t0 vdd.n41 6.9860336660424e-05f
CMODEL6815 a_20800_n23917.t0 vdd.n42 0.000133817328008513f
CMODEL6816 a_20800_n23917.t0 vdd.n43 1.62383468197226e-05f
CMODEL6817 a_20800_n23917.t0 vdd.t13 1.66151722855335e-06f
CMODEL6818 a_20800_n23917.t0 vdd.t12 1.31334328220667e-05f
CMODEL6819 a_20800_n23917.t0 vdd.n44 1.62383468197226e-05f
CMODEL6820 a_20800_n23917.t0 vdd.t23 1.66151722855335e-06f
CMODEL6821 a_20800_n23917.t0 vdd.t22 1.31334328220667e-05f
CMODEL6822 a_20800_n23917.t0 vdd.n45 2.00455624306787e-05f
CMODEL6823 a_20800_n23917.t0 vdd.n46 0.000330872848223343f
CMODEL6824 a_20800_n23917.t1 vdd 6.47859703955112e-07f
CMODEL6825 a_20800_n23917.t1 vdd.n0 0.000217409660966946f
CMODEL6826 a_20800_n23917.t1 vdd.n1 2.01475180577828e-05f
CMODEL6827 a_20800_n23917.t1 vdd.t7 1.66088889394812e-06f
CMODEL6828 a_20800_n23917.t1 vdd.t6 1.31284661625667e-05f
CMODEL6829 a_20800_n23917.t1 vdd.n2 1.80670901475174e-05f
CMODEL6830 a_20800_n23917.t1 vdd.t27 1.66088889394812e-06f
CMODEL6831 a_20800_n23917.t1 vdd.t26 1.31284661625667e-05f
CMODEL6832 a_20800_n23917.t1 vdd.n3 3.388716601828e-05f
CMODEL6833 a_20800_n23917.t1 vdd.n4 1.80670901475174e-05f
CMODEL6834 a_20800_n23917.t1 vdd.t36 1.66088889394812e-06f
CMODEL6835 a_20800_n23917.t1 vdd.t35 1.31284661625667e-05f
CMODEL6836 a_20800_n23917.t1 vdd.n5 2.57788979134599e-05f
CMODEL6837 a_20800_n23917.t1 vdd.t3 2.6456957671855e-06f
CMODEL6838 a_20800_n23917.t1 vdd.n6 2.5312760354626e-05f
CMODEL6839 a_20800_n23917.t1 vdd.t2 3.31741155162388e-05f
CMODEL6840 a_20800_n23917.t1 vdd.n7 3.39328061186881e-05f
CMODEL6841 a_20800_n23917.t1 vdd.t25 2.6456957671855e-06f
CMODEL6842 a_20800_n23917.t1 vdd.n8 1.52891293693494e-05f
CMODEL6843 a_20800_n23917.t1 vdd.t24 3.31741155162388e-05f
CMODEL6844 a_20800_n23917.t1 vdd.n9 3.39328061186881e-05f
CMODEL6845 a_20800_n23917.t1 vdd.t5 2.6456957671855e-06f
CMODEL6846 a_20800_n23917.t1 vdd.n10 4.52725454660638e-05f
CMODEL6847 a_20800_n23917.t1 vdd.t4 3.3192371556402e-05f
CMODEL6848 a_20800_n23917.t1 vdd.n11 0.00010946139121457f
CMODEL6849 a_20800_n23917.t1 vdd.n12 0.000269891212426124f
CMODEL6850 a_20800_n23917.t1 vdd.n13 2.04574143395532e-05f
CMODEL6851 a_20800_n23917.t1 vdd.t42 1.66088889394812e-06f
CMODEL6852 a_20800_n23917.t1 vdd.t41 1.31284661625667e-05f
CMODEL6853 a_20800_n23917.t1 vdd.n14 1.83928083307626e-05f
CMODEL6854 a_20800_n23917.t1 vdd.t9 1.66088889394812e-06f
CMODEL6855 a_20800_n23917.t1 vdd.t8 1.31284661625667e-05f
CMODEL6856 a_20800_n23917.t1 vdd.n15 3.53117456856823e-05f
CMODEL6857 a_20800_n23917.t1 vdd.t15 2.79709919360569e-06f
CMODEL6858 a_20800_n23917.t1 vdd.n16 2.20014189363564e-05f
CMODEL6859 a_20800_n23917.t1 vdd.t14 3.77311274083112e-05f
CMODEL6860 a_20800_n23917.t1 vdd.n17 3.08192384688532e-05f
CMODEL6861 a_20800_n23917.t1 vdd.t32 3.77311274083112e-05f
CMODEL6862 a_20800_n23917.t1 vdd.n18 3.04227781299755e-05f
CMODEL6863 a_20800_n23917.t1 vdd.t34 2.79709919360569e-06f
CMODEL6864 a_20800_n23917.t1 vdd.n19 3.0636069532549e-05f
CMODEL6865 a_20800_n23917.t1 vdd.t33 3.77311274083112e-05f
CMODEL6866 a_20800_n23917.t1 vdd.n20 6.11387178382386e-05f
CMODEL6867 a_20800_n23917.t1 vdd.t48 3.78032387669559e-05f
CMODEL6868 a_20800_n23917.t1 vdd.n21 0.000108527899027558f
CMODEL6869 a_20800_n23917.t1 vdd.n22 0.000475609401005217f
CMODEL6870 a_20800_n23917.t1 vdd.t47 5.37711885630405e-07f
CMODEL6871 a_20800_n23917.t1 vdd.t45 5.32190954817716e-07f
CMODEL6872 a_20800_n23917.t1 vdd.n23 6.07700979606098e-06f
CMODEL6873 a_20800_n23917.t1 vdd.t46 1.45031155601226e-05f
CMODEL6874 a_20800_n23917.t1 vdd.n24 1.55822909476369e-05f
CMODEL6875 a_20800_n23917.t1 vdd.t44 1.45031155601226e-05f
CMODEL6876 a_20800_n23917.t1 vdd.n25 2.45747599310284e-05f
CMODEL6877 a_20800_n23917.t1 vdd.t43 1.45345311625701e-05f
CMODEL6878 a_20800_n23917.t1 vdd.n26 0.000131488825008159f
CMODEL6879 a_20800_n23917.t1 vdd.n27 8.79029855195075e-05f
CMODEL6880 a_20800_n23917.t1 vdd.n28 1.98557256825075e-05f
CMODEL6881 a_20800_n23917.t1 vdd.t29 1.66088889394812e-06f
CMODEL6882 a_20800_n23917.t1 vdd.t28 1.31284661625667e-05f
CMODEL6883 a_20800_n23917.t1 vdd.n29 2.9639594006974e-06f
CMODEL6884 a_20800_n23917.t1 vdd.n30 9.45568557579922e-07f
CMODEL6885 a_20800_n23917.t1 vdd.t38 4.35360917792068e-07f
CMODEL6886 a_20800_n23917.t1 vdd.t40 4.35360917792068e-07f
CMODEL6887 a_20800_n23917.t1 vdd.t37 8.79734234078039e-06f
CMODEL6888 a_20800_n23917.t1 vdd.t39 8.79734234078039e-06f
CMODEL6889 a_20800_n23917.t1 vdd.n31 2.84925061500525e-06f
CMODEL6890 a_20800_n23917.t1 vdd.n32 3.43844909790594e-05f
CMODEL6891 a_20800_n23917.t1 vdd.n33 1.74226519297562e-05f
CMODEL6892 a_20800_n23917.t1 vdd.t17 1.66088889394812e-06f
CMODEL6893 a_20800_n23917.t1 vdd.t16 1.31284661625667e-05f
CMODEL6894 a_20800_n23917.t1 vdd.n34 2.9639594006974e-06f
CMODEL6895 a_20800_n23917.t1 vdd.n35 9.45568557579922e-07f
CMODEL6896 a_20800_n23917.t1 vdd.t1 4.35360917792068e-07f
CMODEL6897 a_20800_n23917.t1 vdd.t31 4.35360917792068e-07f
CMODEL6898 a_20800_n23917.t1 vdd.t0 8.79734234078039e-06f
CMODEL6899 a_20800_n23917.t1 vdd.t30 8.79734234078039e-06f
CMODEL6900 a_20800_n23917.t1 vdd.n36 2.84925061500525e-06f
CMODEL6901 a_20800_n23917.t1 vdd.n37 3.3346178694777e-05f
CMODEL6902 a_20800_n23917.t1 vdd.n38 1.92356288516306e-05f
CMODEL6903 a_20800_n23917.t1 vdd.t19 1.66088889394812e-06f
CMODEL6904 a_20800_n23917.t1 vdd.t18 1.31284661625667e-05f
CMODEL6905 a_20800_n23917.t1 vdd.n39 1.62322059774471e-05f
CMODEL6906 a_20800_n23917.t1 vdd.t21 1.66090410731493e-06f
CMODEL6907 a_20800_n23917.t1 vdd.t20 1.31284661625667e-05f
CMODEL6908 a_20800_n23917.t1 vdd.n40 1.62322059774471e-05f
CMODEL6909 a_20800_n23917.t1 vdd.t11 1.66088889394812e-06f
CMODEL6910 a_20800_n23917.t1 vdd.t10 1.31284661625667e-05f
CMODEL6911 a_20800_n23917.t1 vdd.n41 6.98339176343058e-05f
CMODEL6912 a_20800_n23917.t1 vdd.n42 0.000133766722419523f
CMODEL6913 a_20800_n23917.t1 vdd.n43 1.62322059774471e-05f
CMODEL6914 a_20800_n23917.t1 vdd.t13 1.66088889394812e-06f
CMODEL6915 a_20800_n23917.t1 vdd.t12 1.31284661625667e-05f
CMODEL6916 a_20800_n23917.t1 vdd.n44 1.62322059774471e-05f
CMODEL6917 a_20800_n23917.t1 vdd.t23 1.66088889394812e-06f
CMODEL6918 a_20800_n23917.t1 vdd.t22 1.31284661625667e-05f
CMODEL6919 a_20800_n23917.t1 vdd.n45 2.00379818168035e-05f
CMODEL6920 a_20800_n23917.t1 vdd.n46 0.000330747722310173f
CMODEL6921 a_16000_n24000.t0 vdd 0.000127800281823957f
CMODEL6922 a_16000_n24000.t0 vdd.n0 0.0428873964119117f
CMODEL6923 a_16000_n24000.t0 vdd.n1 0.00397440753008509f
CMODEL6924 a_16000_n24000.t0 vdd.t7 0.000327635856079662f
CMODEL6925 a_16000_n24000.t0 vdd.t6 0.00258979168676395f
CMODEL6926 a_16000_n24000.t0 vdd.n2 0.00356401115626653f
CMODEL6927 a_16000_n24000.t0 vdd.t27 0.000327635856079662f
CMODEL6928 a_16000_n24000.t0 vdd.t26 0.00258979168676395f
CMODEL6929 a_16000_n24000.t0 vdd.n3 0.00668476421810525f
CMODEL6930 a_16000_n24000.t0 vdd.n4 0.00356401115626653f
CMODEL6931 a_16000_n24000.t0 vdd.t36 0.000327635856079662f
CMODEL6932 a_16000_n24000.t0 vdd.t35 0.00258979168676395f
CMODEL6933 a_16000_n24000.t0 vdd.n5 0.00508528374019608f
CMODEL6934 a_16000_n24000.t0 vdd.t3 0.000521904144682199f
CMODEL6935 a_16000_n24000.t0 vdd.n6 0.00499333094389772f
CMODEL6936 a_16000_n24000.t0 vdd.t2 0.00654410404961621f
CMODEL6937 a_16000_n24000.t0 vdd.n7 0.00669376742923107f
CMODEL6938 a_16000_n24000.t0 vdd.t25 0.000521904144682199f
CMODEL6939 a_16000_n24000.t0 vdd.n8 0.0030160157057417f
CMODEL6940 a_16000_n24000.t0 vdd.t24 0.00654410404961621f
CMODEL6941 a_16000_n24000.t0 vdd.n9 0.00669376742923107f
CMODEL6942 a_16000_n24000.t0 vdd.t5 0.000521904144682199f
CMODEL6943 a_16000_n24000.t0 vdd.n10 0.00893070526555194f
CMODEL6944 a_16000_n24000.t0 vdd.t4 0.00654770533406654f
CMODEL6945 a_16000_n24000.t0 vdd.n11 0.0215929414357181f
CMODEL6946 a_16000_n24000.t0 vdd.n12 0.0532401888854904f
CMODEL6947 a_16000_n24000.t0 vdd.n13 0.0040355393336294f
CMODEL6948 a_16000_n24000.t0 vdd.t42 0.000327635856079662f
CMODEL6949 a_16000_n24000.t0 vdd.t41 0.00258979168676395f
CMODEL6950 a_16000_n24000.t0 vdd.n14 0.00362826407300112f
CMODEL6951 a_16000_n24000.t0 vdd.t9 0.000327635856079662f
CMODEL6952 a_16000_n24000.t0 vdd.t8 0.00258979168676395f
CMODEL6953 a_16000_n24000.t0 vdd.n15 0.0069657844480458f
CMODEL6954 a_16000_n24000.t0 vdd.t15 0.000551770797056915f
CMODEL6955 a_16000_n24000.t0 vdd.n16 0.00434011796601584f
CMODEL6956 a_16000_n24000.t0 vdd.t14 0.00744304466982544f
CMODEL6957 a_16000_n24000.t0 vdd.n17 0.00607956836622773f
CMODEL6958 a_16000_n24000.t0 vdd.t32 0.00744304466982544f
CMODEL6959 a_16000_n24000.t0 vdd.n18 0.00600136047224812f
CMODEL6960 a_16000_n24000.t0 vdd.t34 0.000551770797056915f
CMODEL6961 a_16000_n24000.t0 vdd.n19 0.00604343547890945f
CMODEL6962 a_16000_n24000.t0 vdd.t33 0.00744304466982544f
CMODEL6963 a_16000_n24000.t0 vdd.n20 0.0120605515706277f
CMODEL6964 a_16000_n24000.t0 vdd.t48 0.00745726974340424f
CMODEL6965 a_16000_n24000.t0 vdd.n21 0.0214087957574914f
CMODEL6966 a_16000_n24000.t0 vdd.n22 0.0938212627140048f
CMODEL6967 a_16000_n24000.t0 vdd.t47 0.000106071932092906f
CMODEL6968 a_16000_n24000.t0 vdd.t45 0.00010498284365372f
CMODEL6969 a_16000_n24000.t0 vdd.n23 0.00119878356354349f
CMODEL6970 a_16000_n24000.t0 vdd.t46 0.00286096240373286f
CMODEL6971 a_16000_n24000.t0 vdd.n24 0.00307384633187321f
CMODEL6972 a_16000_n24000.t0 vdd.t44 0.00286096240373286f
CMODEL6973 a_16000_n24000.t0 vdd.n25 0.00484774901999324f
CMODEL6974 a_16000_n24000.t0 vdd.t43 0.0028671596140578f
CMODEL6975 a_16000_n24000.t0 vdd.n26 0.0259381912320757f
CMODEL6976 a_16000_n24000.t0 vdd.n27 0.0173402146390303f
CMODEL6977 a_16000_n24000.t0 vdd.n28 0.00391684700028735f
CMODEL6978 a_16000_n24000.t0 vdd.t29 0.000327635856079662f
CMODEL6979 a_16000_n24000.t0 vdd.t28 0.00258979168676395f
CMODEL6980 a_16000_n24000.t0 vdd.n29 0.000584686536932907f
CMODEL6981 a_16000_n24000.t0 vdd.n30 0.000186527927890633f
CMODEL6982 a_16000_n24000.t0 vdd.t38 8.5881630929183e-05f
CMODEL6983 a_16000_n24000.t0 vdd.t40 8.5881630929183e-05f
CMODEL6984 a_16000_n24000.t0 vdd.t37 0.00173541095948678f
CMODEL6985 a_16000_n24000.t0 vdd.t39 0.00173541095948678f
CMODEL6986 a_16000_n24000.t0 vdd.n31 0.00056205846630335f
CMODEL6987 a_16000_n24000.t0 vdd.n32 0.00678286920867292f
CMODEL6988 a_16000_n24000.t0 vdd.n33 0.00343688581516997f
CMODEL6989 a_16000_n24000.t0 vdd.t17 0.000327635856079662f
CMODEL6990 a_16000_n24000.t0 vdd.t16 0.00258979168676395f
CMODEL6991 a_16000_n24000.t0 vdd.n34 0.000584686536932907f
CMODEL6992 a_16000_n24000.t0 vdd.n35 0.000186527927890633f
CMODEL6993 a_16000_n24000.t0 vdd.t1 8.5881630929183e-05f
CMODEL6994 a_16000_n24000.t0 vdd.t31 8.5881630929183e-05f
CMODEL6995 a_16000_n24000.t0 vdd.t0 0.00173541095948678f
CMODEL6996 a_16000_n24000.t0 vdd.t30 0.00173541095948678f
CMODEL6997 a_16000_n24000.t0 vdd.n36 0.00056205846630335f
CMODEL6998 a_16000_n24000.t0 vdd.n37 0.00657804615556055f
CMODEL6999 a_16000_n24000.t0 vdd.n38 0.00379452337179123f
CMODEL7000 a_16000_n24000.t0 vdd.t19 0.000327635856079662f
CMODEL7001 a_16000_n24000.t0 vdd.t18 0.00258979168676395f
CMODEL7002 a_16000_n24000.t0 vdd.n39 0.00320205205830487f
CMODEL7003 a_16000_n24000.t0 vdd.t21 0.000327638857150038f
CMODEL7004 a_16000_n24000.t0 vdd.t20 0.00258979168676395f
CMODEL7005 a_16000_n24000.t0 vdd.n40 0.00320205205830487f
CMODEL7006 a_16000_n24000.t0 vdd.t11 0.000327635856079662f
CMODEL7007 a_16000_n24000.t0 vdd.t10 0.00258979168676395f
CMODEL7008 a_16000_n24000.t0 vdd.n41 0.0137758133436149f
CMODEL7009 a_16000_n24000.t0 vdd.n42 0.0263875414993653f
CMODEL7010 a_16000_n24000.t0 vdd.n43 0.00320205205830487f
CMODEL7011 a_16000_n24000.t0 vdd.t13 0.000327635856079662f
CMODEL7012 a_16000_n24000.t0 vdd.t12 0.00258979168676395f
CMODEL7013 a_16000_n24000.t0 vdd.n44 0.00320205205830487f
CMODEL7014 a_16000_n24000.t0 vdd.t23 0.000327635856079662f
CMODEL7015 a_16000_n24000.t0 vdd.t22 0.00258979168676395f
CMODEL7016 a_16000_n24000.t0 vdd.n45 0.00395279982338312f
CMODEL7017 a_16000_n24000.t0 vdd.n46 0.0652450706006568f
CMODEL7018 a_16000_n24000.t1 vdd 0.000127775126722096f
CMODEL7019 a_16000_n24000.t1 vdd.n0 0.0428789548278253f
CMODEL7020 a_16000_n24000.t1 vdd.n1 0.00397362524208988f
CMODEL7021 a_16000_n24000.t1 vdd.t7 0.000327571367072164f
CMODEL7022 a_16000_n24000.t1 vdd.t6 0.00258928193457289f
CMODEL7023 a_16000_n24000.t1 vdd.n2 0.00356330964714316f
CMODEL7024 a_16000_n24000.t1 vdd.t27 0.000327571367072164f
CMODEL7025 a_16000_n24000.t1 vdd.t26 0.00258928193457289f
CMODEL7026 a_16000_n24000.t1 vdd.n3 0.00668344844694716f
CMODEL7027 a_16000_n24000.t1 vdd.n4 0.00356330964714316f
CMODEL7028 a_16000_n24000.t1 vdd.t36 0.000327571367072164f
CMODEL7029 a_16000_n24000.t1 vdd.t35 0.00258928193457289f
CMODEL7030 a_16000_n24000.t1 vdd.n5 0.00508428279693799f
CMODEL7031 a_16000_n24000.t1 vdd.t3 0.000521801417585408f
CMODEL7032 a_16000_n24000.t1 vdd.n6 0.00499234809983256f
CMODEL7033 a_16000_n24000.t1 vdd.t2 0.00654281596478882f
CMODEL7034 a_16000_n24000.t1 vdd.n7 0.00669244988595879f
CMODEL7035 a_16000_n24000.t1 vdd.t25 0.000521801417585408f
CMODEL7036 a_16000_n24000.t1 vdd.n8 0.00301542205930205f
CMODEL7037 a_16000_n24000.t1 vdd.t24 0.00654281596478882f
CMODEL7038 a_16000_n24000.t1 vdd.n9 0.00669244988595879f
CMODEL7039 a_16000_n24000.t1 vdd.t5 0.000521801417585408f
CMODEL7040 a_16000_n24000.t1 vdd.n10 0.00892894742278794f
CMODEL7041 a_16000_n24000.t1 vdd.t4 0.00654641654039347f
CMODEL7042 a_16000_n24000.t1 vdd.n11 0.0215886912679287f
CMODEL7043 a_16000_n24000.t1 vdd.n12 0.0532297095472966f
CMODEL7044 a_16000_n24000.t1 vdd.n13 0.00403474501297884f
CMODEL7045 a_16000_n24000.t1 vdd.t42 0.000327571367072164f
CMODEL7046 a_16000_n24000.t1 vdd.t41 0.00258928193457289f
CMODEL7047 a_16000_n24000.t1 vdd.n14 0.00362754991688948f
CMODEL7048 a_16000_n24000.t1 vdd.t9 0.000327571367072164f
CMODEL7049 a_16000_n24000.t1 vdd.t8 0.00258928193457289f
CMODEL7050 a_16000_n24000.t1 vdd.n15 0.00696441336329678f
CMODEL7051 a_16000_n24000.t1 vdd.t15 0.000551662191266649f
CMODEL7052 a_16000_n24000.t1 vdd.n16 0.00433926369474222f
CMODEL7053 a_16000_n24000.t1 vdd.t14 0.00744157964530319f
CMODEL7054 a_16000_n24000.t1 vdd.n17 0.00607837171658551f
CMODEL7055 a_16000_n24000.t1 vdd.t32 0.00744157964530319f
CMODEL7056 a_16000_n24000.t1 vdd.n18 0.00600017921637116f
CMODEL7057 a_16000_n24000.t1 vdd.t34 0.000551662191266649f
CMODEL7058 a_16000_n24000.t1 vdd.n19 0.00604224594135217f
CMODEL7059 a_16000_n24000.t1 vdd.t33 0.00744157964530319f
CMODEL7060 a_16000_n24000.t1 vdd.n20 0.0120581776759937f
CMODEL7061 a_16000_n24000.t1 vdd.t48 0.00745580191894157f
CMODEL7062 a_16000_n24000.t1 vdd.n21 0.0214045818353442f
CMODEL7063 a_16000_n24000.t1 vdd.n22 0.0938027957483098f
CMODEL7064 a_16000_n24000.t1 vdd.t47 0.000106051053811432f
CMODEL7065 a_16000_n24000.t1 vdd.t45 0.000104962179738992f
CMODEL7066 a_16000_n24000.t1 vdd.n23 0.00119854760535764f
CMODEL7067 a_16000_n24000.t1 vdd.t46 0.00286039927664379f
CMODEL7068 a_16000_n24000.t1 vdd.n24 0.00307324130255341f
CMODEL7069 a_16000_n24000.t1 vdd.t44 0.00286039927664379f
CMODEL7070 a_16000_n24000.t1 vdd.n25 0.00484679483101453f
CMODEL7071 a_16000_n24000.t1 vdd.t43 0.00286659526716346f
CMODEL7072 a_16000_n24000.t1 vdd.n26 0.0259330857829076f
CMODEL7073 a_16000_n24000.t1 vdd.n27 0.0173368015411927f
CMODEL7074 a_16000_n24000.t1 vdd.n28 0.00391607604200887f
CMODEL7075 a_16000_n24000.t1 vdd.t29 0.000327571367072164f
CMODEL7076 a_16000_n24000.t1 vdd.t28 0.00258928193457289f
CMODEL7077 a_16000_n24000.t1 vdd.n29 0.000584571452293162f
CMODEL7078 a_16000_n24000.t1 vdd.n30 0.00018649121334698f
CMODEL7079 a_16000_n24000.t1 vdd.t38 8.58647267319219e-05f
CMODEL7080 a_16000_n24000.t1 vdd.t40 8.58647267319219e-05f
CMODEL7081 a_16000_n24000.t1 vdd.t37 0.00173506937620673f
CMODEL7082 a_16000_n24000.t1 vdd.t39 0.00173506937620673f
CMODEL7083 a_16000_n24000.t1 vdd.n31 0.00056194783557727f
CMODEL7084 a_16000_n24000.t1 vdd.n32 0.0067815341273772f
CMODEL7085 a_16000_n24000.t1 vdd.n33 0.00343620932829897f
CMODEL7086 a_16000_n24000.t1 vdd.t17 0.000327571367072164f
CMODEL7087 a_16000_n24000.t1 vdd.t16 0.00258928193457289f
CMODEL7088 a_16000_n24000.t1 vdd.n34 0.000584571452293162f
CMODEL7089 a_16000_n24000.t1 vdd.n35 0.00018649121334698f
CMODEL7090 a_16000_n24000.t1 vdd.t1 8.58647267319219e-05f
CMODEL7091 a_16000_n24000.t1 vdd.t31 8.58647267319219e-05f
CMODEL7092 a_16000_n24000.t1 vdd.t0 0.00173506937620673f
CMODEL7093 a_16000_n24000.t1 vdd.t30 0.00173506937620673f
CMODEL7094 a_16000_n24000.t1 vdd.n36 0.00056194783557727f
CMODEL7095 a_16000_n24000.t1 vdd.n37 0.00657675138986266f
CMODEL7096 a_16000_n24000.t1 vdd.n38 0.00379377649063755f
CMODEL7097 a_16000_n24000.t1 vdd.t19 0.000327571367072164f
CMODEL7098 a_16000_n24000.t1 vdd.t18 0.00258928193457289f
CMODEL7099 a_16000_n24000.t1 vdd.n39 0.003201421794079f
CMODEL7100 a_16000_n24000.t1 vdd.t21 0.000327574367551834f
CMODEL7101 a_16000_n24000.t1 vdd.t20 0.00258928193457289f
CMODEL7102 a_16000_n24000.t1 vdd.n40 0.003201421794079f
CMODEL7103 a_16000_n24000.t1 vdd.t11 0.000327571367072164f
CMODEL7104 a_16000_n24000.t1 vdd.t10 0.00258928193457289f
CMODEL7105 a_16000_n24000.t1 vdd.n41 0.0137731018316924f
CMODEL7106 a_16000_n24000.t1 vdd.n42 0.026382347603978f
CMODEL7107 a_16000_n24000.t1 vdd.n43 0.003201421794079f
CMODEL7108 a_16000_n24000.t1 vdd.t13 0.000327571367072164f
CMODEL7109 a_16000_n24000.t1 vdd.t12 0.00258928193457289f
CMODEL7110 a_16000_n24000.t1 vdd.n44 0.003201421794079f
CMODEL7111 a_16000_n24000.t1 vdd.t23 0.000327571367072164f
CMODEL7112 a_16000_n24000.t1 vdd.t22 0.00258928193457289f
CMODEL7113 a_16000_n24000.t1 vdd.n45 0.00395202178846197f
CMODEL7114 a_16000_n24000.t1 vdd.n46 0.0652322283254017f
CMODEL7115 dout vdd 2.32563169281321e-05f
CMODEL7116 dout vdd.n0 0.00780438719651468f
CMODEL7117 dout vdd.n1 0.000723238476488926f
CMODEL7118 dout vdd.t7 5.96211776473579e-05f
CMODEL7119 dout vdd.t6 0.000471274518222027f
CMODEL7120 dout vdd.n2 0.000648557043870273f
CMODEL7121 dout vdd.t27 5.96211776473579e-05f
CMODEL7122 dout vdd.t26 0.000471274518222027f
CMODEL7123 dout vdd.n3 0.00121645267934731f
CMODEL7124 dout vdd.n4 0.000648557043870273f
CMODEL7125 dout vdd.t36 5.96211776473579e-05f
CMODEL7126 dout vdd.t35 0.000471274518222027f
CMODEL7127 dout vdd.n5 0.000925388963495292f
CMODEL7128 dout vdd.t3 9.49729376305627e-05f
CMODEL7129 dout vdd.n6 0.000908655953656641f
CMODEL7130 dout vdd.t2 0.00119085619856606f
CMODEL7131 dout vdd.n7 0.00121809102887459f
CMODEL7132 dout vdd.t25 9.49729376305627e-05f
CMODEL7133 dout vdd.n8 0.000548836169309644f
CMODEL7134 dout vdd.t24 0.00119085619856606f
CMODEL7135 dout vdd.n9 0.00121809102887459f
CMODEL7136 dout vdd.t5 9.49729376305627e-05f
CMODEL7137 dout vdd.n10 0.00162515535242334f
CMODEL7138 dout vdd.t4 0.00119151153837697f
CMODEL7139 dout vdd.n11 0.0039293519722546f
CMODEL7140 dout vdd.n12 0.00968832531793748f
CMODEL7141 dout vdd.n13 0.000734362869779178f
CMODEL7142 dout vdd.t42 5.96211776473579e-05f
CMODEL7143 dout vdd.t41 0.000471274518222027f
CMODEL7144 dout vdd.n14 0.000660249398329983f
CMODEL7145 dout vdd.t9 5.96211776473579e-05f
CMODEL7146 dout vdd.t8 0.000471274518222027f
CMODEL7147 dout vdd.n15 0.0012675910292589f
CMODEL7148 dout vdd.t15 0.00010040788912907f
CMODEL7149 dout vdd.n16 0.000789788234287164f
CMODEL7150 dout vdd.t14 0.00135443993770018f
CMODEL7151 dout vdd.n17 0.00110632282412334f
CMODEL7152 dout vdd.t32 0.00135443993770018f
CMODEL7153 dout vdd.n18 0.00109209102789634f
CMODEL7154 dout vdd.t34 0.00010040788912907f
CMODEL7155 dout vdd.n19 0.00109974758135385f
CMODEL7156 dout vdd.t33 0.00135443993770018f
CMODEL7157 dout vdd.n20 0.00219470572092293f
CMODEL7158 dout vdd.t48 0.00135702852995329f
CMODEL7159 dout vdd.n21 0.00389584226325657f
CMODEL7160 dout vdd.n22 0.0170730219772131f
CMODEL7161 dout vdd.t47 1.93023241789872e-05f
CMODEL7162 dout vdd.t45 1.91041384978369e-05f
CMODEL7163 dout vdd.n23 0.000218147331790758f
CMODEL7164 dout vdd.t46 0.000520620513750775f
CMODEL7165 dout vdd.n24 0.000559359834439892f
CMODEL7166 dout vdd.t44 0.000520620513750775f
CMODEL7167 dout vdd.n25 0.000882163841800473f
CMODEL7168 dout vdd.t43 0.000521748244342055f
CMODEL7169 dout vdd.n26 0.00472007406577232f
CMODEL7170 dout vdd.n27 0.00315546665071227f
CMODEL7171 dout vdd.n28 0.000712763961844496f
CMODEL7172 dout vdd.t29 5.96211776473579e-05f
CMODEL7173 dout vdd.t28 0.000471274518222027f
CMODEL7174 dout vdd.n29 0.000106397695000817f
CMODEL7175 dout vdd.n30 3.39432162829486e-05f
CMODEL7176 dout vdd.t38 1.56282161407531e-05f
CMODEL7177 dout vdd.t40 1.56282161407531e-05f
CMODEL7178 dout vdd.t37 0.000315799517014937f
CMODEL7179 dout vdd.t39 0.000315799517014937f
CMODEL7180 dout vdd.n31 0.000102279976522245f
CMODEL7181 dout vdd.n32 0.0012343052280296f
CMODEL7182 dout vdd.n33 0.000625423548545036f
CMODEL7183 dout vdd.t17 5.96211776473579e-05f
CMODEL7184 dout vdd.t16 0.000471274518222027f
CMODEL7185 dout vdd.n34 0.000106397695000817f
CMODEL7186 dout vdd.n35 3.39432162829486e-05f
CMODEL7187 dout vdd.t1 1.56282161407531e-05f
CMODEL7188 dout vdd.t31 1.56282161407531e-05f
CMODEL7189 dout vdd.t0 0.000315799517014937f
CMODEL7190 dout vdd.t30 0.000315799517014937f
CMODEL7191 dout vdd.n36 0.000102279976522245f
CMODEL7192 dout vdd.n37 0.00119703277628391f
CMODEL7193 dout vdd.n38 0.00069050425293381f
CMODEL7194 dout vdd.t19 5.96211776473579e-05f
CMODEL7195 dout vdd.t18 0.000471274518222027f
CMODEL7196 dout vdd.n39 0.000582689931708403f
CMODEL7197 dout vdd.t21 5.9621723763867e-05f
CMODEL7198 dout vdd.t20 0.000471274518222027f
CMODEL7199 dout vdd.n40 0.000582689931708403f
CMODEL7200 dout vdd.t11 5.96211776473579e-05f
CMODEL7201 dout vdd.t10 0.000471274518222027f
CMODEL7202 dout vdd.n41 0.00250683861169581f
CMODEL7203 dout vdd.n42 0.00480184409067902f
CMODEL7204 dout vdd.n43 0.000582689931708403f
CMODEL7205 dout vdd.t13 5.96211776473579e-05f
CMODEL7206 dout vdd.t12 0.000471274518222027f
CMODEL7207 dout vdd.n44 0.000582689931708403f
CMODEL7208 dout vdd.t23 5.96211776473579e-05f
CMODEL7209 dout vdd.t22 0.000471274518222027f
CMODEL7210 dout vdd.n45 0.000719306437623446f
CMODEL7211 dout vdd.n46 0.0118729005776167f
CMODEL7212 dout.n0 vdd 9.9717000363166e-06f
CMODEL7213 dout.n0 vdd.n0 0.00334631697406803f
CMODEL7214 dout.n0 vdd.n1 0.000310105730178894f
CMODEL7215 dout.n0 vdd.t7 2.55640005744945e-05f
CMODEL7216 dout.n0 vdd.t6 0.00020207017925461f
CMODEL7217 dout.n0 vdd.n2 0.000278084286428496f
CMODEL7218 dout.n0 vdd.t27 2.55640005744945e-05f
CMODEL7219 dout.n0 vdd.t26 0.00020207017925461f
CMODEL7220 dout.n0 vdd.n3 0.000521583072001902f
CMODEL7221 dout.n0 vdd.n4 0.000278084286428496f
CMODEL7222 dout.n0 vdd.t36 2.55640005744945e-05f
CMODEL7223 dout.n0 vdd.t35 0.00020207017925461f
CMODEL7224 dout.n0 vdd.n5 0.000396782568340847f
CMODEL7225 dout.n0 vdd.t3 4.07219100318581e-05f
CMODEL7226 dout.n0 vdd.n6 0.000389607891657028f
CMODEL7227 dout.n0 vdd.t2 0.000510607970951948f
CMODEL7228 dout.n0 vdd.n7 0.000522285553400448f
CMODEL7229 dout.n0 vdd.t25 4.07219100318581e-05f
CMODEL7230 dout.n0 vdd.n8 0.000235326585303651f
CMODEL7231 dout.n0 vdd.t24 0.000510607970951948f
CMODEL7232 dout.n0 vdd.n9 0.000522285553400448f
CMODEL7233 dout.n0 vdd.t5 4.07219100318581e-05f
CMODEL7234 dout.n0 vdd.n10 0.000696824081683235f
CMODEL7235 dout.n0 vdd.t4 0.000510888963511367f
CMODEL7236 dout.n0 vdd.n11 0.00168480328701725f
CMODEL7237 dout.n0 vdd.n12 0.0041541003342563f
CMODEL7238 dout.n0 vdd.n13 0.000314875578875022f
CMODEL7239 dout.n0 vdd.t42 2.55640005744945e-05f
CMODEL7240 dout.n0 vdd.t41 0.00020207017925461f
CMODEL7241 dout.n0 vdd.n14 0.000283097662009454f
CMODEL7242 dout.n0 vdd.t9 2.55640005744945e-05f
CMODEL7243 dout.n0 vdd.t8 0.00020207017925461f
CMODEL7244 dout.n0 vdd.n15 0.00054350985805519f
CMODEL7245 dout.n0 vdd.t15 4.3052274991302e-05f
CMODEL7246 dout.n0 vdd.n16 0.00033864052458784f
CMODEL7247 dout.n0 vdd.t14 0.000580748396992124f
CMODEL7248 dout.n0 vdd.n17 0.000474362272391626f
CMODEL7249 dout.n0 vdd.t32 0.000580748396992124f
CMODEL7250 dout.n0 vdd.n18 0.000468260050642922f
CMODEL7251 dout.n0 vdd.t34 4.3052274991302e-05f
CMODEL7252 dout.n0 vdd.n19 0.000471542980378794f
CMODEL7253 dout.n0 vdd.t33 0.000580748396992124f
CMODEL7254 dout.n0 vdd.n20 0.000941032373469172f
CMODEL7255 dout.n0 vdd.t48 0.000581858317601827f
CMODEL7256 dout.n0 vdd.n21 0.00167043520081232f
CMODEL7257 dout.n0 vdd.n22 0.00732046499006341f
CMODEL7258 dout.n0 vdd.t47 8.27633142906522e-06f
CMODEL7259 dout.n0 vdd.t45 8.19135459588775e-06f
CMODEL7260 dout.n0 vdd.n23 9.35358665373581e-05f
CMODEL7261 dout.n0 vdd.t46 0.000223228450657889f
CMODEL7262 dout.n0 vdd.n24 0.00023983885748698f
CMODEL7263 dout.n0 vdd.t44 0.000223228450657889f
CMODEL7264 dout.n0 vdd.n25 0.000378248767442536f
CMODEL7265 dout.n0 vdd.t43 0.000223711992020555f
CMODEL7266 dout.n0 vdd.n26 0.00202384422600226f
CMODEL7267 dout.n0 vdd.n27 0.00135298151520463f
CMODEL7268 dout.n0 vdd.n28 0.000305614532437522f
CMODEL7269 dout.n0 vdd.t29 2.55640005744945e-05f
CMODEL7270 dout.n0 vdd.t28 0.00020207017925461f
CMODEL7271 dout.n0 vdd.n29 4.56205469843869e-05f
CMODEL7272 dout.n0 vdd.n30 1.45539627829868e-05f
CMODEL7273 dout.n0 vdd.t38 6.70097006073214e-06f
CMODEL7274 dout.n0 vdd.t40 6.70097006073214e-06f
CMODEL7275 dout.n0 vdd.t37 0.000135406567816305f
CMODEL7276 dout.n0 vdd.t39 0.000135406567816305f
CMODEL7277 dout.n0 vdd.n31 4.38549770693741e-05f
CMODEL7278 dout.n0 vdd.n32 0.000529237777641393f
CMODEL7279 dout.n0 vdd.n33 0.000268165249081024f
CMODEL7280 dout.n0 vdd.t17 2.55640005744945e-05f
CMODEL7281 dout.n0 vdd.t16 0.00020207017925461f
CMODEL7282 dout.n0 vdd.n34 4.56205469843869e-05f
CMODEL7283 dout.n0 vdd.n35 1.45539627829868e-05f
CMODEL7284 dout.n0 vdd.t1 6.70097006073214e-06f
CMODEL7285 dout.n0 vdd.t31 6.70097006073214e-06f
CMODEL7286 dout.n0 vdd.t0 0.000135406567816305f
CMODEL7287 dout.n0 vdd.t30 0.000135406567816305f
CMODEL7288 dout.n0 vdd.n36 4.38549770693741e-05f
CMODEL7289 dout.n0 vdd.n37 0.000513256325824467f
CMODEL7290 dout.n0 vdd.n38 0.000296070151835941f
CMODEL7291 dout.n0 vdd.t19 2.55640005744945e-05f
CMODEL7292 dout.n0 vdd.t18 0.00020207017925461f
CMODEL7293 dout.n0 vdd.n39 0.000249842192602277f
CMODEL7294 dout.n0 vdd.t21 2.55642347349607e-05f
CMODEL7295 dout.n0 vdd.t20 0.00020207017925461f
CMODEL7296 dout.n0 vdd.n40 0.000249842192602277f
CMODEL7297 dout.n0 vdd.t11 2.55640005744945e-05f
CMODEL7298 dout.n0 vdd.t10 0.00020207017925461f
CMODEL7299 dout.n0 vdd.n41 0.00107486678791553f
CMODEL7300 dout.n0 vdd.n42 0.0020589050726037f
CMODEL7301 dout.n0 vdd.n43 0.000249842192602277f
CMODEL7302 dout.n0 vdd.t13 2.55640005744945e-05f
CMODEL7303 dout.n0 vdd.t12 0.00020207017925461f
CMODEL7304 dout.n0 vdd.n44 0.000249842192602277f
CMODEL7305 dout.n0 vdd.t23 2.55640005744945e-05f
CMODEL7306 dout.n0 vdd.t22 0.00020207017925461f
CMODEL7307 dout.n0 vdd.n45 0.000308419774822383f
CMODEL7308 dout.n0 vdd.n46 0.00509078903107779f
CMODEL7309 dout.t0 vdd 1.67160728502106e-06f
CMODEL7310 dout.t0 vdd.n0 0.00056096029879254f
CMODEL7311 dout.t0 vdd.n1 5.19846160439953e-05f
CMODEL7312 dout.t0 vdd.t7 4.28542469578663e-06f
CMODEL7313 dout.t0 vdd.t6 3.38740618447532e-05f
CMODEL7314 dout.t0 vdd.n2 4.66166969875545e-05f
CMODEL7315 dout.t0 vdd.t27 4.28542469578663e-06f
CMODEL7316 dout.t0 vdd.t26 3.38740618447532e-05f
CMODEL7317 dout.t0 vdd.n3 8.74356488589384e-05f
CMODEL7318 dout.t0 vdd.n4 4.66166969875545e-05f
CMODEL7319 dout.t0 vdd.t36 4.28542469578663e-06f
CMODEL7320 dout.t0 vdd.t35 3.38740618447532e-05f
CMODEL7321 dout.t0 vdd.n5 6.65146995389289e-05f
CMODEL7322 dout.t0 vdd.t3 6.82642289893535e-06f
CMODEL7323 dout.t0 vdd.n6 6.53119716421146e-05f
CMODEL7324 dout.t0 vdd.t2 8.55958363092098e-05f
CMODEL7325 dout.t0 vdd.n7 8.75534094232479e-05f
CMODEL7326 dout.t0 vdd.t25 6.82642289893535e-06f
CMODEL7327 dout.t0 vdd.n8 3.94490039732502e-05f
CMODEL7328 dout.t0 vdd.t24 8.55958363092098e-05f
CMODEL7329 dout.t0 vdd.n9 8.75534094232479e-05f
CMODEL7330 dout.t0 vdd.t5 6.82642289893535e-06f
CMODEL7331 dout.t0 vdd.n10 0.000116812199231584f
CMODEL7332 dout.t0 vdd.t4 8.56429405349336e-05f
CMODEL7333 dout.t0 vdd.n11 0.000282432227017307f
CMODEL7334 dout.t0 vdd.n12 0.000696373171692022f
CMODEL7335 dout.t0 vdd.n13 5.27842102756568e-05f
CMODEL7336 dout.t0 vdd.t42 4.28542469578663e-06f
CMODEL7337 dout.t0 vdd.t41 3.38740618447532e-05f
CMODEL7338 dout.t0 vdd.n14 4.74571148815098e-05f
CMODEL7339 dout.t0 vdd.t9 4.28542469578663e-06f
CMODEL7340 dout.t0 vdd.t8 3.38740618447532e-05f
CMODEL7341 dout.t0 vdd.n15 9.11113486062519e-05f
CMODEL7342 dout.t0 vdd.t15 7.21707394427137e-06f
CMODEL7343 dout.t0 vdd.n16 5.67680501662468e-05f
CMODEL7344 dout.t0 vdd.t14 9.73538361202979e-05f
CMODEL7345 dout.t0 vdd.n17 7.95197837260545e-05f
CMODEL7346 dout.t0 vdd.t32 9.73538361202979e-05f
CMODEL7347 dout.t0 vdd.n18 7.84968369574194e-05f
CMODEL7348 dout.t0 vdd.t34 7.21707394427137e-06f
CMODEL7349 dout.t0 vdd.n19 7.90471713279591e-05f
CMODEL7350 dout.t0 vdd.t33 9.73538361202979e-05f
CMODEL7351 dout.t0 vdd.n20 0.00015775008927292f
CMODEL7352 dout.t0 vdd.t48 9.75398978119069e-05f
CMODEL7353 dout.t0 vdd.n21 0.000280023630941963f
CMODEL7354 dout.t0 vdd.n22 0.00122716713926061f
CMODEL7355 dout.t0 vdd.t47 1.38740393911654e-06f
CMODEL7356 dout.t0 vdd.t45 1.37315883618723e-06f
CMODEL7357 dout.t0 vdd.n23 1.56798976448514e-05f
CMODEL7358 dout.t0 vdd.t46 3.74209315347122e-05f
CMODEL7359 dout.t0 vdd.n24 4.02054193313315e-05f
CMODEL7360 dout.t0 vdd.t44 3.74209315347122e-05f
CMODEL7361 dout.t0 vdd.n25 6.34077833172302e-05f
CMODEL7362 dout.t0 vdd.t43 3.75019900564785e-05f
CMODEL7363 dout.t0 vdd.n26 0.00033926740070521f
CMODEL7364 dout.t0 vdd.n27 0.000226807239395291f
CMODEL7365 dout.t0 vdd.n28 5.12317335028433e-05f
CMODEL7366 dout.t0 vdd.t29 4.28542469578663e-06f
CMODEL7367 dout.t0 vdd.t28 3.38740618447532e-05f
CMODEL7368 dout.t0 vdd.n29 7.64760656738686e-06f
CMODEL7369 dout.t0 vdd.n30 2.43975552065971e-06f
CMODEL7370 dout.t0 vdd.t38 1.12331802294822e-06f
CMODEL7371 dout.t0 vdd.t40 1.12331802294822e-06f
CMODEL7372 dout.t0 vdd.t37 2.26988983199542e-05f
CMODEL7373 dout.t0 vdd.t39 2.26988983199542e-05f
CMODEL7374 dout.t0 vdd.n31 7.35163501575567e-06f
CMODEL7375 dout.t0 vdd.n32 8.87188464746975e-05f
CMODEL7376 dout.t0 vdd.n33 4.49539178195045e-05f
CMODEL7377 dout.t0 vdd.t17 4.28542469578663e-06f
CMODEL7378 dout.t0 vdd.t16 3.38740618447532e-05f
CMODEL7379 dout.t0 vdd.n34 7.64760656738686e-06f
CMODEL7380 dout.t0 vdd.n35 2.43975552065971e-06f
CMODEL7381 dout.t0 vdd.t1 1.12331802294822e-06f
CMODEL7382 dout.t0 vdd.t31 1.12331802294822e-06f
CMODEL7383 dout.t0 vdd.t0 2.26988983199542e-05f
CMODEL7384 dout.t0 vdd.t30 2.26988983199542e-05f
CMODEL7385 dout.t0 vdd.n36 7.35163501575567e-06f
CMODEL7386 dout.t0 vdd.n37 8.60397936366566e-05f
CMODEL7387 dout.t0 vdd.n38 4.96317599690918e-05f
CMODEL7388 dout.t0 vdd.t19 4.28542469578663e-06f
CMODEL7389 dout.t0 vdd.t18 3.38740618447532e-05f
CMODEL7390 dout.t0 vdd.n39 4.18823297670986e-05f
CMODEL7391 dout.t0 vdd.t21 4.28546394930806e-06f
CMODEL7392 dout.t0 vdd.t20 3.38740618447532e-05f
CMODEL7393 dout.t0 vdd.n40 4.18823297670986e-05f
CMODEL7394 dout.t0 vdd.t11 4.28542469578663e-06f
CMODEL7395 dout.t0 vdd.t10 3.38740618447532e-05f
CMODEL7396 dout.t0 vdd.n41 0.00018018543944995f
CMODEL7397 dout.t0 vdd.n42 0.000345144830469897f
CMODEL7398 dout.t0 vdd.n43 4.18823297670986e-05f
CMODEL7399 dout.t0 vdd.t13 4.28542469578663e-06f
CMODEL7400 dout.t0 vdd.t12 3.38740618447532e-05f
CMODEL7401 dout.t0 vdd.n44 4.18823297670986e-05f
CMODEL7402 dout.t0 vdd.t23 4.28542469578663e-06f
CMODEL7403 dout.t0 vdd.t22 3.38740618447532e-05f
CMODEL7404 dout.t0 vdd.n45 5.17019906896526e-05f
CMODEL7405 dout.t0 vdd.n46 0.000853395108142295f
CMODEL7406 dout.t1 vdd 7.36312041345873e-06f
CMODEL7407 dout.t1 vdd.n0 0.00247092619432274f
CMODEL7408 dout.t1 vdd.n1 0.000228982603156419f
CMODEL7409 dout.t1 vdd.t7 1.88765018797398e-05f
CMODEL7410 dout.t1 vdd.t6 0.00014920896701687f
CMODEL7411 dout.t1 vdd.n2 0.000205337914157725f
CMODEL7412 dout.t1 vdd.t27 1.88765018797398e-05f
CMODEL7413 dout.t1 vdd.t26 0.00014920896701687f
CMODEL7414 dout.t1 vdd.n3 0.000385137835151962f
CMODEL7415 dout.t1 vdd.n4 0.000205337914157725f
CMODEL7416 dout.t1 vdd.t36 1.88765018797398e-05f
CMODEL7417 dout.t1 vdd.t35 0.00014920896701687f
CMODEL7418 dout.t1 vdd.n5 0.000292984929150983f
CMODEL7419 dout.t1 vdd.t3 3.00691282267413e-05f
CMODEL7420 dout.t1 vdd.n6 0.000287687135579356f
CMODEL7421 dout.t1 vdd.t2 0.00037703380170868f
CMODEL7422 dout.t1 vdd.n7 0.000385656548621769f
CMODEL7423 dout.t1 vdd.t25 3.00691282267413e-05f
CMODEL7424 dout.t1 vdd.n8 0.000173765554295484f
CMODEL7425 dout.t1 vdd.t24 0.00037703380170868f
CMODEL7426 dout.t1 vdd.n9 0.000385656548621769f
CMODEL7427 dout.t1 vdd.t5 3.00691282267413e-05f
CMODEL7428 dout.t1 vdd.n10 0.00051453609732997f
CMODEL7429 dout.t1 vdd.t4 0.000377241287096603f
CMODEL7430 dout.t1 vdd.n11 0.00124406163744587f
CMODEL7431 dout.t1 vdd.n12 0.0030673948132536f
CMODEL7432 dout.t1 vdd.n13 0.000232504667616408f
CMODEL7433 dout.t1 vdd.t42 1.88765018797398e-05f
CMODEL7434 dout.t1 vdd.t41 0.00014920896701687f
CMODEL7435 dout.t1 vdd.n14 0.000209039799287247f
CMODEL7436 dout.t1 vdd.t9 1.88765018797398e-05f
CMODEL7437 dout.t1 vdd.t8 0.00014920896701687f
CMODEL7438 dout.t1 vdd.n15 0.000401328611589532f
CMODEL7439 dout.t1 vdd.t15 3.17898737105804e-05f
CMODEL7440 dout.t1 vdd.n16 0.000250052744299972f
CMODEL7441 dout.t1 vdd.t14 0.000428825612623991f
CMODEL7442 dout.t1 vdd.n17 0.000350269915711548f
CMODEL7443 dout.t1 vdd.t32 0.000428825612623991f
CMODEL7444 dout.t1 vdd.n18 0.000345764024703826f
CMODEL7445 dout.t1 vdd.t34 3.17898737105804e-05f
CMODEL7446 dout.t1 vdd.n19 0.000348188145652723f
CMODEL7447 dout.t1 vdd.t33 0.000428825612623991f
CMODEL7448 dout.t1 vdd.n20 0.000694859918928711f
CMODEL7449 dout.t1 vdd.t48 0.000429645179906286f
CMODEL7450 dout.t1 vdd.n21 0.00123345221794342f
CMODEL7451 dout.t1 vdd.n22 0.00540544390706083f
CMODEL7452 dout.t1 vdd.t47 6.11125732542696e-06f
CMODEL7453 dout.t1 vdd.t45 6.04851028602933e-06f
CMODEL7454 dout.t1 vdd.n23 6.90670443137571e-05f
CMODEL7455 dout.t1 vdd.t46 0.000164832270918471f
CMODEL7456 dout.t1 vdd.n24 0.000177097423816543f
CMODEL7457 dout.t1 vdd.t44 0.000164832270918471f
CMODEL7458 dout.t1 vdd.n25 0.00027929953877258f
CMODEL7459 dout.t1 vdd.t43 0.000165189318690188f
CMODEL7460 dout.t1 vdd.n26 0.00149441004842363f
CMODEL7461 dout.t1 vdd.n27 0.000999043871892823f
CMODEL7462 dout.t1 vdd.n28 0.000225666295039454f
CMODEL7463 dout.t1 vdd.t29 1.88765018797398e-05f
CMODEL7464 dout.t1 vdd.t28 0.00014920896701687f
CMODEL7465 dout.t1 vdd.n29 3.36862901561941e-05f
CMODEL7466 dout.t1 vdd.n30 1.07466710865596e-05f
CMODEL7467 dout.t1 vdd.t38 4.9480077884872e-06f
CMODEL7468 dout.t1 vdd.t40 4.9480077884872e-06f
CMODEL7469 dout.t1 vdd.t37 9.99844419681225e-05f
CMODEL7470 dout.t1 vdd.t39 9.99844419681225e-05f
CMODEL7471 dout.t1 vdd.n31 3.23825903020796e-05f
CMODEL7472 dout.t1 vdd.n32 0.000390790082927957f
CMODEL7473 dout.t1 vdd.n33 0.000198013679964053f
CMODEL7474 dout.t1 vdd.t17 1.88765018797398e-05f
CMODEL7475 dout.t1 vdd.t16 0.00014920896701687f
CMODEL7476 dout.t1 vdd.n34 3.36862901561941e-05f
CMODEL7477 dout.t1 vdd.n35 1.07466710865596e-05f
CMODEL7478 dout.t1 vdd.t1 4.9480077884872e-06f
CMODEL7479 dout.t1 vdd.t31 4.9480077884872e-06f
CMODEL7480 dout.t1 vdd.t0 9.99844419681225e-05f
CMODEL7481 dout.t1 vdd.t30 9.99844419681225e-05f
CMODEL7482 dout.t1 vdd.n36 3.23825903020796e-05f
CMODEL7483 dout.t1 vdd.n37 0.000378989351489852f
CMODEL7484 dout.t1 vdd.n38 0.000218618708029679f
CMODEL7485 dout.t1 vdd.t19 1.88765018797398e-05f
CMODEL7486 dout.t1 vdd.t18 0.00014920896701687f
CMODEL7487 dout.t1 vdd.n39 0.000184483903626592f
CMODEL7488 dout.t1 vdd.t21 1.88766747842297e-05f
CMODEL7489 dout.t1 vdd.t20 0.00014920896701687f
CMODEL7490 dout.t1 vdd.n40 0.000184483903626592f
CMODEL7491 dout.t1 vdd.t11 1.88765018797398e-05f
CMODEL7492 dout.t1 vdd.t10 0.00014920896701687f
CMODEL7493 dout.t1 vdd.n41 0.000793683480151406f
CMODEL7494 dout.t1 vdd.n42 0.00152029903770169f
CMODEL7495 dout.t1 vdd.n43 0.000184483903626592f
CMODEL7496 dout.t1 vdd.t13 1.88765018797398e-05f
CMODEL7497 dout.t1 vdd.t12 0.00014920896701687f
CMODEL7498 dout.t1 vdd.n44 0.000184483903626592f
CMODEL7499 dout.t1 vdd.t23 1.88765018797398e-05f
CMODEL7500 dout.t1 vdd.t22 0.00014920896701687f
CMODEL7501 dout.t1 vdd.n45 0.000227737690828883f
CMODEL7502 dout.t1 vdd.n46 0.00375904735389401f
CMODEL7503 a_6400_n24000.t0 we 7.61736201168943e-05f
CMODEL7504 a_6400_n24000.t0 we.t1 0.000435511412655313f
CMODEL7505 a_6400_n24000.t0 we.t3 0.000443712380398509f
CMODEL7506 a_6400_n24000.t0 we.n0 0.0151612304079855f
CMODEL7507 a_6400_n24000.t0 we.t0 0.000537797833801245f
CMODEL7508 a_6400_n24000.t0 we.n1 0.0414031775178389f
CMODEL7509 a_6400_n24000.t0 we.t2 0.000809298407654667f
CMODEL7510 a_6400_n24000.t1 we 7.61570528594258e-05f
CMODEL7511 a_6400_n24000.t1 we.t1 0.000435416691809791f
CMODEL7512 a_6400_n24000.t1 we.t3 0.000443615875896862f
CMODEL7513 a_6400_n24000.t1 we.n0 0.015157932940866f
CMODEL7514 a_6400_n24000.t1 we.t0 0.000537680866337116f
CMODEL7515 a_6400_n24000.t1 we.n1 0.0413941726011644f
CMODEL7516 a_6400_n24000.t1 we.t2 0.000809122390615331f
CMODEL7517 a_3200_83.t0 en 6.51476913894145e-07f
CMODEL7518 a_3200_83.t0 en.t3 4.93980879857672e-06f
CMODEL7519 a_3200_83.t0 en.t1 4.44634385400296e-06f
CMODEL7520 a_3200_83.t0 en.n0 0.000177686754055062f
CMODEL7521 a_3200_83.t0 en.t0 6.08077252446077e-06f
CMODEL7522 a_3200_83.t0 en.t2 4.44634385400296e-06f
CMODEL7523 a_3200_83.t1 en 6.51476913894145e-07f
CMODEL7524 a_3200_83.t1 en.t3 4.93980879857672e-06f
CMODEL7525 a_3200_83.t1 en.t1 4.44634385400296e-06f
CMODEL7526 a_3200_83.t1 en.n0 0.000177686754055062f
CMODEL7527 a_3200_83.t1 en.t0 6.08077252446077e-06f
CMODEL7528 a_3200_83.t1 en.t2 4.44634385400296e-06f
CMODEL7529 a_12800_83.t1 a_6400_83.t1 0.00020136622271448f
CMODEL7530 a_12800_83.t1 a_6400_83.n0 0.00227160035097766f
CMODEL7531 a_12800_83.t1 a_6400_83.t0 4.57150001844329e-05f
CMODEL7532 a_12800_83.t1 a_6400_83.t3 4.50858294640605e-05f
CMODEL7533 a_12800_83.t1 a_6400_83.t2 4.50858294640605e-05f
CMODEL7534 a_12800_83.t1 a_6400_83.n1 0.0166030352264209f
CMODEL7535 a_12800_83.n0 a_6400_83.t1 0.0028041994972308f
CMODEL7536 a_12800_83.n0 a_6400_83.n0 0.031634007313893f
CMODEL7537 a_12800_83.n0 a_6400_83.t0 0.00063662107182127f
CMODEL7538 a_12800_83.n0 a_6400_83.t3 0.000627859323232271f
CMODEL7539 a_12800_83.n0 a_6400_83.t2 0.000627859323232271f
CMODEL7540 a_12800_83.n0 a_6400_83.n1 0.231211681913755f
CMODEL7541 a_12800_83.t0 a_6400_83.t1 4.57151084297775e-05f
CMODEL7542 a_12800_83.t0 a_6400_83.n0 0.000515709412205193f
CMODEL7543 a_12800_83.t0 a_6400_83.t0 1.03784346854532e-05f
CMODEL7544 a_12800_83.t0 a_6400_83.t3 1.02355973847633e-05f
CMODEL7545 a_12800_83.t0 a_6400_83.t2 1.02355973847633e-05f
CMODEL7546 a_12800_83.t0 a_6400_83.n1 0.00376929926681625f
CMODEL7547 a_12800_83.t2 a_6400_83.t1 4.50858223886987e-05f
CMODEL7548 a_12800_83.t2 a_6400_83.n0 0.0005086104739001f
CMODEL7549 a_12800_83.t2 a_6400_83.t0 1.02355715423889e-05f
CMODEL7550 a_12800_83.t2 a_6400_83.t3 1.00947004520517e-05f
CMODEL7551 a_12800_83.t2 a_6400_83.t2 1.00947004520517e-05f
CMODEL7552 a_12800_83.t2 a_6400_83.n1 0.00371741341343587f
CMODEL7553 a_12800_83.t3 a_6400_83.t1 4.50858223886987e-05f
CMODEL7554 a_12800_83.t3 a_6400_83.n0 0.0005086104739001f
CMODEL7555 a_12800_83.t3 a_6400_83.t0 1.02355715423889e-05f
CMODEL7556 a_12800_83.t3 a_6400_83.t3 1.00947004520517e-05f
CMODEL7557 a_12800_83.t3 a_6400_83.t2 1.00947004520517e-05f
CMODEL7558 a_12800_83.t3 a_6400_83.n1 0.00371741341343587f
CMODEL7559 a_12800_83.n1 a_6400_83.t1 0.0189457581810521f
CMODEL7560 a_12800_83.n1 a_6400_83.n0 0.213725968305215f
CMODEL7561 a_12800_83.n1 a_6400_83.t0 0.00430114508315072f
CMODEL7562 a_12800_83.n1 a_6400_83.t3 0.00424194887754043f
CMODEL7563 a_12800_83.n1 a_6400_83.t2 0.00424194887754043f
CMODEL7564 a_12800_83.n1 a_6400_83.n1 1.56211447099186f
CMODEL7565 a_0_n11917.t2 sa_en 6.91463069018326e-07f
CMODEL7566 a_0_n11917.t2 sa_en.t1 4.68523415935451e-06f
CMODEL7567 a_0_n11917.t2 sa_en.n0 0.000205288560294976f
CMODEL7568 a_0_n11917.t2 sa_en.t0 5.73984837298382e-06f
CMODEL7569 a_0_n11917.t1 sa_en 1.08169813171531e-06f
CMODEL7570 a_0_n11917.t1 sa_en.t1 7.3293994486468e-06f
CMODEL7571 a_0_n11917.t1 sa_en.n0 0.000321145498701561f
CMODEL7572 a_0_n11917.t1 sa_en.t0 8.97919721179098e-06f
CMODEL7573 a_0_n11917.n0 sa_en 2.94959495155982e-05f
CMODEL7574 a_0_n11917.n0 sa_en.t1 0.000199859452261526f
CMODEL7575 a_0_n11917.n0 sa_en.n0 0.00875705627950168f
CMODEL7576 a_0_n11917.n0 sa_en.t0 0.000244846450117833f
CMODEL7577 a_0_n11917.t6 sa_en 1.84293881863078e-06f
CMODEL7578 a_0_n11917.t6 sa_en.t1 1.24874346780486e-05f
CMODEL7579 a_0_n11917.t6 sa_en.n0 0.000547150345029359f
CMODEL7580 a_0_n11917.t6 sa_en.t0 1.52982709469134e-05f
CMODEL7581 a_0_n11917.n1 sa_en 0.000114349992757296f
CMODEL7582 a_0_n11917.n1 sa_en.t1 0.00077481577280626f
CMODEL7583 a_0_n11917.n1 sa_en.n0 0.033949384189402f
CMODEL7584 a_0_n11917.n1 sa_en.t0 0.000949221512018713f
CMODEL7585 a_0_n11917.t4 sa_en 1.46306106663872e-07f
CMODEL7586 a_0_n11917.t4 sa_en.t1 9.91344873467959e-07f
CMODEL7587 a_0_n11917.t4 sa_en.n0 4.34368389942073e-05f
CMODEL7588 a_0_n11917.t4 sa_en.t0 1.21448983455394e-06f
CMODEL7589 a_0_n11917.t5 sa_en 1.47715081957929e-07f
CMODEL7590 a_0_n11917.t5 sa_en.t1 1.00089184636237e-06f
CMODEL7591 a_0_n11917.t5 sa_en.n0 4.38551498521087e-05f
CMODEL7592 a_0_n11917.t5 sa_en.t0 1.22618576585024e-06f
CMODEL7593 a_0_n11917.n2 sa_en 3.7148408694126e-05f
CMODEL7594 a_0_n11917.n2 sa_en.t1 0.00025171119207636f
CMODEL7595 a_0_n11917.n2 sa_en.n0 0.0110289958781072f
CMODEL7596 a_0_n11917.n2 sa_en.t0 0.000308369662467492f
CMODEL7597 a_0_n11917.t0 sa_en 2.927919074725e-07f
CMODEL7598 a_0_n11917.t0 sa_en.t1 1.98390732338066e-06f
CMODEL7599 a_0_n11917.t0 sa_en.n0 8.69270274063708e-05f
CMODEL7600 a_0_n11917.t0 sa_en.t0 2.43047131369545e-06f
CMODEL7601 a_0_n11917.t3 sa_en 5.25815377409697e-07f
CMODEL7602 a_0_n11917.t3 sa_en.t1 3.5628340516455e-06f
CMODEL7603 a_0_n11917.t3 sa_en.n0 0.000156109395636479f
CMODEL7604 a_0_n11917.t3 sa_en.t0 4.36480366594233e-06f
CMODEL7605 a_0_n11917.n3 sa_en 8.15244189888669e-05f
CMODEL7606 a_0_n11917.n3 sa_en.t1 0.000552395362503511f
CMODEL7607 a_0_n11917.n3 sa_en.n0 0.0242037953333778f
CMODEL7608 a_0_n11917.n3 sa_en.t0 0.000676735786274215f
CMODEL7609 a_0_n11917.n4 sa_en 0.000148499241225765f
CMODEL7610 a_0_n11917.n4 sa_en.t1 0.00100620517393206f
CMODEL7611 a_0_n11917.n4 sa_en.n0 0.0440879589989002f
CMODEL7612 a_0_n11917.n4 sa_en.t0 0.00123269508717095f
CMODEL7613 a_1600_n11917.t5 a_6400_83.t1 9.02718861078753e-06f
CMODEL7614 a_1600_n11917.t5 a_6400_83.n0 0.000101835176427193f
CMODEL7615 a_1600_n11917.t5 a_6400_83.t0 2.04939002899312e-06f
CMODEL7616 a_1600_n11917.t5 a_6400_83.t3 2.02118449042452e-06f
CMODEL7617 a_1600_n11917.t5 a_6400_83.t2 2.02118449042452e-06f
CMODEL7618 a_1600_n11917.t5 a_6400_83.n1 0.000744309191879544f
CMODEL7619 a_1600_n11917.t4 a_6400_83.t1 1.43489556612206e-05f
CMODEL7620 a_1600_n11917.t4 a_6400_83.n0 0.000161869713186252f
CMODEL7621 a_1600_n11917.t4 a_6400_83.t0 3.25755979258359e-06f
CMODEL7622 a_1600_n11917.t4 a_6400_83.t3 3.21272634113249e-06f
CMODEL7623 a_1600_n11917.t4 a_6400_83.t2 3.21272634113249e-06f
CMODEL7624 a_1600_n11917.t4 a_6400_83.n1 0.00118309919654895f
CMODEL7625 a_1600_n11917.n0 a_6400_83.t1 0.000249799043212411f
CMODEL7626 a_1600_n11917.n0 a_6400_83.n0 0.00281796811096657f
CMODEL7627 a_1600_n11917.n0 a_6400_83.t0 5.67104212046451e-05f
CMODEL7628 a_1600_n11917.n0 a_6400_83.t3 5.59299216658067e-05f
CMODEL7629 a_1600_n11917.n0 a_6400_83.t2 5.59299216658067e-05f
CMODEL7630 a_1600_n11917.n0 a_6400_83.n1 0.0205964151190469f
CMODEL7631 a_1600_n11917.t6 a_6400_83.t1 2.64901036676752e-05f
CMODEL7632 a_1600_n11917.t6 a_6400_83.n0 0.00029883327987062f
CMODEL7633 a_1600_n11917.t6 a_6400_83.t0 6.01389387817295e-06f
CMODEL7634 a_1600_n11917.t6 a_6400_83.t3 5.93112529175038e-06f
CMODEL7635 a_1600_n11917.t6 a_6400_83.t2 5.93112529175038e-06f
CMODEL7636 a_1600_n11917.t6 a_6400_83.n1 0.00218416037415359f
CMODEL7637 a_1600_n11917.n1 a_6400_83.t1 0.00147163969788519f
CMODEL7638 a_1600_n11917.n1 a_6400_83.n0 0.0166014796779931f
CMODEL7639 a_1600_n11917.n1 a_6400_83.t0 0.000334097785384951f
CMODEL7640 a_1600_n11917.n1 a_6400_83.t3 0.000329499632842953f
CMODEL7641 a_1600_n11917.n1 a_6400_83.t2 0.000329499632842953f
CMODEL7642 a_1600_n11917.n1 a_6400_83.n1 0.121339544513541f
CMODEL7643 a_1600_n11917.t2 a_6400_83.t1 1.85025795808895e-06f
CMODEL7644 a_1600_n11917.t2 a_6400_83.n0 2.08726496943513e-05f
CMODEL7645 a_1600_n11917.t2 a_6400_83.t0 4.20053282795191e-07f
CMODEL7646 a_1600_n11917.t2 a_6400_83.t3 4.14272133818601e-07f
CMODEL7647 a_1600_n11917.t2 a_6400_83.t2 4.14272133818601e-07f
CMODEL7648 a_1600_n11917.t2 a_6400_83.n1 0.000152557353671348f
CMODEL7649 a_1600_n11917.t3 a_6400_83.t1 1.85025795808895e-06f
CMODEL7650 a_1600_n11917.t3 a_6400_83.n0 2.08726496943513e-05f
CMODEL7651 a_1600_n11917.t3 a_6400_83.t0 4.20053282795191e-07f
CMODEL7652 a_1600_n11917.t3 a_6400_83.t3 4.14272133818601e-07f
CMODEL7653 a_1600_n11917.t3 a_6400_83.t2 4.14272133818601e-07f
CMODEL7654 a_1600_n11917.t3 a_6400_83.n1 0.000152557353671348f
CMODEL7655 a_1600_n11917.n2 a_6400_83.t1 0.000448835380211441f
CMODEL7656 a_1600_n11917.n2 a_6400_83.n0 0.00506328516011929f
CMODEL7657 a_1600_n11917.n2 a_6400_83.t0 0.000101896481011314f
CMODEL7658 a_1600_n11917.n2 a_6400_83.t3 0.00010049409050267f
CMODEL7659 a_1600_n11917.n2 a_6400_83.t2 0.00010049409050267f
CMODEL7660 a_1600_n11917.n2 a_6400_83.n1 0.0370073467538839f
CMODEL7661 a_1600_n11917.t1 a_6400_83.t1 6.5367708651979e-06f
CMODEL7662 a_1600_n11917.t1 a_6400_83.n0 7.37409223427637e-05f
CMODEL7663 a_1600_n11917.t1 a_6400_83.t0 1.48400499984464e-06f
CMODEL7664 a_1600_n11917.t1 a_6400_83.t3 1.46358079573174e-06f
CMODEL7665 a_1600_n11917.t1 a_6400_83.t2 1.46358079573174e-06f
CMODEL7666 a_1600_n11917.t1 a_6400_83.n1 0.000538969423366546f
CMODEL7667 a_1600_n11917.t0 a_6400_83.t1 8.98450522204651e-06f
CMODEL7668 a_1600_n11917.t0 a_6400_83.n0 0.000101353667664015f
CMODEL7669 a_1600_n11917.t0 a_6400_83.t0 2.03969986796281e-06f
CMODEL7670 a_1600_n11917.t0 a_6400_83.t3 2.01162769405726e-06f
CMODEL7671 a_1600_n11917.t0 a_6400_83.t2 2.01162769405726e-06f
CMODEL7672 a_1600_n11917.t0 a_6400_83.n1 0.000740789863775272f
CMODEL7673 a_1600_n11917.n3 a_6400_83.t1 0.00124541238205104f
CMODEL7674 a_1600_n11917.n3 a_6400_83.n0 0.014049422817999f
CMODEL7675 a_1600_n11917.n3 a_6400_83.t0 0.000282738716094835f
CMODEL7676 a_1600_n11917.n3 a_6400_83.t3 0.000278847413000339f
CMODEL7677 a_1600_n11917.n3 a_6400_83.t2 0.000278847413000339f
CMODEL7678 a_1600_n11917.n3 a_6400_83.n1 0.102686663988992f
CMODEL7679 a_1600_n11917.n4 a_6400_83.t1 0.00182597073500984f
CMODEL7680 a_1600_n11917.n4 a_6400_83.n0 0.0205986669790425f
CMODEL7681 a_1600_n11917.n4 a_6400_83.t0 0.000414539496060882f
CMODEL7682 a_1600_n11917.n4 a_6400_83.t3 0.000408834232748902f
CMODEL7683 a_1600_n11917.n4 a_6400_83.t2 0.000408834232748902f
CMODEL7684 a_1600_n11917.n4 a_6400_83.n1 0.150554825069984f
CMODEL7685 a_3200_n35917.t1 a_n104_n35959.t0 0.000314316375083333f
CMODEL7686 a_3200_n35917.t1 a_n104_n35959.t3 0.000274296387239588f
CMODEL7687 a_3200_n35917.t1 a_n104_n35959.t4 0.000109975739183197f
CMODEL7688 a_3200_n35917.t1 a_n104_n35959.t2 0.000150524925343353f
CMODEL7689 a_3200_n35917.t1 a_n104_n35959.n0 0.0112365765360769f
CMODEL7690 a_3200_n35917.t1 a_n104_n35959.t1 0.000278563493050034f
CMODEL7691 a_3200_n35917.t1 a_n104_n35959.n1 0.00524916990300247f
CMODEL7692 a_3200_n35917.n0 a_n104_n35959.t0 0.00407709178044995f
CMODEL7693 a_3200_n35917.n0 a_n104_n35959.t3 0.00355798053959213f
CMODEL7694 a_3200_n35917.n0 a_n104_n35959.t4 0.00142652823020704f
CMODEL7695 a_3200_n35917.n0 a_n104_n35959.t2 0.0019525038608234f
CMODEL7696 a_3200_n35917.n0 a_n104_n35959.n0 0.145752997512426f
CMODEL7697 a_3200_n35917.n0 a_n104_n35959.t1 0.00361333044626329f
CMODEL7698 a_3200_n35917.n0 a_n104_n35959.n1 0.0680885539610927f
CMODEL7699 a_3200_n35917.t0 a_n104_n35959.t0 7.13574719027363e-05f
CMODEL7700 a_3200_n35917.t0 a_n104_n35959.t3 6.22719600284321e-05f
CMODEL7701 a_3200_n35917.t0 a_n104_n35959.t4 2.49671711079864e-05f
CMODEL7702 a_3200_n35917.t0 a_n104_n35959.t2 3.41728238880397e-05f
CMODEL7703 a_3200_n35917.t0 a_n104_n35959.n0 0.00255097652562158f
CMODEL7704 a_3200_n35917.t0 a_n104_n35959.t1 6.32406969671111e-05f
CMODEL7705 a_3200_n35917.t0 a_n104_n35959.n1 0.00119168940455896f
CMODEL7706 a_3200_n35917.t3 a_n104_n35959.t0 0.000525231325503282f
CMODEL7707 a_3200_n35917.t3 a_n104_n35959.t3 0.000458356822842635f
CMODEL7708 a_3200_n35917.t3 a_n104_n35959.t4 0.000183772491169381f
CMODEL7709 a_3200_n35917.t3 a_n104_n35959.t2 0.000251531298801759f
CMODEL7710 a_3200_n35917.t3 a_n104_n35959.n0 0.0187766290782591f
CMODEL7711 a_3200_n35917.t3 a_n104_n35959.t1 0.000465487274255766f
CMODEL7712 a_3200_n35917.t3 a_n104_n35959.n1 0.00877150757804127f
CMODEL7713 a_3200_n35917.t2 a_n104_n35959.t0 0.000119998735203821f
CMODEL7714 a_3200_n35917.t2 a_n104_n35959.t3 0.000104720027809564f
CMODEL7715 a_3200_n35917.t2 a_n104_n35959.t4 4.19861981469787e-05f
CMODEL7716 a_3200_n35917.t2 a_n104_n35959.t2 5.7466941240535e-05f
CMODEL7717 a_3200_n35917.t2 a_n104_n35959.n0 0.00428986549616661f
CMODEL7718 a_3200_n35917.t2 a_n104_n35959.t1 0.000106349110290866f
CMODEL7719 a_3200_n35917.t2 a_n104_n35959.n1 0.00200401187836065f
CMODEL7720 a_6400_83.t1 vdd 3.41582034011327e-06f
CMODEL7721 a_6400_83.t1 vdd.n0 0.00114628574293838f
CMODEL7722 a_6400_83.t1 vdd.n1 0.000106227168574359f
CMODEL7723 a_6400_83.t1 vdd.t7 8.75698555100954e-06f
CMODEL7724 a_6400_83.t1 vdd.t6 6.9219433588497e-05f
CMODEL7725 a_6400_83.t1 vdd.n2 9.52581764783225e-05f
CMODEL7726 a_6400_83.t1 vdd.t27 8.75698555100954e-06f
CMODEL7727 a_6400_83.t1 vdd.t26 6.9219433588497e-05f
CMODEL7728 a_6400_83.t1 vdd.n3 0.000178669039372846f
CMODEL7729 a_6400_83.t1 vdd.n4 9.52581764783225e-05f
CMODEL7730 a_6400_83.t1 vdd.t36 8.75698555100954e-06f
CMODEL7731 a_6400_83.t1 vdd.t35 6.9219433588497e-05f
CMODEL7732 a_6400_83.t1 vdd.n5 0.00013591844546115f
CMODEL7733 a_6400_83.t1 vdd.t3 1.39493494658374e-05f
CMODEL7734 a_6400_83.t1 vdd.n6 0.000133460749535574f
CMODEL7735 a_6400_83.t1 vdd.t2 0.000174909502557188f
CMODEL7736 a_6400_83.t1 vdd.n7 0.000178909675396891f
CMODEL7737 a_6400_83.t1 vdd.t25 1.39493494658374e-05f
CMODEL7738 a_6400_83.t1 vdd.n8 8.06114638148037e-05f
CMODEL7739 a_6400_83.t1 vdd.t24 0.000174909502557188f
CMODEL7740 a_6400_83.t1 vdd.n9 0.000178909675396891f
CMODEL7741 a_6400_83.t1 vdd.t5 1.39493494658374e-05f
CMODEL7742 a_6400_83.t1 vdd.n10 0.000238698101931029f
CMODEL7743 a_6400_83.t1 vdd.t4 0.000175005756966806f
CMODEL7744 a_6400_83.t1 vdd.n11 0.000577131814627772f
CMODEL7745 a_6400_83.t1 vdd.n12 0.00142299310698735f
CMODEL7746 a_6400_83.t1 vdd.n13 0.000107861087177622f
CMODEL7747 a_6400_83.t1 vdd.t42 8.75698555100954e-06f
CMODEL7748 a_6400_83.t1 vdd.t41 6.9219433588497e-05f
CMODEL7749 a_6400_83.t1 vdd.n14 9.69755155699213e-05f
CMODEL7750 a_6400_83.t1 vdd.t9 8.75698555100954e-06f
CMODEL7751 a_6400_83.t1 vdd.t8 6.9219433588497e-05f
CMODEL7752 a_6400_83.t1 vdd.n15 0.00018618009180336f
CMODEL7753 a_6400_83.t1 vdd.t15 1.47476193696016e-05f
CMODEL7754 a_6400_83.t1 vdd.n16 0.000116001803871053f
CMODEL7755 a_6400_83.t1 vdd.t14 0.000198936207437968f
CMODEL7756 a_6400_83.t1 vdd.n17 0.000162493485836563f
CMODEL7757 a_6400_83.t1 vdd.t32 0.000198936207437968f
CMODEL7758 a_6400_83.t1 vdd.n18 0.000160403160907695f
CMODEL7759 a_6400_83.t1 vdd.t34 1.47476193696016e-05f
CMODEL7760 a_6400_83.t1 vdd.n19 0.000161527733260064f
CMODEL7761 a_6400_83.t1 vdd.t33 0.000198936207437968f
CMODEL7762 a_6400_83.t1 vdd.n20 0.000322352007209837f
CMODEL7763 a_6400_83.t1 vdd.t48 0.000199316412355959f
CMODEL7764 a_6400_83.t1 vdd.n21 0.000572210005815978f
CMODEL7765 a_6400_83.t1 vdd.n22 0.00250763592176629f
CMODEL7766 a_6400_83.t1 vdd.t47 2.83506935968387e-06f
CMODEL7767 a_6400_83.t1 vdd.t45 2.80596042197526e-06f
CMODEL7768 a_6400_83.t1 vdd.n23 3.20408470255637e-05f
CMODEL7769 a_6400_83.t1 vdd.t46 7.64672302087064e-05f
CMODEL7770 a_6400_83.t1 vdd.n24 8.21571492092506e-05f
CMODEL7771 a_6400_83.t1 vdd.t44 7.64672302087064e-05f
CMODEL7772 a_6400_83.t1 vdd.n25 0.000129569665026772f
CMODEL7773 a_6400_83.t1 vdd.t43 7.66328680052572e-05f
CMODEL7774 a_6400_83.t1 vdd.n26 0.00069327078103253f
CMODEL7775 a_6400_83.t1 vdd.n27 0.000463465784430112f
CMODEL7776 a_6400_83.t1 vdd.n28 0.000104688702260633f
CMODEL7777 a_6400_83.t1 vdd.t29 8.75698555100954e-06f
CMODEL7778 a_6400_83.t1 vdd.t28 6.9219433588497e-05f
CMODEL7779 a_6400_83.t1 vdd.n29 1.56273846735089e-05f
CMODEL7780 a_6400_83.t1 vdd.n30 4.98548110375584e-06f
CMODEL7781 a_6400_83.t1 vdd.t38 2.29542703336209e-06f
CMODEL7782 a_6400_83.t1 vdd.t40 2.29542703336209e-06f
CMODEL7783 a_6400_83.t1 vdd.t37 4.63837166027221e-05f
CMODEL7784 a_6400_83.t1 vdd.t39 4.63837166027221e-05f
CMODEL7785 a_6400_83.t1 vdd.n31 1.50225861330766e-05f
CMODEL7786 a_6400_83.t1 vdd.n32 0.000181291169914853f
CMODEL7787 a_6400_83.t1 vdd.n33 9.18603958188118e-05f
CMODEL7788 a_6400_83.t1 vdd.t17 8.75698555100954e-06f
CMODEL7789 a_6400_83.t1 vdd.t16 6.9219433588497e-05f
CMODEL7790 a_6400_83.t1 vdd.n34 1.56273846735089e-05f
CMODEL7791 a_6400_83.t1 vdd.n35 4.98548110375584e-06f
CMODEL7792 a_6400_83.t1 vdd.t1 2.29542703336209e-06f
CMODEL7793 a_6400_83.t1 vdd.t31 2.29542703336209e-06f
CMODEL7794 a_6400_83.t1 vdd.t0 4.63837166027221e-05f
CMODEL7795 a_6400_83.t1 vdd.t30 4.63837166027221e-05f
CMODEL7796 a_6400_83.t1 vdd.n36 1.50225861330766e-05f
CMODEL7797 a_6400_83.t1 vdd.n37 0.000175816700367836f
CMODEL7798 a_6400_83.t1 vdd.n38 0.000101419260813946f
CMODEL7799 a_6400_83.t1 vdd.t19 8.75698555100954e-06f
CMODEL7800 a_6400_83.t1 vdd.t18 6.9219433588497e-05f
CMODEL7801 a_6400_83.t1 vdd.n39 8.55838061916467e-05f
CMODEL7802 a_6400_83.t1 vdd.t21 8.75706576301755e-06f
CMODEL7803 a_6400_83.t1 vdd.t20 6.9219433588497e-05f
CMODEL7804 a_6400_83.t1 vdd.n40 8.55838061916467e-05f
CMODEL7805 a_6400_83.t1 vdd.t11 8.75698555100954e-06f
CMODEL7806 a_6400_83.t1 vdd.t10 6.9219433588497e-05f
CMODEL7807 a_6400_83.t1 vdd.n41 0.000368197180390748f
CMODEL7808 a_6400_83.t1 vdd.n42 0.000705280924992599f
CMODEL7809 a_6400_83.t1 vdd.n43 8.55838061916467e-05f
CMODEL7810 a_6400_83.t1 vdd.t13 8.75698555100954e-06f
CMODEL7811 a_6400_83.t1 vdd.t12 6.9219433588497e-05f
CMODEL7812 a_6400_83.t1 vdd.n44 8.55838061916467e-05f
CMODEL7813 a_6400_83.t1 vdd.t23 8.75698555100954e-06f
CMODEL7814 a_6400_83.t1 vdd.t22 6.9219433588497e-05f
CMODEL7815 a_6400_83.t1 vdd.n45 0.000105649642116651f
CMODEL7816 a_6400_83.t1 vdd.n46 0.00174385718144851f
CMODEL7817 a_6400_83.n0 vdd 3.85336655715099e-05f
CMODEL7818 a_6400_83.n0 vdd.n0 0.0129311811130888f
CMODEL7819 a_6400_83.n0 vdd.n1 0.00119834235436311f
CMODEL7820 a_6400_83.n0 vdd.t7 9.87870318220413e-05f
CMODEL7821 a_6400_83.n0 vdd.t6 0.000780860302758205f
CMODEL7822 a_6400_83.n0 vdd.n2 0.00107460180860854f
CMODEL7823 a_6400_83.n0 vdd.t27 9.87870318220413e-05f
CMODEL7824 a_6400_83.n0 vdd.t26 0.000780860302758205f
CMODEL7825 a_6400_83.n0 vdd.n3 0.00201555477913334f
CMODEL7826 a_6400_83.n0 vdd.n4 0.00107460180860854f
CMODEL7827 a_6400_83.n0 vdd.t36 9.87870318220413e-05f
CMODEL7828 a_6400_83.n0 vdd.t35 0.000780860302758205f
CMODEL7829 a_6400_83.n0 vdd.n5 0.00153328787843268f
CMODEL7830 a_6400_83.n0 vdd.t3 0.000157361779524644f
CMODEL7831 a_6400_83.n0 vdd.n6 0.00150556275724862f
CMODEL7832 a_6400_83.n0 vdd.t2 0.00197314366849702f
CMODEL7833 a_6400_83.n0 vdd.n7 0.00201826937977147f
CMODEL7834 a_6400_83.n0 vdd.t25 0.000157361779524644f
CMODEL7835 a_6400_83.n0 vdd.n8 0.000909373116434604f
CMODEL7836 a_6400_83.n0 vdd.t24 0.00197314366849702f
CMODEL7837 a_6400_83.n0 vdd.n9 0.00201826937977147f
CMODEL7838 a_6400_83.n0 vdd.t5 0.000157361779524644f
CMODEL7839 a_6400_83.n0 vdd.n10 0.00269273905432024f
CMODEL7840 a_6400_83.n0 vdd.t4 0.00197422950875227f
CMODEL7841 a_6400_83.n0 vdd.n11 0.00651058958645574f
CMODEL7842 a_6400_83.n0 vdd.n12 0.0160527003868698f
CMODEL7843 a_6400_83.n0 vdd.n13 0.00121677449269599f
CMODEL7844 a_6400_83.n0 vdd.t42 9.87870318220413e-05f
CMODEL7845 a_6400_83.n0 vdd.t41 0.000780860302758205f
CMODEL7846 a_6400_83.n0 vdd.n14 0.00109397500849596f
CMODEL7847 a_6400_83.n0 vdd.t9 9.87870318220413e-05f
CMODEL7848 a_6400_83.n0 vdd.t8 0.000780860302758205f
CMODEL7849 a_6400_83.n0 vdd.n15 0.00210028651371804f
CMODEL7850 a_6400_83.n0 vdd.t15 0.000166367014708187f
CMODEL7851 a_6400_83.n0 vdd.n16 0.00130860943228379f
CMODEL7852 a_6400_83.n0 vdd.t14 0.0022441874935451f
CMODEL7853 a_6400_83.n0 vdd.n17 0.00183307932423851f
CMODEL7854 a_6400_83.n0 vdd.t32 0.0022441874935451f
CMODEL7855 a_6400_83.n0 vdd.n18 0.00180949849336199f
CMODEL7856 a_6400_83.n0 vdd.t34 0.000166367014708187f
CMODEL7857 a_6400_83.n0 vdd.n19 0.00182218472701084f
CMODEL7858 a_6400_83.n0 vdd.t33 0.0022441874935451f
CMODEL7859 a_6400_83.n0 vdd.n20 0.00363643377148955f
CMODEL7860 a_6400_83.n0 vdd.t48 0.00224847656255334f
CMODEL7861 a_6400_83.n0 vdd.n21 0.00645506695473728f
CMODEL7862 a_6400_83.n0 vdd.n22 0.0282884913031587f
CMODEL7863 a_6400_83.n0 vdd.t47 3.19822483914567e-05f
CMODEL7864 a_6400_83.n0 vdd.t45 3.16538722009314e-05f
CMODEL7865 a_6400_83.n0 vdd.n23 0.000361450884700229f
CMODEL7866 a_6400_83.n0 vdd.t46 0.000862622264244799f
CMODEL7867 a_6400_83.n0 vdd.n24 0.000926809901200167f
CMODEL7868 a_6400_83.n0 vdd.t44 0.000862622264244799f
CMODEL7869 a_6400_83.n0 vdd.n25 0.00146166766493012f
CMODEL7870 a_6400_83.n0 vdd.t43 0.000864490814350709f
CMODEL7871 a_6400_83.n0 vdd.n26 0.00782074634110326f
CMODEL7872 a_6400_83.n0 vdd.n27 0.00522832987769937f
CMODEL7873 a_6400_83.n0 vdd.n28 0.00118098700761669f
CMODEL7874 a_6400_83.n0 vdd.t29 9.87870318220413e-05f
CMODEL7875 a_6400_83.n0 vdd.t28 0.000780860302758205f
CMODEL7876 a_6400_83.n0 vdd.n29 0.000176291594641175f
CMODEL7877 a_6400_83.n0 vdd.n30 5.62409150473175e-05f
CMODEL7878 a_6400_83.n0 vdd.t38 2.58945754870834e-05f
CMODEL7879 a_6400_83.n0 vdd.t40 2.58945754870834e-05f
CMODEL7880 a_6400_83.n0 vdd.t37 0.000523251941135087f
CMODEL7881 a_6400_83.n0 vdd.t39 0.000523251941135087f
CMODEL7882 a_6400_83.n0 vdd.n31 0.000169468898370685f
CMODEL7883 a_6400_83.n0 vdd.n32 0.00204513487742012f
CMODEL7884 a_6400_83.n0 vdd.n33 0.0010362716475982f
CMODEL7885 a_6400_83.n0 vdd.t17 9.87870318220413e-05f
CMODEL7886 a_6400_83.n0 vdd.t16 0.000780860302758205f
CMODEL7887 a_6400_83.n0 vdd.n34 0.000176291594641175f
CMODEL7888 a_6400_83.n0 vdd.n35 5.62409150473175e-05f
CMODEL7889 a_6400_83.n0 vdd.t1 2.58945754870834e-05f
CMODEL7890 a_6400_83.n0 vdd.t31 2.58945754870834e-05f
CMODEL7891 a_6400_83.n0 vdd.t0 0.000523251941135087f
CMODEL7892 a_6400_83.n0 vdd.t30 0.000523251941135087f
CMODEL7893 a_6400_83.n0 vdd.n36 0.000169468898370685f
CMODEL7894 a_6400_83.n0 vdd.n37 0.00198337771290275f
CMODEL7895 a_6400_83.n0 vdd.n38 0.00114410463361336f
CMODEL7896 a_6400_83.n0 vdd.t19 9.87870318220413e-05f
CMODEL7897 a_6400_83.n0 vdd.t18 0.000780860302758205f
CMODEL7898 a_6400_83.n0 vdd.n39 0.00096546581428708f
CMODEL7899 a_6400_83.n0 vdd.t21 9.87879366889207e-05f
CMODEL7900 a_6400_83.n0 vdd.t20 0.000780860302758205f
CMODEL7901 a_6400_83.n0 vdd.n40 0.00096546581428708f
CMODEL7902 a_6400_83.n0 vdd.t11 9.87870318220413e-05f
CMODEL7903 a_6400_83.n0 vdd.t10 0.000780860302758205f
CMODEL7904 a_6400_83.n0 vdd.n41 0.00415361043639651f
CMODEL7905 a_6400_83.n0 vdd.n42 0.00795623205895213f
CMODEL7906 a_6400_83.n0 vdd.n43 0.00096546581428708f
CMODEL7907 a_6400_83.n0 vdd.t13 9.87870318220413e-05f
CMODEL7908 a_6400_83.n0 vdd.t12 0.000780860302758205f
CMODEL7909 a_6400_83.n0 vdd.n44 0.00096546581428708f
CMODEL7910 a_6400_83.n0 vdd.t23 9.87870318220413e-05f
CMODEL7911 a_6400_83.n0 vdd.t22 0.000780860302758205f
CMODEL7912 a_6400_83.n0 vdd.n45 0.00119182731283161f
CMODEL7913 a_6400_83.n0 vdd.n46 0.019672348877747f
CMODEL7914 a_6400_83.t0 vdd 7.75473787873955e-07f
CMODEL7915 a_6400_83.t0 vdd.n0 0.000260234572826761f
CMODEL7916 a_6400_83.t0 vdd.n1 2.41161350970676e-05f
CMODEL7917 a_6400_83.t0 vdd.t7 1.98804740280154e-06f
CMODEL7918 a_6400_83.t0 vdd.t6 1.57144846668316e-05f
CMODEL7919 a_6400_83.t0 vdd.n2 2.16259087376829e-05f
CMODEL7920 a_6400_83.t0 vdd.t27 1.98804740280154e-06f
CMODEL7921 a_6400_83.t0 vdd.t26 1.57144846668316e-05f
CMODEL7922 a_6400_83.t0 vdd.n3 4.05621909065824e-05f
CMODEL7923 a_6400_83.t0 vdd.n4 2.16259087376829e-05f
CMODEL7924 a_6400_83.t0 vdd.t36 1.98804740280154e-06f
CMODEL7925 a_6400_83.t0 vdd.t35 1.57144846668316e-05f
CMODEL7926 a_6400_83.t0 vdd.n5 3.08567726779806e-05f
CMODEL7927 a_6400_83.t0 vdd.t3 3.16683952654598e-06f
CMODEL7928 a_6400_83.t0 vdd.n6 3.02988162929602e-05f
CMODEL7929 a_6400_83.t0 vdd.t2 3.97086851700971e-05f
CMODEL7930 a_6400_83.t0 vdd.n7 4.06168211009382e-05f
CMODEL7931 a_6400_83.t0 vdd.t25 3.16683952654598e-06f
CMODEL7932 a_6400_83.t0 vdd.n8 1.83007509078938e-05f
CMODEL7933 a_6400_83.t0 vdd.t24 3.97086851700971e-05f
CMODEL7934 a_6400_83.t0 vdd.n9 4.06168211009382e-05f
CMODEL7935 a_6400_83.t0 vdd.t5 3.16683952654598e-06f
CMODEL7936 a_6400_83.t0 vdd.n10 5.41902391905777e-05f
CMODEL7937 a_6400_83.t0 vdd.t4 3.97305372478394e-05f
CMODEL7938 a_6400_83.t0 vdd.n11 0.000131022872935152f
CMODEL7939 a_6400_83.t0 vdd.n12 0.000323053833316483f
CMODEL7940 a_6400_83.t0 vdd.n13 2.44870741167434e-05f
CMODEL7941 a_6400_83.t0 vdd.t42 1.98804740280154e-06f
CMODEL7942 a_6400_83.t0 vdd.t41 1.57144846668316e-05f
CMODEL7943 a_6400_83.t0 vdd.n14 2.20157862247354e-05f
CMODEL7944 a_6400_83.t0 vdd.t9 1.98804740280154e-06f
CMODEL7945 a_6400_83.t0 vdd.t8 1.57144846668316e-05f
CMODEL7946 a_6400_83.t0 vdd.n15 4.22673813730744e-05f
CMODEL7947 a_6400_83.t0 vdd.t15 3.34806609128892e-06f
CMODEL7948 a_6400_83.t0 vdd.n16 2.63352135917998e-05f
CMODEL7949 a_6400_83.t0 vdd.t14 4.51633279758748e-05f
CMODEL7950 a_6400_83.t0 vdd.n17 3.68899492419862e-05f
CMODEL7951 a_6400_83.t0 vdd.t32 4.51633279758748e-05f
CMODEL7952 a_6400_83.t0 vdd.n18 3.64153949536822e-05f
CMODEL7953 a_6400_83.t0 vdd.t34 3.34806609128892e-06f
CMODEL7954 a_6400_83.t0 vdd.n19 3.66707000619716e-05f
CMODEL7955 a_6400_83.t0 vdd.t33 4.51633279758748e-05f
CMODEL7956 a_6400_83.t0 vdd.n20 7.31816978557765e-05f
CMODEL7957 a_6400_83.t0 vdd.t48 4.5249643682957e-05f
CMODEL7958 a_6400_83.t0 vdd.n21 0.000129905503359928f
CMODEL7959 a_6400_83.t0 vdd.n22 0.000569293971355769f
CMODEL7960 a_6400_83.t0 vdd.t47 6.43629276815692e-07f
CMODEL7961 a_6400_83.t0 vdd.t45 6.3702084430512e-07f
CMODEL7962 a_6400_83.t0 vdd.n23 7.27404679860296e-06f
CMODEL7963 a_6400_83.t0 vdd.t46 1.73599097006984e-05f
CMODEL7964 a_6400_83.t0 vdd.n24 1.86516588563058e-05f
CMODEL7965 a_6400_83.t0 vdd.t44 1.73599097006984e-05f
CMODEL7966 a_6400_83.t0 vdd.n25 2.94154460502271e-05f
CMODEL7967 a_6400_83.t0 vdd.t43 1.739751348448e-05f
CMODEL7968 a_6400_83.t0 vdd.n26 0.000157389225737734f
CMODEL7969 a_6400_83.t0 vdd.n27 0.000105217936429899f
CMODEL7970 a_6400_83.t0 vdd.n28 2.37668660544863e-05f
CMODEL7971 a_6400_83.t0 vdd.t29 1.98804740280154e-06f
CMODEL7972 a_6400_83.t0 vdd.t28 1.57144846668316e-05f
CMODEL7973 a_6400_83.t0 vdd.n29 3.54779408185369e-06f
CMODEL7974 a_6400_83.t0 vdd.n30 1.13182472465029e-06f
CMODEL7975 a_6400_83.t0 vdd.t38 5.21117423959877e-07f
CMODEL7976 a_6400_83.t0 vdd.t40 5.21117423959877e-07f
CMODEL7977 a_6400_83.t0 vdd.t37 1.05302249029854e-05f
CMODEL7978 a_6400_83.t0 vdd.t39 1.05302249029854e-05f
CMODEL7979 a_6400_83.t0 vdd.n31 3.4104901933728e-06f
CMODEL7980 a_6400_83.t0 vdd.n32 4.11574779244126e-05f
CMODEL7981 a_6400_83.t0 vdd.n33 2.08545303933791e-05f
CMODEL7982 a_6400_83.t0 vdd.t17 1.98804740280154e-06f
CMODEL7983 a_6400_83.t0 vdd.t16 1.57144846668316e-05f
CMODEL7984 a_6400_83.t0 vdd.n34 3.54779408185369e-06f
CMODEL7985 a_6400_83.t0 vdd.n35 1.13182472465029e-06f
CMODEL7986 a_6400_83.t0 vdd.t1 5.21117423959877e-07f
CMODEL7987 a_6400_83.t0 vdd.t31 5.21117423959877e-07f
CMODEL7988 a_6400_83.t0 vdd.t0 1.05302249029854e-05f
CMODEL7989 a_6400_83.t0 vdd.t30 1.05302249029854e-05f
CMODEL7990 a_6400_83.t0 vdd.n36 3.4104901933728e-06f
CMODEL7991 a_6400_83.t0 vdd.n37 3.99146410028184e-05f
CMODEL7992 a_6400_83.t0 vdd.n38 2.30246238138389e-05f
CMODEL7993 a_6400_83.t0 vdd.t19 1.98804740280154e-06f
CMODEL7994 a_6400_83.t0 vdd.t18 1.57144846668316e-05f
CMODEL7995 a_6400_83.t0 vdd.n39 1.94295928239323e-05f
CMODEL7996 a_6400_83.t0 vdd.t21 1.98806561286633e-06f
CMODEL7997 a_6400_83.t0 vdd.t20 1.57144846668316e-05f
CMODEL7998 a_6400_83.t0 vdd.n40 1.94295928239323e-05f
CMODEL7999 a_6400_83.t0 vdd.t11 1.98804740280154e-06f
CMODEL8000 a_6400_83.t0 vdd.t10 1.57144846668316e-05f
CMODEL8001 a_6400_83.t0 vdd.n41 8.35896603837937e-05f
CMODEL8002 a_6400_83.t0 vdd.n42 0.000160115818738032f
CMODEL8003 a_6400_83.t0 vdd.n43 1.94295928239323e-05f
CMODEL8004 a_6400_83.t0 vdd.t13 1.98804740280154e-06f
CMODEL8005 a_6400_83.t0 vdd.t12 1.57144846668316e-05f
CMODEL8006 a_6400_83.t0 vdd.n44 1.94295928239323e-05f
CMODEL8007 a_6400_83.t0 vdd.t23 1.98804740280154e-06f
CMODEL8008 a_6400_83.t0 vdd.t22 1.57144846668316e-05f
CMODEL8009 a_6400_83.t0 vdd.n45 2.39850226306137e-05f
CMODEL8010 a_6400_83.t0 vdd.n46 0.000395897734470493f
CMODEL8011 a_6400_83.t3 vdd 7.64801024015743e-07f
CMODEL8012 a_6400_83.t3 vdd.n0 0.000256652991879792f
CMODEL8013 a_6400_83.t3 vdd.n1 2.37842272762122e-05f
CMODEL8014 a_6400_83.t3 vdd.t7 1.96068611631988e-06f
CMODEL8015 a_6400_83.t3 vdd.t6 1.54982078736954e-05f
CMODEL8016 a_6400_83.t3 vdd.n2 2.13282736392622e-05f
CMODEL8017 a_6400_83.t3 vdd.t27 1.96068611631988e-06f
CMODEL8018 a_6400_83.t3 vdd.t26 1.54982078736954e-05f
CMODEL8019 a_6400_83.t3 vdd.n3 4.00039377562025e-05f
CMODEL8020 a_6400_83.t3 vdd.n4 2.13282736392622e-05f
CMODEL8021 a_6400_83.t3 vdd.t36 1.96068611631988e-06f
CMODEL8022 a_6400_83.t3 vdd.t35 1.54982078736954e-05f
CMODEL8023 a_6400_83.t3 vdd.n5 3.04320941738606e-05f
CMODEL8024 a_6400_83.t3 vdd.t3 3.12325464853696e-06f
CMODEL8025 a_6400_83.t3 vdd.n6 2.98818168836511e-05f
CMODEL8026 a_6400_83.t3 vdd.t2 3.91621787290445e-05f
CMODEL8027 a_6400_83.t3 vdd.n7 4.00578160809619e-05f
CMODEL8028 a_6400_83.t3 vdd.t25 3.12325464853696e-06f
CMODEL8029 a_6400_83.t3 vdd.n8 1.80488796055724e-05f
CMODEL8030 a_6400_83.t3 vdd.t24 3.91621787290445e-05f
CMODEL8031 a_6400_83.t3 vdd.n9 4.00578160809619e-05f
CMODEL8032 a_6400_83.t3 vdd.t5 3.12325464853696e-06f
CMODEL8033 a_6400_83.t3 vdd.n10 5.34444246506862e-05f
CMODEL8034 a_6400_83.t3 vdd.t4 3.91837300589483e-05f
CMODEL8035 a_6400_83.t3 vdd.n11 0.000129219618969991f
CMODEL8036 a_6400_83.t3 vdd.n12 0.000318607677520644f
CMODEL8037 a_6400_83.t3 vdd.n13 2.41500611013286e-05f
CMODEL8038 a_6400_83.t3 vdd.t42 1.96068611631988e-06f
CMODEL8039 a_6400_83.t3 vdd.t41 1.54982078736954e-05f
CMODEL8040 a_6400_83.t3 vdd.n14 2.17127852836285e-05f
CMODEL8041 a_6400_83.t3 vdd.t9 1.96068611631988e-06f
CMODEL8042 a_6400_83.t3 vdd.t8 1.54982078736954e-05f
CMODEL8043 a_6400_83.t3 vdd.n15 4.16856598663597e-05f
CMODEL8044 a_6400_83.t3 vdd.t15 3.30198701120553e-06f
CMODEL8045 a_6400_83.t3 vdd.n16 2.59727648279396e-05f
CMODEL8046 a_6400_83.t3 vdd.t14 4.45417498618563e-05f
CMODEL8047 a_6400_83.t3 vdd.n17 3.63822367658746e-05f
CMODEL8048 a_6400_83.t3 vdd.t32 4.45417498618563e-05f
CMODEL8049 a_6400_83.t3 vdd.n18 3.59142137181311e-05f
CMODEL8050 a_6400_83.t3 vdd.t34 3.30198701120553e-06f
CMODEL8051 a_6400_83.t3 vdd.n19 3.61660050891734e-05f
CMODEL8052 a_6400_83.t3 vdd.t33 4.45417498618563e-05f
CMODEL8053 a_6400_83.t3 vdd.n20 7.21745058756335e-05f
CMODEL8054 a_6400_83.t3 vdd.t48 4.46268776149762e-05f
CMODEL8055 a_6400_83.t3 vdd.n21 0.000128117627634246f
CMODEL8056 a_6400_83.t3 vdd.n22 0.000561458838541233f
CMODEL8057 a_6400_83.t3 vdd.t47 6.3477107504137e-07f
CMODEL8058 a_6400_83.t3 vdd.t45 6.28253593689639e-07f
CMODEL8059 a_6400_83.t3 vdd.n23 7.17393486059933e-06f
CMODEL8060 a_6400_83.t3 vdd.t46 1.71209870965658e-05f
CMODEL8061 a_6400_83.t3 vdd.n24 1.83949580449437e-05f
CMODEL8062 a_6400_83.t3 vdd.t44 1.71209870965658e-05f
CMODEL8063 a_6400_83.t3 vdd.n25 2.90106043722913e-05f
CMODEL8064 a_6400_83.t3 vdd.t43 1.71580733434418e-05f
CMODEL8065 a_6400_83.t3 vdd.n26 0.000155223094443044f
CMODEL8066 a_6400_83.t3 vdd.n27 0.00010376983308105f
CMODEL8067 a_6400_83.t3 vdd.n28 2.34397651865837e-05f
CMODEL8068 a_6400_83.t3 vdd.t29 1.96068611631988e-06f
CMODEL8069 a_6400_83.t3 vdd.t28 1.54982078736954e-05f
CMODEL8070 a_6400_83.t3 vdd.n29 3.49896616652595e-06f
CMODEL8071 a_6400_83.t3 vdd.n30 1.11624754047725e-06f
CMODEL8072 a_6400_83.t3 vdd.t38 5.13945339880063e-07f
CMODEL8073 a_6400_83.t3 vdd.t40 5.13945339880063e-07f
CMODEL8074 a_6400_83.t3 vdd.t37 1.03852985295595e-05f
CMODEL8075 a_6400_83.t3 vdd.t39 1.03852985295595e-05f
CMODEL8076 a_6400_83.t3 vdd.n31 3.36355197696396e-06f
CMODEL8077 a_6400_83.t3 vdd.n32 4.05910319016642e-05f
CMODEL8078 a_6400_83.t3 vdd.n33 2.05675116936592e-05f
CMODEL8079 a_6400_83.t3 vdd.t17 1.96068611631988e-06f
CMODEL8080 a_6400_83.t3 vdd.t16 1.54982078736954e-05f
CMODEL8081 a_6400_83.t3 vdd.n34 3.49896616652595e-06f
CMODEL8082 a_6400_83.t3 vdd.n35 1.11624754047725e-06f
CMODEL8083 a_6400_83.t3 vdd.t1 5.13945339880063e-07f
CMODEL8084 a_6400_83.t3 vdd.t31 5.13945339880063e-07f
CMODEL8085 a_6400_83.t3 vdd.t0 1.03852985295595e-05f
CMODEL8086 a_6400_83.t3 vdd.t30 1.03852985295595e-05f
CMODEL8087 a_6400_83.t3 vdd.n36 3.36355197696396e-06f
CMODEL8088 a_6400_83.t3 vdd.n37 3.93653000133875e-05f
CMODEL8089 a_6400_83.t3 vdd.n38 2.27077383475191e-05f
CMODEL8090 a_6400_83.t3 vdd.t19 1.96068611631988e-06f
CMODEL8091 a_6400_83.t3 vdd.t18 1.54982078736954e-05f
CMODEL8092 a_6400_83.t3 vdd.n39 1.91621853895178e-05f
CMODEL8093 a_6400_83.t3 vdd.t21 1.96070407576147e-06f
CMODEL8094 a_6400_83.t3 vdd.t20 1.54982078736954e-05f
CMODEL8095 a_6400_83.t3 vdd.n40 1.91621853895178e-05f
CMODEL8096 a_6400_83.t3 vdd.t11 1.96068611631988e-06f
CMODEL8097 a_6400_83.t3 vdd.t10 1.54982078736954e-05f
CMODEL8098 a_6400_83.t3 vdd.n41 8.24392247143815e-05f
CMODEL8099 a_6400_83.t3 vdd.n42 0.000157912161631786f
CMODEL8100 a_6400_83.t3 vdd.n43 1.91621853895178e-05f
CMODEL8101 a_6400_83.t3 vdd.t13 1.96068611631988e-06f
CMODEL8102 a_6400_83.t3 vdd.t12 1.54982078736954e-05f
CMODEL8103 a_6400_83.t3 vdd.n44 1.91621853895178e-05f
CMODEL8104 a_6400_83.t3 vdd.t23 1.96068611631988e-06f
CMODEL8105 a_6400_83.t3 vdd.t22 1.54982078736954e-05f
CMODEL8106 a_6400_83.t3 vdd.n45 2.36549192967896e-05f
CMODEL8107 a_6400_83.t3 vdd.n46 0.000390449035754849f
CMODEL8108 a_6400_83.t2 vdd 7.64801024015743e-07f
CMODEL8109 a_6400_83.t2 vdd.n0 0.000256652991879792f
CMODEL8110 a_6400_83.t2 vdd.n1 2.37842272762122e-05f
CMODEL8111 a_6400_83.t2 vdd.t7 1.96068611631988e-06f
CMODEL8112 a_6400_83.t2 vdd.t6 1.54982078736954e-05f
CMODEL8113 a_6400_83.t2 vdd.n2 2.13282736392622e-05f
CMODEL8114 a_6400_83.t2 vdd.t27 1.96068611631988e-06f
CMODEL8115 a_6400_83.t2 vdd.t26 1.54982078736954e-05f
CMODEL8116 a_6400_83.t2 vdd.n3 4.00039377562025e-05f
CMODEL8117 a_6400_83.t2 vdd.n4 2.13282736392622e-05f
CMODEL8118 a_6400_83.t2 vdd.t36 1.96068611631988e-06f
CMODEL8119 a_6400_83.t2 vdd.t35 1.54982078736954e-05f
CMODEL8120 a_6400_83.t2 vdd.n5 3.04320941738606e-05f
CMODEL8121 a_6400_83.t2 vdd.t3 3.12325464853696e-06f
CMODEL8122 a_6400_83.t2 vdd.n6 2.98818168836511e-05f
CMODEL8123 a_6400_83.t2 vdd.t2 3.91621787290445e-05f
CMODEL8124 a_6400_83.t2 vdd.n7 4.00578160809619e-05f
CMODEL8125 a_6400_83.t2 vdd.t25 3.12325464853696e-06f
CMODEL8126 a_6400_83.t2 vdd.n8 1.80488796055724e-05f
CMODEL8127 a_6400_83.t2 vdd.t24 3.91621787290445e-05f
CMODEL8128 a_6400_83.t2 vdd.n9 4.00578160809619e-05f
CMODEL8129 a_6400_83.t2 vdd.t5 3.12325464853696e-06f
CMODEL8130 a_6400_83.t2 vdd.n10 5.34444246506862e-05f
CMODEL8131 a_6400_83.t2 vdd.t4 3.91837300589483e-05f
CMODEL8132 a_6400_83.t2 vdd.n11 0.000129219618969991f
CMODEL8133 a_6400_83.t2 vdd.n12 0.000318607677520644f
CMODEL8134 a_6400_83.t2 vdd.n13 2.41500611013286e-05f
CMODEL8135 a_6400_83.t2 vdd.t42 1.96068611631988e-06f
CMODEL8136 a_6400_83.t2 vdd.t41 1.54982078736954e-05f
CMODEL8137 a_6400_83.t2 vdd.n14 2.17127852836285e-05f
CMODEL8138 a_6400_83.t2 vdd.t9 1.96068611631988e-06f
CMODEL8139 a_6400_83.t2 vdd.t8 1.54982078736954e-05f
CMODEL8140 a_6400_83.t2 vdd.n15 4.16856598663597e-05f
CMODEL8141 a_6400_83.t2 vdd.t15 3.30198701120553e-06f
CMODEL8142 a_6400_83.t2 vdd.n16 2.59727648279396e-05f
CMODEL8143 a_6400_83.t2 vdd.t14 4.45417498618563e-05f
CMODEL8144 a_6400_83.t2 vdd.n17 3.63822367658746e-05f
CMODEL8145 a_6400_83.t2 vdd.t32 4.45417498618563e-05f
CMODEL8146 a_6400_83.t2 vdd.n18 3.59142137181311e-05f
CMODEL8147 a_6400_83.t2 vdd.t34 3.30198701120553e-06f
CMODEL8148 a_6400_83.t2 vdd.n19 3.61660050891734e-05f
CMODEL8149 a_6400_83.t2 vdd.t33 4.45417498618563e-05f
CMODEL8150 a_6400_83.t2 vdd.n20 7.21745058756335e-05f
CMODEL8151 a_6400_83.t2 vdd.t48 4.46268776149762e-05f
CMODEL8152 a_6400_83.t2 vdd.n21 0.000128117627634246f
CMODEL8153 a_6400_83.t2 vdd.n22 0.000561458838541233f
CMODEL8154 a_6400_83.t2 vdd.t47 6.3477107504137e-07f
CMODEL8155 a_6400_83.t2 vdd.t45 6.28253593689639e-07f
CMODEL8156 a_6400_83.t2 vdd.n23 7.17393486059933e-06f
CMODEL8157 a_6400_83.t2 vdd.t46 1.71209870965658e-05f
CMODEL8158 a_6400_83.t2 vdd.n24 1.83949580449437e-05f
CMODEL8159 a_6400_83.t2 vdd.t44 1.71209870965658e-05f
CMODEL8160 a_6400_83.t2 vdd.n25 2.90106043722913e-05f
CMODEL8161 a_6400_83.t2 vdd.t43 1.71580733434418e-05f
CMODEL8162 a_6400_83.t2 vdd.n26 0.000155223094443044f
CMODEL8163 a_6400_83.t2 vdd.n27 0.00010376983308105f
CMODEL8164 a_6400_83.t2 vdd.n28 2.34397651865837e-05f
CMODEL8165 a_6400_83.t2 vdd.t29 1.96068611631988e-06f
CMODEL8166 a_6400_83.t2 vdd.t28 1.54982078736954e-05f
CMODEL8167 a_6400_83.t2 vdd.n29 3.49896616652595e-06f
CMODEL8168 a_6400_83.t2 vdd.n30 1.11624754047725e-06f
CMODEL8169 a_6400_83.t2 vdd.t38 5.13945339880063e-07f
CMODEL8170 a_6400_83.t2 vdd.t40 5.13945339880063e-07f
CMODEL8171 a_6400_83.t2 vdd.t37 1.03852985295595e-05f
CMODEL8172 a_6400_83.t2 vdd.t39 1.03852985295595e-05f
CMODEL8173 a_6400_83.t2 vdd.n31 3.36355197696396e-06f
CMODEL8174 a_6400_83.t2 vdd.n32 4.05910319016642e-05f
CMODEL8175 a_6400_83.t2 vdd.n33 2.05675116936592e-05f
CMODEL8176 a_6400_83.t2 vdd.t17 1.96068611631988e-06f
CMODEL8177 a_6400_83.t2 vdd.t16 1.54982078736954e-05f
CMODEL8178 a_6400_83.t2 vdd.n34 3.49896616652595e-06f
CMODEL8179 a_6400_83.t2 vdd.n35 1.11624754047725e-06f
CMODEL8180 a_6400_83.t2 vdd.t1 5.13945339880063e-07f
CMODEL8181 a_6400_83.t2 vdd.t31 5.13945339880063e-07f
CMODEL8182 a_6400_83.t2 vdd.t0 1.03852985295595e-05f
CMODEL8183 a_6400_83.t2 vdd.t30 1.03852985295595e-05f
CMODEL8184 a_6400_83.t2 vdd.n36 3.36355197696396e-06f
CMODEL8185 a_6400_83.t2 vdd.n37 3.93653000133875e-05f
CMODEL8186 a_6400_83.t2 vdd.n38 2.27077383475191e-05f
CMODEL8187 a_6400_83.t2 vdd.t19 1.96068611631988e-06f
CMODEL8188 a_6400_83.t2 vdd.t18 1.54982078736954e-05f
CMODEL8189 a_6400_83.t2 vdd.n39 1.91621853895178e-05f
CMODEL8190 a_6400_83.t2 vdd.t21 1.96070407576147e-06f
CMODEL8191 a_6400_83.t2 vdd.t20 1.54982078736954e-05f
CMODEL8192 a_6400_83.t2 vdd.n40 1.91621853895178e-05f
CMODEL8193 a_6400_83.t2 vdd.t11 1.96068611631988e-06f
CMODEL8194 a_6400_83.t2 vdd.t10 1.54982078736954e-05f
CMODEL8195 a_6400_83.t2 vdd.n41 8.24392247143815e-05f
CMODEL8196 a_6400_83.t2 vdd.n42 0.000157912161631786f
CMODEL8197 a_6400_83.t2 vdd.n43 1.91621853895178e-05f
CMODEL8198 a_6400_83.t2 vdd.t13 1.96068611631988e-06f
CMODEL8199 a_6400_83.t2 vdd.t12 1.54982078736954e-05f
CMODEL8200 a_6400_83.t2 vdd.n44 1.91621853895178e-05f
CMODEL8201 a_6400_83.t2 vdd.t23 1.96068611631988e-06f
CMODEL8202 a_6400_83.t2 vdd.t22 1.54982078736954e-05f
CMODEL8203 a_6400_83.t2 vdd.n45 2.36549192967896e-05f
CMODEL8204 a_6400_83.t2 vdd.n46 0.000390449035754849f
CMODEL8205 a_6400_83.n1 vdd 0.000281641005475083f
CMODEL8206 a_6400_83.n1 vdd.n0 0.0945134805281396f
CMODEL8207 a_6400_83.n1 vdd.n1 0.00875863587282856f
CMODEL8208 a_6400_83.n1 vdd.t7 0.000722030426060206f
CMODEL8209 a_6400_83.n1 vdd.t6 0.0057072764177151f
CMODEL8210 a_6400_83.n1 vdd.n2 0.00785422122118637f
CMODEL8211 a_6400_83.n1 vdd.t27 0.000722030426060206f
CMODEL8212 a_6400_83.n1 vdd.t26 0.0057072764177151f
CMODEL8213 a_6400_83.n1 vdd.n3 0.0147316084822444f
CMODEL8214 a_6400_83.n1 vdd.n4 0.00785422122118637f
CMODEL8215 a_6400_83.n1 vdd.t36 0.000722030426060206f
CMODEL8216 a_6400_83.n1 vdd.t35 0.0057072764177151f
CMODEL8217 a_6400_83.n1 vdd.n5 0.0112067391814346f
CMODEL8218 a_6400_83.n1 vdd.t3 0.00115015089146974f
CMODEL8219 a_6400_83.n1 vdd.n6 0.0110040973903829f
CMODEL8220 a_6400_83.n1 vdd.t2 0.0144216273873817f
CMODEL8221 a_6400_83.n1 vdd.n7 0.0147514493886789f
CMODEL8222 a_6400_83.n1 vdd.t25 0.00115015089146974f
CMODEL8223 a_6400_83.n1 vdd.n8 0.00664657138286926f
CMODEL8224 a_6400_83.n1 vdd.t24 0.0144216273873817f
CMODEL8225 a_6400_83.n1 vdd.n9 0.0147514493886789f
CMODEL8226 a_6400_83.n1 vdd.t5 0.00115015089146974f
CMODEL8227 a_6400_83.n1 vdd.n10 0.0196811210014106f
CMODEL8228 a_6400_83.n1 vdd.t4 0.0144295637499555f
CMODEL8229 a_6400_83.n1 vdd.n11 0.0475856363564001f
CMODEL8230 a_6400_83.n1 vdd.n12 0.117328538837244f
CMODEL8231 a_6400_83.n1 vdd.n13 0.00889335562751925f
CMODEL8232 a_6400_83.n1 vdd.t42 0.000722030426060206f
CMODEL8233 a_6400_83.n1 vdd.t41 0.0057072764177151f
CMODEL8234 a_6400_83.n1 vdd.n14 0.00799581915677437f
CMODEL8235 a_6400_83.n1 vdd.t9 0.000722030426060206f
CMODEL8236 a_6400_83.n1 vdd.t8 0.0057072764177151f
CMODEL8237 a_6400_83.n1 vdd.n15 0.0153509093084219f
CMODEL8238 a_6400_83.n1 vdd.t15 0.00121596979174867f
CMODEL8239 a_6400_83.n1 vdd.n16 0.00956457349220054f
CMODEL8240 a_6400_83.n1 vdd.t14 0.0164026757585181f
CMODEL8241 a_6400_83.n1 vdd.n17 0.013397902751713f
CMODEL8242 a_6400_83.n1 vdd.t32 0.0164026757585181f
CMODEL8243 a_6400_83.n1 vdd.n18 0.0132255514111514f
CMODEL8244 a_6400_83.n1 vdd.t34 0.00121596979174867f
CMODEL8245 a_6400_83.n1 vdd.n19 0.0133182745805556f
CMODEL8246 a_6400_83.n1 vdd.t33 0.0164026757585181f
CMODEL8247 a_6400_83.n1 vdd.n20 0.0265785475779676f
CMODEL8248 a_6400_83.n1 vdd.t48 0.0164340243906847f
CMODEL8249 a_6400_83.n1 vdd.n21 0.0471798236834585f
CMODEL8250 a_6400_83.n1 vdd.n22 0.206759440500396f
CMODEL8251 a_6400_83.n1 vdd.t47 0.000233756961885907f
CMODEL8252 a_6400_83.n1 vdd.t45 0.000231356873570873f
CMODEL8253 a_6400_83.n1 vdd.n23 0.00264182991903311f
CMODEL8254 a_6400_83.n1 vdd.t46 0.0063048712922532f
CMODEL8255 a_6400_83.n1 vdd.n24 0.00677401613853394f
CMODEL8256 a_6400_83.n1 vdd.t44 0.0063048712922532f
CMODEL8257 a_6400_83.n1 vdd.n25 0.010683269933336f
CMODEL8258 a_6400_83.n1 vdd.t43 0.00631852844951566f
CMODEL8259 a_6400_83.n1 vdd.n26 0.0571615191652683f
CMODEL8260 a_6400_83.n1 vdd.n27 0.0382136519293244f
CMODEL8261 a_6400_83.n1 vdd.n28 0.00863178634435692f
CMODEL8262 a_6400_83.n1 vdd.t29 0.000722030426060206f
CMODEL8263 a_6400_83.n1 vdd.t28 0.0057072764177151f
CMODEL8264 a_6400_83.n1 vdd.n29 0.00128850814567343f
CMODEL8265 a_6400_83.n1 vdd.n30 0.000411062576784194f
CMODEL8266 a_6400_83.n1 vdd.t38 0.000189262406479303f
CMODEL8267 a_6400_83.n1 vdd.t40 0.000189262406479303f
CMODEL8268 a_6400_83.n1 vdd.t37 0.00382442730615884f
CMODEL8269 a_6400_83.n1 vdd.t39 0.00382442730615884f
CMODEL8270 a_6400_83.n1 vdd.n31 0.0012386413341679f
CMODEL8271 a_6400_83.n1 vdd.n32 0.0149478082260263f
CMODEL8272 a_6400_83.n1 vdd.n33 0.00757406762233033f
CMODEL8273 a_6400_83.n1 vdd.t17 0.000722030426060206f
CMODEL8274 a_6400_83.n1 vdd.t16 0.0057072764177151f
CMODEL8275 a_6400_83.n1 vdd.n34 0.00128850814567343f
CMODEL8276 a_6400_83.n1 vdd.n35 0.000411062576784194f
CMODEL8277 a_6400_83.n1 vdd.t1 0.000189262406479303f
CMODEL8278 a_6400_83.n1 vdd.t31 0.000189262406479303f
CMODEL8279 a_6400_83.n1 vdd.t0 0.00382442730615884f
CMODEL8280 a_6400_83.n1 vdd.t30 0.00382442730615884f
CMODEL8281 a_6400_83.n1 vdd.n36 0.0012386413341679f
CMODEL8282 a_6400_83.n1 vdd.n37 0.01449642760464f
CMODEL8283 a_6400_83.n1 vdd.n38 0.00836221456226598f
CMODEL8284 a_6400_83.n1 vdd.t19 0.000722030426060206f
CMODEL8285 a_6400_83.n1 vdd.t18 0.0057072764177151f
CMODEL8286 a_6400_83.n1 vdd.n39 0.00705655064616213f
CMODEL8287 a_6400_83.n1 vdd.t21 0.000722037039695684f
CMODEL8288 a_6400_83.n1 vdd.t20 0.0057072764177151f
CMODEL8289 a_6400_83.n1 vdd.n40 0.00705655064616213f
CMODEL8290 a_6400_83.n1 vdd.t11 0.000722030426060206f
CMODEL8291 a_6400_83.n1 vdd.t10 0.0057072764177151f
CMODEL8292 a_6400_83.n1 vdd.n41 0.0303585709355258f
CMODEL8293 a_6400_83.n1 vdd.n42 0.0581517788054174f
CMODEL8294 a_6400_83.n1 vdd.n43 0.00705655064616213f
CMODEL8295 a_6400_83.n1 vdd.t13 0.000722030426060206f
CMODEL8296 a_6400_83.n1 vdd.t12 0.0057072764177151f
CMODEL8297 a_6400_83.n1 vdd.n44 0.00705655064616213f
CMODEL8298 a_6400_83.n1 vdd.t23 0.000722030426060206f
CMODEL8299 a_6400_83.n1 vdd.t22 0.0057072764177151f
CMODEL8300 a_6400_83.n1 vdd.n45 0.00871101769738561f
CMODEL8301 a_6400_83.n1 vdd.n46 0.143784403477091f
CMODEL8302 a_3200_169.t2 en 0.000141419669757108f
CMODEL8303 a_3200_169.t2 en.t3 0.00107231141128585f
CMODEL8304 a_3200_169.t2 en.t1 0.000965192267061389f
CMODEL8305 a_3200_169.t2 en.n0 0.0385714390529615f
CMODEL8306 a_3200_169.t2 en.t0 0.00131998667019085f
CMODEL8307 a_3200_169.t2 en.t2 0.000965192267061389f
CMODEL8308 a_3200_169.n0 en 0.00254131322115724f
CMODEL8309 a_3200_169.n0 en.t3 0.0192694493727704f
CMODEL8310 a_3200_169.n0 en.t1 0.0173445170212509f
CMODEL8311 a_3200_169.n0 en.n0 0.693129238617989f
CMODEL8312 a_3200_169.n0 en.t0 0.0237201768500008f
CMODEL8313 a_3200_169.n0 en.t2 0.0173445170212509f
CMODEL8314 a_3200_169.t1 en 0.000206458989456898f
CMODEL8315 a_3200_169.t1 en.t3 0.00156547056528569f
CMODEL8316 a_3200_169.t1 en.t1 0.00140908701336499f
CMODEL8317 a_3200_169.t1 en.n0 0.0563105566746842f
CMODEL8318 a_3200_169.t1 en.t0 0.00192705240008156f
CMODEL8319 a_3200_169.t1 en.t2 0.00140908701336499f
CMODEL8320 a_3200_169.t3 en 0.000409509625861924f
CMODEL8321 a_3200_169.t3 en.t3 0.00310509737151374f
CMODEL8322 a_3200_169.t3 en.t1 0.00279491194434262f
CMODEL8323 a_3200_169.t3 en.n0 0.111691503753779f
CMODEL8324 a_3200_169.t3 en.t0 0.00382229182390952f
CMODEL8325 a_3200_169.t3 en.t2 0.00279491194434262f
CMODEL8326 a_3200_169.t4 en 9.17830550987863e-05f
CMODEL8327 a_3200_169.t4 en.t3 0.000695942915961725f
CMODEL8328 a_3200_169.t4 en.t1 0.000626421311694268f
CMODEL8329 a_3200_169.t4 en.n0 0.0250333247271602f
CMODEL8330 a_3200_169.t4 en.t0 0.000856687117767083f
CMODEL8331 a_3200_169.t4 en.t2 0.000626421311694268f
CMODEL8332 a_3200_169.t0 en 0.000229559809191628f
CMODEL8333 a_3200_169.t0 en.t3 0.00174063200254653f
CMODEL8334 a_3200_169.t0 en.t1 0.00156675060152805f
CMODEL8335 a_3200_169.t0 en.n0 0.0626111785188871f
CMODEL8336 a_3200_169.t0 en.t0 0.00214267144496194f
CMODEL8337 a_3200_169.t0 en.t2 0.00156675060152805f
CMODEL8338 a_3200_169.n1 en 0.000207554814176763f
CMODEL8339 a_3200_169.n1 en.t3 0.00157377963115962f
CMODEL8340 a_3200_169.n1 en.t1 0.00141656604048678f
CMODEL8341 a_3200_169.n1 en.n0 0.0566094368549845f
CMODEL8342 a_3200_169.n1 en.t0 0.00193728063796086f
CMODEL8343 a_3200_169.n1 en.t2 0.00141656604048678f
CMODEL8344 a_1600_n11917.t5 a_19896_16041.t2 4.9737230272231e-06f
CMODEL8345 a_1600_n11917.t5 a_19896_16041.t1 2.35485528851817e-06f
CMODEL8346 a_1600_n11917.t5 a_19896_16041.n0 7.05501614245575e-06f
CMODEL8347 a_1600_n11917.t5 a_19896_16041.t4 2.35105841065963e-06f
CMODEL8348 a_1600_n11917.t5 a_19896_16041.t3 2.19991678408597e-06f
CMODEL8349 a_1600_n11917.t5 a_19896_16041.t0 2.21228540135244e-06f
CMODEL8350 a_1600_n11917.t5 a_19896_16041.n1 6.68181468960964e-05f
CMODEL8351 a_1600_n11917.t4 a_19896_16041.t2 7.90586463470272e-06f
CMODEL8352 a_1600_n11917.t4 a_19896_16041.t1 3.74310492229655e-06f
CMODEL8353 a_1600_n11917.t4 a_19896_16041.n0 1.12141352288043e-05f
CMODEL8354 a_1600_n11917.t4 a_19896_16041.t4 3.73706968426262e-06f
CMODEL8355 a_1600_n11917.t4 a_19896_16041.t3 3.49682606116179e-06f
CMODEL8356 a_1600_n11917.t4 a_19896_16041.t0 3.51648630627233e-06f
CMODEL8357 a_1600_n11917.t4 a_19896_16041.n1 0.000106209216237188f
CMODEL8358 a_1600_n11917.n0 a_19896_16041.t2 0.000137632136313088f
CMODEL8359 a_1600_n11917.n0 a_19896_16041.t1 6.51632111987307e-05f
CMODEL8360 a_1600_n11917.n0 a_19896_16041.n0 0.000195225375055037f
CMODEL8361 a_1600_n11917.n0 a_19896_16041.t4 6.50581445498379e-05f
CMODEL8362 a_1600_n11917.n0 a_19896_16041.t3 6.08757755603887e-05f
CMODEL8363 a_1600_n11917.n0 a_19896_16041.t0 6.12180381287517e-05f
CMODEL8364 a_1600_n11917.n0 a_19896_16041.n1 0.00184898199024281f
CMODEL8365 a_1600_n11917.t6 a_19896_16041.t2 1.45952903263809e-05f
CMODEL8366 a_1600_n11917.t6 a_19896_16041.t1 6.91027554699309e-06f
CMODEL8367 a_1600_n11917.t6 a_19896_16041.n0 2.07028031703517e-05f
CMODEL8368 a_1600_n11917.t6 a_19896_16041.t4 6.89913368517732e-06f
CMODEL8369 a_1600_n11917.t6 a_19896_16041.t3 6.45561161766975e-06f
CMODEL8370 a_1600_n11917.t6 a_19896_16041.t0 6.49190707661509e-06f
CMODEL8371 a_1600_n11917.t6 a_19896_16041.n1 0.000196076510027093f
CMODEL8372 a_1600_n11917.n1 a_19896_16041.t2 0.000810831430330409f
CMODEL8373 a_1600_n11917.n1 a_19896_16041.t1 0.000383895659520944f
CMODEL8374 a_1600_n11917.n1 a_19896_16041.n0 0.00115013015370607f
CMODEL8375 a_1600_n11917.n1 a_19896_16041.t4 0.000383276680963436f
CMODEL8376 a_1600_n11917.n1 a_19896_16041.t3 0.000358637114066282f
CMODEL8377 a_1600_n11917.n1 a_19896_16041.t0 0.000360653483609678f
CMODEL8378 a_1600_n11917.n1 a_19896_16041.n1 0.0108928971965771f
CMODEL8379 a_1600_n11917.t2 a_19896_16041.t2 1.01943927497566e-06f
CMODEL8380 a_1600_n11917.t2 a_19896_16041.t1 4.82662977986508e-07f
CMODEL8381 a_1600_n11917.t2 a_19896_16041.n0 1.44603157470595e-06f
CMODEL8382 a_1600_n11917.t2 a_19896_16041.t4 4.81884750813402e-07f
CMODEL8383 a_1600_n11917.t2 a_19896_16041.t3 4.50906003229439e-07f
CMODEL8384 a_1600_n11917.t2 a_19896_16041.t0 4.53441137202434e-07f
CMODEL8385 a_1600_n11917.t2 a_19896_16041.n1 1.36953832881612e-05f
CMODEL8386 a_1600_n11917.t3 a_19896_16041.t2 1.01943927497566e-06f
CMODEL8387 a_1600_n11917.t3 a_19896_16041.t1 4.82662977986508e-07f
CMODEL8388 a_1600_n11917.t3 a_19896_16041.n0 1.44603157470595e-06f
CMODEL8389 a_1600_n11917.t3 a_19896_16041.t4 4.81884750813402e-07f
CMODEL8390 a_1600_n11917.t3 a_19896_16041.t3 4.50906003229439e-07f
CMODEL8391 a_1600_n11917.t3 a_19896_16041.t0 4.53441137202434e-07f
CMODEL8392 a_1600_n11917.t3 a_19896_16041.n1 1.36953832881612e-05f
CMODEL8393 a_1600_n11917.n2 a_19896_16041.t2 0.000247295471739936f
CMODEL8394 a_1600_n11917.n2 a_19896_16041.t1 0.000117084334263486f
CMODEL8395 a_1600_n11917.n2 a_19896_16041.n0 0.00035077818678929f
CMODEL8396 a_1600_n11917.n2 a_19896_16041.t4 0.000116895551997962f
CMODEL8397 a_1600_n11917.n2 a_19896_16041.t3 0.000109380730678299f
CMODEL8398 a_1600_n11917.n2 a_19896_16041.t0 0.00010999570320993f
CMODEL8399 a_1600_n11917.n2 a_19896_16041.n1 0.00332222463273834f
CMODEL8400 a_1600_n11917.t1 a_19896_16041.t2 3.601573998029e-06f
CMODEL8401 a_1600_n11917.t1 a_19896_16041.t1 1.70519860672324e-06f
CMODEL8402 a_1600_n11917.t1 a_19896_16041.n0 5.10868067145463e-06f
CMODEL8403 a_1600_n11917.t1 a_19896_16041.t4 1.70244921024616e-06f
CMODEL8404 a_1600_n11917.t1 a_19896_16041.t3 1.59300448457324e-06f
CMODEL8405 a_1600_n11917.t1 a_19896_16041.t0 1.60196085188495e-06f
CMODEL8406 a_1600_n11917.t1 a_19896_16041.n1 4.83843790939483e-05f
CMODEL8407 a_1600_n11917.t0 a_19896_16041.t2 4.95020569944649e-06f
CMODEL8408 a_1600_n11917.t0 a_19896_16041.t1 2.34372079160641e-06f
CMODEL8409 a_1600_n11917.t0 a_19896_16041.n0 7.02165780581672e-06f
CMODEL8410 a_1600_n11917.t0 a_19896_16041.t4 2.33994186658132e-06f
CMODEL8411 a_1600_n11917.t0 a_19896_16041.t3 2.1895148851846e-06f
CMODEL8412 a_1600_n11917.t0 a_19896_16041.t0 2.20182501973605e-06f
CMODEL8413 a_1600_n11917.t0 a_19896_16041.n1 6.65022096689166e-05f
CMODEL8414 a_1600_n11917.n3 a_19896_16041.t2 0.000686186642383187f
CMODEL8415 a_1600_n11917.n3 a_19896_16041.t1 0.000324881428837572f
CMODEL8416 a_1600_n11917.n3 a_19896_16041.n0 0.000973326784031585f
CMODEL8417 a_1600_n11917.n3 a_19896_16041.t4 0.000324357602549893f
CMODEL8418 a_1600_n11917.n3 a_19896_16041.t3 0.000303505744757399f
CMODEL8419 a_1600_n11917.n3 a_19896_16041.t0 0.000305212148573323f
CMODEL8420 a_1600_n11917.n3 a_19896_16041.n1 0.00921839025171805f
CMODEL8421 a_1600_n11917.n4 a_19896_16041.t2 0.00100605770891959f
CMODEL8422 a_1600_n11917.n4 a_19896_16041.t1 0.000476327351450144f
CMODEL8423 a_1600_n11917.n4 a_19896_16041.n0 0.00142705038817421f
CMODEL8424 a_1600_n11917.n4 a_19896_16041.t4 0.000475559339596949f
CMODEL8425 a_1600_n11917.n4 a_19896_16041.t3 0.000444987231395345f
CMODEL8426 a_1600_n11917.n4 a_19896_16041.t0 0.000447489088189843f
CMODEL8427 a_1600_n11917.n4 a_19896_16041.n1 0.0135156122310395f
CMODEL8428 a_3200_n35917.t1 dout 0.0304840724523237f
CMODEL8429 a_3200_n35917.t1 dout.n0 0.0130707724408505f
CMODEL8430 a_3200_n35917.t1 dout.t0 0.00219112070694105f
CMODEL8431 a_3200_n35917.t1 dout.t1 0.00965148079348465f
CMODEL8432 a_3200_n35917.n0 dout 0.395418028084149f
CMODEL8433 a_3200_n35917.n0 dout.n0 0.16954490159348f
CMODEL8434 a_3200_n35917.n0 dout.t0 0.0284216825225048f
CMODEL8435 a_3200_n35917.n0 dout.t1 0.125192246194154f
CMODEL8436 a_3200_n35917.t0 dout 0.0069206268458681f
CMODEL8437 a_3200_n35917.t0 dout.n0 0.00296738366541599f
CMODEL8438 a_3200_n35917.t0 dout.t0 0.000497437762317017f
CMODEL8439 a_3200_n35917.t0 dout.t1 0.00219112118914672f
CMODEL8440 a_3200_n35917.t3 dout 0.0509397252263013f
CMODEL8441 a_3200_n35917.t3 dout.n0 0.0218416209866238f
CMODEL8442 a_3200_n35917.t3 dout.t0 0.00366142308983812f
CMODEL8443 a_3200_n35917.t3 dout.t1 0.0161278904062425f
CMODEL8444 a_3200_n35917.t2 dout 0.0116381150589772f
CMODEL8445 a_3200_n35917.t2 dout.n0 0.00499011914547301f
CMODEL8446 a_3200_n35917.t2 dout.t0 0.000836519298245655f
CMODEL8447 a_3200_n35917.t2 dout.t1 0.00368471253766231f
CMODEL8448 a_12800_83.t1 a_19896_16041.t2 3.73233476532254e-06f
CMODEL8449 a_12800_83.t1 a_19896_16041.t1 1.76710850454154e-06f
CMODEL8450 a_12800_83.t1 a_19896_16041.n0 5.29415929963851e-06f
CMODEL8451 a_12800_83.t1 a_19896_16041.t4 1.7642592869326e-06f
CMODEL8452 a_12800_83.t1 a_19896_16041.t3 1.65084099961329e-06f
CMODEL8453 a_12800_83.t1 a_19896_16041.t0 1.66012254182422e-06f
CMODEL8454 a_12800_83.t1 a_19896_16041.n1 5.01410495216027e-05f
CMODEL8455 a_12800_83.n0 a_19896_16041.t2 5.19760023867295e-05f
CMODEL8456 a_12800_83.n0 a_19896_16041.t1 2.46085203029004e-05f
CMODEL8457 a_12800_83.n0 a_19896_16041.n0 7.37257651565339e-05f
CMODEL8458 a_12800_83.n0 a_19896_16041.t4 2.45688424737255e-05f
CMODEL8459 a_12800_83.n0 a_19896_16041.t3 2.29893943419077e-05f
CMODEL8460 a_12800_83.n0 a_19896_16041.t0 2.31186478763414e-05f
CMODEL8461 a_12800_83.n0 a_19896_16041.n1 0.000698257651972097f
CMODEL8462 a_12800_83.t0 a_19896_16041.t2 8.47332219837479e-07f
CMODEL8463 a_12800_83.t0 a_19896_16041.t1 4.01177296784489e-07f
CMODEL8464 a_12800_83.t0 a_19896_16041.n0 1.20190498269741e-06f
CMODEL8465 a_12800_83.t0 a_19896_16041.t4 4.00530453981478e-07f
CMODEL8466 a_12800_83.t0 a_19896_16041.t3 3.74781700129777e-07f
CMODEL8467 a_12800_83.t0 a_19896_16041.t0 3.7688883956383e-07f
CMODEL8468 a_12800_83.t0 a_19896_16041.n1 1.13832572551806e-05f
CMODEL8469 a_12800_83.t2 a_19896_16041.t2 8.35668366104767e-07f
CMODEL8470 a_12800_83.t2 a_19896_16041.t1 3.95654937075948e-07f
CMODEL8471 a_12800_83.t2 a_19896_16041.n0 1.18536029858108e-06f
CMODEL8472 a_12800_83.t2 a_19896_16041.t4 3.95016998312776e-07f
CMODEL8473 a_12800_83.t2 a_19896_16041.t3 3.69622685956034e-07f
CMODEL8474 a_12800_83.t2 a_19896_16041.t0 3.71700819805763e-07f
CMODEL8475 a_12800_83.t2 a_19896_16041.n1 1.12265623431758e-05f
CMODEL8476 a_12800_83.t3 a_19896_16041.t2 8.35668366104767e-07f
CMODEL8477 a_12800_83.t3 a_19896_16041.t1 3.95654937075948e-07f
CMODEL8478 a_12800_83.t3 a_19896_16041.n0 1.18536029858108e-06f
CMODEL8479 a_12800_83.t3 a_19896_16041.t4 3.95016998312776e-07f
CMODEL8480 a_12800_83.t3 a_19896_16041.t3 3.69622685956034e-07f
CMODEL8481 a_12800_83.t3 a_19896_16041.t0 3.71700819805763e-07f
CMODEL8482 a_12800_83.t3 a_19896_16041.n1 1.12265623431758e-05f
CMODEL8483 a_12800_83.n1 a_19896_16041.t2 0.000351160740670982f
CMODEL8484 a_12800_83.n1 a_19896_16041.t1 0.000166260308980396f
CMODEL8485 a_12800_83.n1 a_19896_16041.n0 0.000498106685971553f
CMODEL8486 a_12800_83.n1 a_19896_16041.t4 0.000165992237269577f
CMODEL8487 a_12800_83.n1 a_19896_16041.t3 0.000155321155417347f
CMODEL8488 a_12800_83.n1 a_19896_16041.t0 0.0001561944193238f
CMODEL8489 a_12800_83.n1 a_19896_16041.n1 0.00471757470729043f
CMODEL8490 a_1600_n11917.t5 a_20000_14483.t0 1.87050692105397e-08f
CMODEL8491 a_1600_n11917.t5 a_20000_14483.t1 8.85609848325337e-09f
CMODEL8492 a_1600_n11917.t5 a_20000_14483.n0 2.40385846197307e-08f
CMODEL8493 a_1600_n11917.t5 a_20000_14483.t2 8.029145822884e-09f
CMODEL8494 a_1600_n11917.t5 a_20000_14483.t3 8.45829671346567e-09f
CMODEL8495 a_1600_n11917.t5 a_20000_14483.t4 8.27341006749048e-09f
CMODEL8496 a_1600_n11917.t5 a_20000_14483.n1 2.10852385433527e-07f
CMODEL8497 a_1600_n11917.t4 a_20000_14483.t0 2.97322034926091e-08f
CMODEL8498 a_1600_n11917.t4 a_20000_14483.t1 1.40770033668899e-08f
CMODEL8499 a_1600_n11917.t4 a_20000_14483.n0 3.82099676586823e-08f
CMODEL8500 a_1600_n11917.t4 a_20000_14483.t2 1.27625401858073e-08f
CMODEL8501 a_1600_n11917.t4 a_20000_14483.t3 1.34446869057253e-08f
CMODEL8502 a_1600_n11917.t4 a_20000_14483.t4 1.31508046795048e-08f
CMODEL8503 a_1600_n11917.t4 a_20000_14483.n1 3.35155457595378e-07f
CMODEL8504 a_1600_n11917.n0 a_20000_14483.t0 5.17603939994238e-07f
CMODEL8505 a_1600_n11917.n0 a_20000_14483.t1 2.45064662221406e-07f
CMODEL8506 a_1600_n11917.n0 a_20000_14483.n0 6.65192198489518e-07f
CMODEL8507 a_1600_n11917.n0 a_20000_14483.t2 2.22181349127076e-07f
CMODEL8508 a_1600_n11917.n0 a_20000_14483.t3 2.34056749817491e-07f
CMODEL8509 a_1600_n11917.n0 a_20000_14483.t4 2.2894059358562e-07f
CMODEL8510 a_1600_n11917.n0 a_20000_14483.n1 5.83467637725079e-06f
CMODEL8511 a_1600_n11917.t6 a_20000_14483.t0 5.48896499078476e-08f
CMODEL8512 a_1600_n11917.t6 a_20000_14483.t1 2.59880431247638e-08f
CMODEL8513 a_1600_n11917.t6 a_20000_14483.n0 7.05407437526994e-08f
CMODEL8514 a_1600_n11917.t6 a_20000_14483.t2 2.35613671522172e-08f
CMODEL8515 a_1600_n11917.t6 a_20000_14483.t3 2.48207018211526e-08f
CMODEL8516 a_1600_n11917.t6 a_20000_14483.t4 2.42781556719785e-08f
CMODEL8517 a_1600_n11917.t6 a_20000_14483.n1 6.18742090093923e-07f
CMODEL8518 a_1600_n11917.n1 a_20000_14483.t0 3.04935717960133e-06f
CMODEL8519 a_1600_n11917.n1 a_20000_14483.t1 1.44374806578895e-06f
CMODEL8520 a_1600_n11917.n1 a_20000_14483.n0 3.91884305652964e-06f
CMODEL8521 a_1600_n11917.n1 a_20000_14483.t2 1.30893573209991e-06f
CMODEL8522 a_1600_n11917.n1 a_20000_14483.t3 1.37889721337528e-06f
CMODEL8523 a_1600_n11917.n1 a_20000_14483.t4 1.34875643095042e-06f
CMODEL8524 a_1600_n11917.n1 a_20000_14483.n1 3.43737961148789e-05f
CMODEL8525 a_1600_n11917.t2 a_20000_14483.t0 3.8338850173184e-09f
CMODEL8526 a_1600_n11917.t2 a_20000_14483.t1 1.81519046546536e-09f
CMODEL8527 a_1600_n11917.t2 a_20000_14483.n0 4.9270691476082e-09f
CMODEL8528 a_1600_n11917.t2 a_20000_14483.t2 1.6456940910368e-09f
CMODEL8529 a_1600_n11917.t2 a_20000_14483.t3 1.73365501494736e-09f
CMODEL8530 a_1600_n11917.t2 a_20000_14483.t4 1.69575971854786e-09f
CMODEL8531 a_1600_n11917.t2 a_20000_14483.n1 4.32173648907936e-08f
CMODEL8532 a_1600_n11917.t3 a_20000_14483.t0 3.8338850173184e-09f
CMODEL8533 a_1600_n11917.t3 a_20000_14483.t1 1.81519046546536e-09f
CMODEL8534 a_1600_n11917.t3 a_20000_14483.n0 4.9270691476082e-09f
CMODEL8535 a_1600_n11917.t3 a_20000_14483.t2 1.6456940910368e-09f
CMODEL8536 a_1600_n11917.t3 a_20000_14483.t3 1.73365501494736e-09f
CMODEL8537 a_1600_n11917.t3 a_20000_14483.t4 1.69575971854786e-09f
CMODEL8538 a_1600_n11917.t3 a_20000_14483.n1 4.32173648907936e-08f
CMODEL8539 a_1600_n11917.n2 a_20000_14483.t0 9.30023422902813e-07f
CMODEL8540 a_1600_n11917.n2 a_20000_14483.t1 4.40328711551561e-07f
CMODEL8541 a_1600_n11917.n2 a_20000_14483.n0 1.1952079138624e-06f
CMODEL8542 a_1600_n11917.n2 a_20000_14483.t2 3.99212298930005e-07f
CMODEL8543 a_1600_n11917.n2 a_20000_14483.t3 4.20549850569518e-07f
CMODEL8544 a_1600_n11917.n2 a_20000_14483.t4 4.11357213568101e-07f
CMODEL8545 a_1600_n11917.n2 a_20000_14483.n1 1.04836638143855e-05f
CMODEL8546 a_1600_n11917.t1 a_20000_14483.t0 1.35447210331744e-08f
CMODEL8547 a_1600_n11917.t1 a_20000_14483.t1 6.41288102427315e-09f
CMODEL8548 a_1600_n11917.t1 a_20000_14483.n0 1.74068280123308e-08f
CMODEL8549 a_1600_n11917.t1 a_20000_14483.t2 5.81406778459621e-09f
CMODEL8550 a_1600_n11917.t1 a_20000_14483.t3 6.12482467240242e-09f
CMODEL8551 a_1600_n11917.t1 a_20000_14483.t4 5.99094449188525e-09f
CMODEL8552 a_1600_n11917.t1 a_20000_14483.n1 1.52682500542006e-07f
CMODEL8553 a_1600_n11917.t0 a_20000_14483.t0 1.86166257565515e-08f
CMODEL8554 a_1600_n11917.t0 a_20000_14483.t1 8.81422406247992e-09f
CMODEL8555 a_1600_n11917.t0 a_20000_14483.n0 2.3924922626352e-08f
CMODEL8556 a_1600_n11917.t0 a_20000_14483.t2 7.99118149454295e-09f
CMODEL8557 a_1600_n11917.t0 a_20000_14483.t3 8.41830322465385e-09f
CMODEL8558 a_1600_n11917.t0 a_20000_14483.t4 8.23429078092738e-09f
CMODEL8559 a_1600_n11917.t0 a_20000_14483.n1 2.09855408996846e-07f
CMODEL8560 a_1600_n11917.n3 a_20000_14483.t0 2.5805957764181e-06f
CMODEL8561 a_1600_n11917.n3 a_20000_14483.t1 1.22180838168452e-06f
CMODEL8562 a_1600_n11917.n3 a_20000_14483.n0 3.31642023039359e-06f
CMODEL8563 a_1600_n11917.n3 a_20000_14483.t2 1.10772002848856e-06f
CMODEL8564 a_1600_n11917.n3 a_20000_14483.t3 1.166926704669e-06f
CMODEL8565 a_1600_n11917.n3 a_20000_14483.t4 1.14141930384897e-06f
CMODEL8566 a_1600_n11917.n3 a_20000_14483.n1 2.9089695909323e-05f
CMODEL8567 a_1600_n11917.n4 a_20000_14483.t0 3.78355991520591e-06f
CMODEL8568 a_1600_n11917.n4 a_20000_14483.t1 1.79136355226491e-06f
CMODEL8569 a_1600_n11917.n4 a_20000_14483.n0 4.86239447508969e-06f
CMODEL8570 a_1600_n11917.n4 a_20000_14483.t2 1.62409205477248e-06f
CMODEL8571 a_1600_n11917.n4 a_20000_14483.t3 1.71089836855318e-06f
CMODEL8572 a_1600_n11917.n4 a_20000_14483.t4 1.67350050091126e-06f
CMODEL8573 a_1600_n11917.n4 a_20000_14483.n1 4.26500765419419e-05f
CMODEL8574 a_3200_169.t2 a_3200_83.t0 0.000398499403027665f
CMODEL8575 a_3200_169.t2 a_3200_83.t1 0.000398499403027665f
CMODEL8576 a_3200_169.n0 a_3200_83.t0 0.00716103921948645f
CMODEL8577 a_3200_169.n0 a_3200_83.t1 0.00716103921948645f
CMODEL8578 a_3200_169.t1 a_3200_83.t0 0.000581770443882213f
CMODEL8579 a_3200_169.t1 a_3200_83.t1 0.000581770443882213f
CMODEL8580 a_3200_169.t3 a_3200_83.t0 0.0011539366604401f
CMODEL8581 a_3200_169.t3 a_3200_83.t1 0.0011539366604401f
CMODEL8582 a_3200_169.t4 a_3200_83.t0 0.000258630873115041f
CMODEL8583 a_3200_169.t4 a_3200_83.t1 0.000258630873115041f
CMODEL8584 a_3200_169.t0 a_3200_83.t0 0.000646865086583264f
CMODEL8585 a_3200_169.t0 a_3200_83.t1 0.000646865086583264f
CMODEL8586 a_3200_169.n1 a_3200_83.t0 0.000584858313465272f
CMODEL8587 a_3200_169.n1 a_3200_83.t1 0.000584858313465272f
CMODEL8588 a_12800_83.t1 a_20000_14483.t0 7.85158367362187e-06f
CMODEL8589 a_12800_83.t1 a_20000_14483.t1 3.71740930121334e-06f
CMODEL8590 a_12800_83.t1 a_20000_14483.n0 1.00903640832778e-05f
CMODEL8591 a_12800_83.t1 a_20000_14483.t2 3.37029013613932e-06f
CMODEL8592 a_12800_83.t1 a_20000_14483.t3 3.55042922507211e-06f
CMODEL8593 a_12800_83.t1 a_20000_14483.t4 3.47282176184008e-06f
CMODEL8594 a_12800_83.t1 a_20000_14483.n1 8.85067640424056e-05f
CMODEL8595 a_12800_83.n0 a_20000_14483.t0 0.00010934012017127f
CMODEL8596 a_12800_83.n0 a_20000_14483.t1 5.1768152339255e-05f
CMODEL8597 a_12800_83.n0 a_20000_14483.n0 0.000140517081304762f
CMODEL8598 a_12800_83.n0 a_20000_14483.t2 4.6934216562648e-05f
CMODEL8599 a_12800_83.n0 a_20000_14483.t3 4.94428097904863e-05f
CMODEL8600 a_12800_83.n0 a_20000_14483.t4 4.83620584785586e-05f
CMODEL8601 a_12800_83.n0 a_20000_14483.n1 0.0012325335395557f
CMODEL8602 a_12800_83.t0 a_20000_14483.t0 1.78250351099864e-06f
CMODEL8603 a_12800_83.t0 a_20000_14483.t1 8.43943770668006e-07f
CMODEL8604 a_12800_83.t0 a_20000_14483.n0 2.29076198552444e-06f
CMODEL8605 a_12800_83.t0 a_20000_14483.t2 7.65139142684726e-07f
CMODEL8606 a_12800_83.t0 a_20000_14483.t3 8.06035167211542e-07f
CMODEL8607 a_12800_83.t0 a_20000_14483.t4 7.88416355333432e-07f
CMODEL8608 a_12800_83.t0 a_20000_14483.n1 2.00932224899721e-05f
CMODEL8609 a_12800_83.t2 a_20000_14483.t0 1.75796666494985e-06f
CMODEL8610 a_12800_83.t2 a_20000_14483.t1 8.3232656024068e-07f
CMODEL8611 a_12800_83.t2 a_20000_14483.n0 2.25922876619196e-06f
CMODEL8612 a_12800_83.t2 a_20000_14483.t2 7.54606708255218e-07f
CMODEL8613 a_12800_83.t2 a_20000_14483.t3 7.94939783283405e-07f
CMODEL8614 a_12800_83.t2 a_20000_14483.t4 7.77563501123721e-07f
CMODEL8615 a_12800_83.t2 a_20000_14483.n1 1.98166315582749e-05f
CMODEL8616 a_12800_83.t3 a_20000_14483.t0 1.75796666494985e-06f
CMODEL8617 a_12800_83.t3 a_20000_14483.t1 8.3232656024068e-07f
CMODEL8618 a_12800_83.t3 a_20000_14483.n0 2.25922876619196e-06f
CMODEL8619 a_12800_83.t3 a_20000_14483.t2 7.54606708255218e-07f
CMODEL8620 a_12800_83.t3 a_20000_14483.t3 7.94939783283405e-07f
CMODEL8621 a_12800_83.t3 a_20000_14483.t4 7.77563501123721e-07f
CMODEL8622 a_12800_83.t3 a_20000_14483.n1 1.98166315582749e-05f
CMODEL8623 a_12800_83.n1 a_20000_14483.t0 0.000738724715662255f
CMODEL8624 a_12800_83.n1 a_20000_14483.t1 0.000349756462287344f
CMODEL8625 a_12800_83.n1 a_20000_14483.n0 0.00094936278440112f
CMODEL8626 a_12800_83.n1 a_20000_14483.t2 0.000317097381370749f
CMODEL8627 a_12800_83.n1 a_20000_14483.t3 0.000334045961782444f
CMODEL8628 a_12800_83.n1 a_20000_14483.t4 0.000326744179926389f
CMODEL8629 a_12800_83.n1 a_20000_14483.n1 0.00832725432463642f
CMODEL8630 a_3200_n35917.t1 vdd 6.90589952958443e-06f
CMODEL8631 a_3200_n35917.t1 vdd.n0 0.00231749137387741f
CMODEL8632 a_3200_n35917.t1 vdd.n1 0.000214763682056657f
CMODEL8633 a_3200_n35917.t1 vdd.t7 1.77043451867521e-05f
CMODEL8634 a_3200_n35917.t1 vdd.t6 0.000139943675679691f
CMODEL8635 a_3200_n35917.t1 vdd.n2 0.000192587235460078f
CMODEL8636 a_3200_n35917.t1 vdd.t27 1.77043451867521e-05f
CMODEL8637 a_3200_n35917.t1 vdd.t26 0.000139943675679691f
CMODEL8638 a_3200_n35917.t1 vdd.n3 0.000361222286917854f
CMODEL8639 a_3200_n35917.t1 vdd.n4 0.000192587235460078f
CMODEL8640 a_3200_n35917.t1 vdd.t36 1.77043451867521e-05f
CMODEL8641 a_3200_n35917.t1 vdd.t35 0.000139943675679691f
CMODEL8642 a_3200_n35917.t1 vdd.n5 0.000274791714760056f
CMODEL8643 a_3200_n35917.t1 vdd.t3 2.82019533588645e-05f
CMODEL8644 a_3200_n35917.t1 vdd.n6 0.000269822893380026f
CMODEL8645 a_3200_n35917.t1 vdd.t2 0.000353621482150164f
CMODEL8646 a_3200_n35917.t1 vdd.n7 0.000361708790316683f
CMODEL8647 a_3200_n35917.t1 vdd.t25 2.82019533588645e-05f
CMODEL8648 a_3200_n35917.t1 vdd.n8 0.00016297539525141f
CMODEL8649 a_3200_n35917.t1 vdd.t24 0.000353621482150164f
CMODEL8650 a_3200_n35917.t1 vdd.n9 0.000361708790316683f
CMODEL8651 a_3200_n35917.t1 vdd.t5 2.82019533588645e-05f
CMODEL8652 a_3200_n35917.t1 vdd.n10 0.000482585424789504f
CMODEL8653 a_3200_n35917.t1 vdd.t4 0.000353816083509695f
CMODEL8654 a_3200_n35917.t1 vdd.n11 0.00116681029161328f
CMODEL8655 a_3200_n35917.t1 vdd.n12 0.00287692163218981f
CMODEL8656 a_3200_n35917.t1 vdd.n13 0.0002180670401347f
CMODEL8657 a_3200_n35917.t1 vdd.t42 1.77043451867521e-05f
CMODEL8658 a_3200_n35917.t1 vdd.t41 0.000139943675679691f
CMODEL8659 a_3200_n35917.t1 vdd.n14 0.000196059248049714f
CMODEL8660 a_3200_n35917.t1 vdd.t9 1.77043451867521e-05f
CMODEL8661 a_3200_n35917.t1 vdd.t8 0.000139943675679691f
CMODEL8662 a_3200_n35917.t1 vdd.n15 0.000376407679673274f
CMODEL8663 a_3200_n35917.t1 vdd.t15 2.98158473005768e-05f
CMODEL8664 a_3200_n35917.t1 vdd.n16 0.000234525450117053f
CMODEL8665 a_3200_n35917.t1 vdd.t14 0.00040219722484515f
CMODEL8666 a_3200_n35917.t1 vdd.n17 0.000328519528448632f
CMODEL8667 a_3200_n35917.t1 vdd.t32 0.00040219722484515f
CMODEL8668 a_3200_n35917.t1 vdd.n18 0.000324293435590812f
CMODEL8669 a_3200_n35917.t1 vdd.t34 2.98158473005768e-05f
CMODEL8670 a_3200_n35917.t1 vdd.n19 0.000326567028141335f
CMODEL8671 a_3200_n35917.t1 vdd.t33 0.00040219722484515f
CMODEL8672 a_3200_n35917.t1 vdd.n20 0.000651711844680096f
CMODEL8673 a_3200_n35917.t1 vdd.t48 0.000402965900215299f
CMODEL8674 a_3200_n35917.t1 vdd.n21 0.00115685967542925f
CMODEL8675 a_3200_n35917.t1 vdd.n22 0.00506978705206743f
CMODEL8676 a_3200_n35917.t1 vdd.t47 5.73177222685278e-06f
CMODEL8677 a_3200_n35917.t1 vdd.t45 5.67292153237454e-06f
CMODEL8678 a_3200_n35917.t1 vdd.n23 6.47782518895562e-05f
CMODEL8679 a_3200_n35917.t1 vdd.t46 0.000154596833716793f
CMODEL8680 a_3200_n35917.t1 vdd.n24 0.000166100368749882f
CMODEL8681 a_3200_n35917.t1 vdd.t44 0.000154596833716793f
CMODEL8682 a_3200_n35917.t1 vdd.n25 0.000261956133420976f
CMODEL8683 a_3200_n35917.t1 vdd.t43 0.000154931710222986f
CMODEL8684 a_3200_n35917.t1 vdd.n26 0.00140161304866766f
CMODEL8685 a_3200_n35917.t1 vdd.n27 0.000937007167820851f
CMODEL8686 a_3200_n35917.t1 vdd.n28 0.00021165330366015f
CMODEL8687 a_3200_n35917.t1 vdd.t29 1.77043451867521e-05f
CMODEL8688 a_3200_n35917.t1 vdd.t28 0.000139943675679691f
CMODEL8689 a_3200_n35917.t1 vdd.n29 3.15945037266922e-05f
CMODEL8690 a_3200_n35917.t1 vdd.n30 1.00793449833599e-05f
CMODEL8691 a_3200_n35917.t1 vdd.t38 4.64075592142092e-06f
CMODEL8692 a_3200_n35917.t1 vdd.t40 4.64075592142092e-06f
CMODEL8693 a_3200_n35917.t1 vdd.t37 9.37758004733042e-05f
CMODEL8694 a_3200_n35917.t1 vdd.t39 9.37758004733042e-05f
CMODEL8695 a_3200_n35917.t1 vdd.n31 3.03717585176377e-05f
CMODEL8696 a_3200_n35917.t1 vdd.n32 0.000366523552287084f
CMODEL8697 a_3200_n35917.t1 vdd.n33 0.000185717807468626f
CMODEL8698 a_3200_n35917.t1 vdd.t17 1.77043451867521e-05f
CMODEL8699 a_3200_n35917.t1 vdd.t16 0.000139943675679691f
CMODEL8700 a_3200_n35917.t1 vdd.n34 3.15945037266922e-05f
CMODEL8701 a_3200_n35917.t1 vdd.n35 1.00793449833599e-05f
CMODEL8702 a_3200_n35917.t1 vdd.t1 4.64075592142092e-06f
CMODEL8703 a_3200_n35917.t1 vdd.t31 4.64075592142092e-06f
CMODEL8704 a_3200_n35917.t1 vdd.t0 9.37758004733042e-05f
CMODEL8705 a_3200_n35917.t1 vdd.t30 9.37758004733042e-05f
CMODEL8706 a_3200_n35917.t1 vdd.n36 3.03717585176377e-05f
CMODEL8707 a_3200_n35917.t1 vdd.n37 0.000355455599963746f
CMODEL8708 a_3200_n35917.t1 vdd.n38 0.000205043344148073f
CMODEL8709 a_3200_n35917.t1 vdd.t19 1.77043451867521e-05f
CMODEL8710 a_3200_n35917.t1 vdd.t18 0.000139943675679691f
CMODEL8711 a_3200_n35917.t1 vdd.n39 0.000173028177149194f
CMODEL8712 a_3200_n35917.t1 vdd.t21 1.77045073545518e-05f
CMODEL8713 a_3200_n35917.t1 vdd.t20 0.000139943675679691f
CMODEL8714 a_3200_n35917.t1 vdd.n40 0.000173028177149194f
CMODEL8715 a_3200_n35917.t1 vdd.t11 1.77043451867521e-05f
CMODEL8716 a_3200_n35917.t1 vdd.t10 0.000139943675679691f
CMODEL8717 a_3200_n35917.t1 vdd.n41 0.000744398850546823f
CMODEL8718 a_3200_n35917.t1 vdd.n42 0.00142589443330317f
CMODEL8719 a_3200_n35917.t1 vdd.n43 0.000173028177149194f
CMODEL8720 a_3200_n35917.t1 vdd.t13 1.77043451867521e-05f
CMODEL8721 a_3200_n35917.t1 vdd.t12 0.000139943675679691f
CMODEL8722 a_3200_n35917.t1 vdd.n44 0.000173028177149194f
CMODEL8723 a_3200_n35917.t1 vdd.t23 1.77043451867521e-05f
CMODEL8724 a_3200_n35917.t1 vdd.t22 0.000139943675679691f
CMODEL8725 a_3200_n35917.t1 vdd.n45 0.00021359607389947f
CMODEL8726 a_3200_n35917.t1 vdd.n46 0.00352562526418715f
CMODEL8727 a_3200_n35917.n0 vdd 8.95784898296087e-05f
CMODEL8728 a_3200_n35917.n0 vdd.n0 0.0300608742678271f
CMODEL8729 a_3200_n35917.n0 vdd.n1 0.00278576400170121f
CMODEL8730 a_3200_n35917.n0 vdd.t7 0.000229648360573064f
CMODEL8731 a_3200_n35917.n0 vdd.t6 0.00181525130432148f
CMODEL8732 a_3200_n35917.n0 vdd.n2 0.00249810667517939f
CMODEL8733 a_3200_n35917.n0 vdd.t27 0.000229648360573064f
CMODEL8734 a_3200_n35917.n0 vdd.t26 0.00181525130432148f
CMODEL8735 a_3200_n35917.n0 vdd.n3 0.00468552240244453f
CMODEL8736 a_3200_n35917.n0 vdd.n4 0.00249810667517939f
CMODEL8737 a_3200_n35917.n0 vdd.t36 0.000229648360573064f
CMODEL8738 a_3200_n35917.n0 vdd.t35 0.00181525130432148f
CMODEL8739 a_3200_n35917.n0 vdd.n5 0.00356440558111851f
CMODEL8740 a_3200_n35917.n0 vdd.t3 0.000365815978253041f
CMODEL8741 a_3200_n35917.n0 vdd.n6 0.00349995351176108f
CMODEL8742 a_3200_n35917.n0 vdd.t2 0.00458693008877669f
CMODEL8743 a_3200_n35917.n0 vdd.n7 0.00469183298364794f
CMODEL8744 a_3200_n35917.n0 vdd.t25 0.000365815978253041f
CMODEL8745 a_3200_n35917.n0 vdd.n8 0.00211400263259888f
CMODEL8746 a_3200_n35917.n0 vdd.t24 0.00458693008877669f
CMODEL8747 a_3200_n35917.n0 vdd.n9 0.00469183298364794f
CMODEL8748 a_3200_n35917.n0 vdd.t5 0.000365815978253041f
CMODEL8749 a_3200_n35917.n0 vdd.n10 0.00625975998944562f
CMODEL8750 a_3200_n35917.n0 vdd.t4 0.00458945432125805f
CMODEL8751 a_3200_n35917.n0 vdd.n11 0.0151350455349953f
CMODEL8752 a_3200_n35917.n0 vdd.n12 0.037317411593621f
CMODEL8753 a_3200_n35917.n0 vdd.n13 0.00282861284807232f
CMODEL8754 a_3200_n35917.n0 vdd.t42 0.000229648360573064f
CMODEL8755 a_3200_n35917.n0 vdd.t41 0.00181525130432148f
CMODEL8756 a_3200_n35917.n0 vdd.n14 0.00254314318970101f
CMODEL8757 a_3200_n35917.n0 vdd.t9 0.000229648360573064f
CMODEL8758 a_3200_n35917.n0 vdd.t8 0.00181525130432148f
CMODEL8759 a_3200_n35917.n0 vdd.n15 0.00488249667707344f
CMODEL8760 a_3200_n35917.n0 vdd.t15 0.000386750279631799f
CMODEL8761 a_3200_n35917.n0 vdd.n16 0.00304209981018346f
CMODEL8762 a_3200_n35917.n0 vdd.t14 0.00521702058666587f
CMODEL8763 a_3200_n35917.n0 vdd.n17 0.00426132513395174f
CMODEL8764 a_3200_n35917.n0 vdd.t32 0.00521702058666587f
CMODEL8765 a_3200_n35917.n0 vdd.n18 0.00420650721856484f
CMODEL8766 a_3200_n35917.n0 vdd.t34 0.000386750279631799f
CMODEL8767 a_3200_n35917.n0 vdd.n19 0.00423599866805541f
CMODEL8768 a_3200_n35917.n0 vdd.t33 0.00521702058666587f
CMODEL8769 a_3200_n35917.n0 vdd.n20 0.0084535494037262f
CMODEL8770 a_3200_n35917.n0 vdd.t48 0.00522699130496725f
CMODEL8771 a_3200_n35917.n0 vdd.n21 0.015005973114115f
CMODEL8772 a_3200_n35917.n0 vdd.n22 0.0657617253098428f
CMODEL8773 a_3200_n35917.n0 vdd.t47 7.43485331533142e-05f
CMODEL8774 a_3200_n35917.n0 vdd.t45 7.35851631804091e-05f
CMODEL8775 a_3200_n35917.n0 vdd.n23 0.000840258094287338f
CMODEL8776 a_3200_n35917.n0 vdd.t46 0.00200532180311386f
CMODEL8777 a_3200_n35917.n0 vdd.n24 0.00215453759919541f
CMODEL8778 a_3200_n35917.n0 vdd.t44 0.00200532180311386f
CMODEL8779 a_3200_n35917.n0 vdd.n25 0.00339791141370204f
CMODEL8780 a_3200_n35917.n0 vdd.t43 0.00200966558650887f
CMODEL8781 a_3200_n35917.n0 vdd.n26 0.0181807423764647f
CMODEL8782 a_3200_n35917.n0 vdd.n27 0.0121542004330262f
CMODEL8783 a_3200_n35917.n0 vdd.n28 0.00274541835254078f
CMODEL8784 a_3200_n35917.n0 vdd.t29 0.000229648360573064f
CMODEL8785 a_3200_n35917.n0 vdd.t28 0.00181525130432148f
CMODEL8786 a_3200_n35917.n0 vdd.n29 0.000409821764511443f
CMODEL8787 a_3200_n35917.n0 vdd.n30 0.000130742200666704f
CMODEL8788 a_3200_n35917.n0 vdd.t38 6.01966340992679e-05f
CMODEL8789 a_3200_n35917.n0 vdd.t40 6.01966340992679e-05f
CMODEL8790 a_3200_n35917.n0 vdd.t37 0.00121639397633501f
CMODEL8791 a_3200_n35917.n0 vdd.t39 0.00121639397633501f
CMODEL8792 a_3200_n35917.n0 vdd.n31 0.000393961170420222f
CMODEL8793 a_3200_n35917.n0 vdd.n32 0.00475428670229096f
CMODEL8794 a_3200_n35917.n0 vdd.n33 0.00240900126858733f
CMODEL8795 a_3200_n35917.n0 vdd.t17 0.000229648360573064f
CMODEL8796 a_3200_n35917.n0 vdd.t16 0.00181525130432148f
CMODEL8797 a_3200_n35917.n0 vdd.n34 0.000409821764511443f
CMODEL8798 a_3200_n35917.n0 vdd.n35 0.000130742200666704f
CMODEL8799 a_3200_n35917.n0 vdd.t1 6.01966340992679e-05f
CMODEL8800 a_3200_n35917.n0 vdd.t31 6.01966340992679e-05f
CMODEL8801 a_3200_n35917.n0 vdd.t0 0.00121639397633501f
CMODEL8802 a_3200_n35917.n0 vdd.t30 0.00121639397633501f
CMODEL8803 a_3200_n35917.n0 vdd.n36 0.000393961170420222f
CMODEL8804 a_3200_n35917.n0 vdd.n37 0.00461072097991352f
CMODEL8805 a_3200_n35917.n0 vdd.n38 0.0026596785892572f
CMODEL8806 a_3200_n35917.n0 vdd.t19 0.000229648360573064f
CMODEL8807 a_3200_n35917.n0 vdd.t18 0.00181525130432148f
CMODEL8808 a_3200_n35917.n0 vdd.n39 0.00224440027553188f
CMODEL8809 a_3200_n35917.n0 vdd.t21 0.000229650464100132f
CMODEL8810 a_3200_n35917.n0 vdd.t20 0.00181525130432148f
CMODEL8811 a_3200_n35917.n0 vdd.n40 0.00224440027553188f
CMODEL8812 a_3200_n35917.n0 vdd.t11 0.000229648360573064f
CMODEL8813 a_3200_n35917.n0 vdd.t10 0.00181525130432148f
CMODEL8814 a_3200_n35917.n0 vdd.n41 0.009655820299328f
CMODEL8815 a_3200_n35917.n0 vdd.n42 0.0184957034843266f
CMODEL8816 a_3200_n35917.n0 vdd.n43 0.00224440027553188f
CMODEL8817 a_3200_n35917.n0 vdd.t13 0.000229648360573064f
CMODEL8818 a_3200_n35917.n0 vdd.t12 0.00181525130432148f
CMODEL8819 a_3200_n35917.n0 vdd.n44 0.00224440027553188f
CMODEL8820 a_3200_n35917.n0 vdd.t23 0.000229648360573064f
CMODEL8821 a_3200_n35917.n0 vdd.t22 0.00181525130432148f
CMODEL8822 a_3200_n35917.n0 vdd.n45 0.00277061860681304f
CMODEL8823 a_3200_n35917.n0 vdd.n46 0.0457319405702395f
CMODEL8824 a_3200_n35917.t0 vdd 1.56780737724781e-06f
CMODEL8825 a_3200_n35917.t0 vdd.n0 0.000526126981301714f
CMODEL8826 a_3200_n35917.t0 vdd.n1 4.87565861117579e-05f
CMODEL8827 a_3200_n35917.t0 vdd.t7 4.01931752326002e-06f
CMODEL8828 a_3200_n35917.t0 vdd.t6 3.17706225220739e-05f
CMODEL8829 a_3200_n35917.t0 vdd.n2 4.37219926563632e-05f
CMODEL8830 a_3200_n35917.t0 vdd.t27 4.01931752326002e-06f
CMODEL8831 a_3200_n35917.t0 vdd.t26 3.17706225220739e-05f
CMODEL8832 a_3200_n35917.t0 vdd.n3 8.20062562205011e-05f
CMODEL8833 a_3200_n35917.t0 vdd.n4 4.37219926563632e-05f
CMODEL8834 a_3200_n35917.t0 vdd.t36 4.01931752326002e-06f
CMODEL8835 a_3200_n35917.t0 vdd.t35 3.17706225220739e-05f
CMODEL8836 a_3200_n35917.t0 vdd.n5 6.23844114386238e-05f
CMODEL8837 a_3200_n35917.t0 vdd.t3 6.40253023366636e-06f
CMODEL8838 a_3200_n35917.t0 vdd.n6 6.12563679762962e-05f
CMODEL8839 a_3200_n35917.t0 vdd.t2 8.0280688430707e-05f
CMODEL8840 a_3200_n35917.t0 vdd.n7 8.21167043401807e-05f
CMODEL8841 a_3200_n35917.t0 vdd.t25 6.40253023366636e-06f
CMODEL8842 a_3200_n35917.t0 vdd.n8 3.69993837718654e-05f
CMODEL8843 a_3200_n35917.t0 vdd.t24 8.0280688430707e-05f
CMODEL8844 a_3200_n35917.t0 vdd.n9 8.21167043401807e-05f
CMODEL8845 a_3200_n35917.t0 vdd.t5 6.40253023366636e-06f
CMODEL8846 a_3200_n35917.t0 vdd.n10 0.000109558644155772f
CMODEL8847 a_3200_n35917.t0 vdd.t4 8.03248676785788e-05f
CMODEL8848 a_3200_n35917.t0 vdd.n11 0.000264894352314746f
CMODEL8849 a_3200_n35917.t0 vdd.n12 0.000653131274121276f
CMODEL8850 a_3200_n35917.t0 vdd.n13 4.95065288443823e-05f
CMODEL8851 a_3200_n35917.t0 vdd.t42 4.01931752326002e-06f
CMODEL8852 a_3200_n35917.t0 vdd.t41 3.17706225220739e-05f
CMODEL8853 a_3200_n35917.t0 vdd.n14 4.45102240704765e-05f
CMODEL8854 a_3200_n35917.t0 vdd.t9 4.01931752326002e-06f
CMODEL8855 a_3200_n35917.t0 vdd.t8 3.17706225220739e-05f
CMODEL8856 a_3200_n35917.t0 vdd.n15 8.54537101961001e-05f
CMODEL8857 a_3200_n35917.t0 vdd.t15 6.76892346268346e-06f
CMODEL8858 a_3200_n35917.t0 vdd.n16 5.32429887331429e-05f
CMODEL8859 a_3200_n35917.t0 vdd.t14 9.13085650203153e-05f
CMODEL8860 a_3200_n35917.t0 vdd.n17 7.4581933615639e-05f
CMODEL8861 a_3200_n35917.t0 vdd.t32 9.13085650203153e-05f
CMODEL8862 a_3200_n35917.t0 vdd.n18 7.36225076160222e-05f
CMODEL8863 a_3200_n35917.t0 vdd.t34 6.76892346268346e-06f
CMODEL8864 a_3200_n35917.t0 vdd.n19 7.41386684953249e-05f
CMODEL8865 a_3200_n35917.t0 vdd.t33 9.13085650203153e-05f
CMODEL8866 a_3200_n35917.t0 vdd.n20 0.000147954460320786f
CMODEL8867 a_3200_n35917.t0 vdd.t48 9.1483073049409e-05f
CMODEL8868 a_3200_n35917.t0 vdd.n21 0.000262635320106899f
CMODEL8869 a_3200_n35917.t0 vdd.n22 0.00115096512876507f
CMODEL8870 a_3200_n35917.t0 vdd.t47 1.30125188521309e-06f
CMODEL8871 a_3200_n35917.t0 vdd.t45 1.28789134433585e-06f
CMODEL8872 a_3200_n35917.t0 vdd.n23 1.47062407674174e-05f
CMODEL8873 a_3200_n35917.t0 vdd.t46 3.50972462547434e-05f
CMODEL8874 a_3200_n35917.t0 vdd.n24 3.77088288606073e-05f
CMODEL8875 a_3200_n35917.t0 vdd.t44 3.50972462547434e-05f
CMODEL8876 a_3200_n35917.t0 vdd.n25 5.94704218810772e-05f
CMODEL8877 a_3200_n35917.t0 vdd.t43 3.51732713771229e-05f
CMODEL8878 a_3200_n35917.t0 vdd.n26 0.000318200296476106f
CMODEL8879 a_3200_n35917.t0 vdd.n27 0.000212723446663293f
CMODEL8880 a_3200_n35917.t0 vdd.n28 4.80504544666064e-05f
CMODEL8881 a_3200_n35917.t0 vdd.t29 4.01931752326002e-06f
CMODEL8882 a_3200_n35917.t0 vdd.t28 3.17706225220739e-05f
CMODEL8883 a_3200_n35917.t0 vdd.n29 7.17272178823204e-06f
CMODEL8884 a_3200_n35917.t0 vdd.n30 2.2882567803138e-06f
CMODEL8885 a_3200_n35917.t0 vdd.t38 1.05356461362363e-06f
CMODEL8886 a_3200_n35917.t0 vdd.t40 1.05356461362363e-06f
CMODEL8887 a_3200_n35917.t0 vdd.t37 2.12893904927998e-05f
CMODEL8888 a_3200_n35917.t0 vdd.t39 2.12893904927998e-05f
CMODEL8889 a_3200_n35917.t0 vdd.n31 6.89512884743734e-06f
CMODEL8890 a_3200_n35917.t0 vdd.n32 8.32097725646097e-05f
CMODEL8891 a_3200_n35917.t0 vdd.n33 4.21624652064873e-05f
CMODEL8892 a_3200_n35917.t0 vdd.t17 4.01931752326002e-06f
CMODEL8893 a_3200_n35917.t0 vdd.t16 3.17706225220739e-05f
CMODEL8894 a_3200_n35917.t0 vdd.n34 7.17272178823204e-06f
CMODEL8895 a_3200_n35917.t0 vdd.n35 2.2882567803138e-06f
CMODEL8896 a_3200_n35917.t0 vdd.t1 1.05356461362363e-06f
CMODEL8897 a_3200_n35917.t0 vdd.t31 1.05356461362363e-06f
CMODEL8898 a_3200_n35917.t0 vdd.t0 2.12893904927998e-05f
CMODEL8899 a_3200_n35917.t0 vdd.t30 2.12893904927998e-05f
CMODEL8900 a_3200_n35917.t0 vdd.n36 6.89512884743734e-06f
CMODEL8901 a_3200_n35917.t0 vdd.n37 8.0697077841899e-05f
CMODEL8902 a_3200_n35917.t0 vdd.n38 4.65498326805597e-05f
CMODEL8903 a_3200_n35917.t0 vdd.t19 4.01931752326002e-06f
CMODEL8904 a_3200_n35917.t0 vdd.t18 3.17706225220739e-05f
CMODEL8905 a_3200_n35917.t0 vdd.n39 3.92816100848447e-05f
CMODEL8906 a_3200_n35917.t0 vdd.t21 4.01935433929992e-06f
CMODEL8907 a_3200_n35917.t0 vdd.t20 3.17706225220739e-05f
CMODEL8908 a_3200_n35917.t0 vdd.n40 3.92816100848447e-05f
CMODEL8909 a_3200_n35917.t0 vdd.t11 4.01931752326002e-06f
CMODEL8910 a_3200_n35917.t0 vdd.t10 3.17706225220739e-05f
CMODEL8911 a_3200_n35917.t0 vdd.n41 0.000168996667921743f
CMODEL8912 a_3200_n35917.t0 vdd.n42 0.000323712762129314f
CMODEL8913 a_3200_n35917.t0 vdd.n43 3.92816100848447e-05f
CMODEL8914 a_3200_n35917.t0 vdd.t13 4.01931752326002e-06f
CMODEL8915 a_3200_n35917.t0 vdd.t12 3.17706225220739e-05f
CMODEL8916 a_3200_n35917.t0 vdd.n44 3.92816100848447e-05f
CMODEL8917 a_3200_n35917.t0 vdd.t23 4.01931752326002e-06f
CMODEL8918 a_3200_n35917.t0 vdd.t22 3.17706225220739e-05f
CMODEL8919 a_3200_n35917.t0 vdd.n45 4.84915106245269e-05f
CMODEL8920 a_3200_n35917.t0 vdd.n46 0.000800402796902044f
CMODEL8921 a_3200_n35917.t3 vdd 1.15399484444756e-05f
CMODEL8922 a_3200_n35917.t3 vdd.n0 0.00387259195713663f
CMODEL8923 a_3200_n35917.t3 vdd.n1 0.00035887603172656f
CMODEL8924 a_3200_n35917.t3 vdd.t7 2.958444874894e-05f
CMODEL8925 a_3200_n35917.t3 vdd.t6 0.000233849738988489f
CMODEL8926 a_3200_n35917.t3 vdd.n2 0.000321818578268126f
CMODEL8927 a_3200_n35917.t3 vdd.t27 2.958444874894e-05f
CMODEL8928 a_3200_n35917.t3 vdd.t26 0.000233849738988489f
CMODEL8929 a_3200_n35917.t3 vdd.n3 0.000603612396932519f
CMODEL8930 a_3200_n35917.t3 vdd.n4 0.000321818578268126f
CMODEL8931 a_3200_n35917.t3 vdd.t36 2.958444874894e-05f
CMODEL8932 a_3200_n35917.t3 vdd.t35 0.000233849738988489f
CMODEL8933 a_3200_n35917.t3 vdd.n5 0.000459184528780846f
CMODEL8934 a_3200_n35917.t3 vdd.t3 4.71262413246238e-05f
CMODEL8935 a_3200_n35917.t3 vdd.n6 0.000450881491311256f
CMODEL8936 a_3200_n35917.t3 vdd.t2 0.000590911242683182f
CMODEL8937 a_3200_n35917.t3 vdd.n7 0.000604425357520272f
CMODEL8938 a_3200_n35917.t3 vdd.t25 4.71262413246238e-05f
CMODEL8939 a_3200_n35917.t3 vdd.n8 0.000272336377160193f
CMODEL8940 a_3200_n35917.t3 vdd.t24 0.000590911242683182f
CMODEL8941 a_3200_n35917.t3 vdd.n9 0.000604425357520272f
CMODEL8942 a_3200_n35917.t3 vdd.t5 4.71262413246238e-05f
CMODEL8943 a_3200_n35917.t3 vdd.n10 0.000806413545153523f
CMODEL8944 a_3200_n35917.t3 vdd.t4 0.000591236426918284f
CMODEL8945 a_3200_n35917.t3 vdd.n11 0.00194977215524464f
CMODEL8946 a_3200_n35917.t3 vdd.n12 0.00480741533699445f
CMODEL8947 a_3200_n35917.t3 vdd.n13 0.000364396034117406f
CMODEL8948 a_3200_n35917.t3 vdd.t42 2.958444874894e-05f
CMODEL8949 a_3200_n35917.t3 vdd.t41 0.000233849738988489f
CMODEL8950 a_3200_n35917.t3 vdd.n14 0.000327620406996061f
CMODEL8951 a_3200_n35917.t3 vdd.t9 2.958444874894e-05f
CMODEL8952 a_3200_n35917.t3 vdd.t8 0.000233849738988489f
CMODEL8953 a_3200_n35917.t3 vdd.n15 0.000628987606744933f
CMODEL8954 a_3200_n35917.t3 vdd.t15 4.9823102581065e-05f
CMODEL8955 a_3200_n35917.t3 vdd.n16 0.00039189849080111f
CMODEL8956 a_3200_n35917.t3 vdd.t14 0.00067208264750175f
CMODEL8957 a_3200_n35917.t3 vdd.n17 0.000548965186223724f
CMODEL8958 a_3200_n35917.t3 vdd.t32 0.00067208264750175f
CMODEL8959 a_3200_n35917.t3 vdd.n18 0.000541903268584772f
CMODEL8960 a_3200_n35917.t3 vdd.t34 4.9823102581065e-05f
CMODEL8961 a_3200_n35917.t3 vdd.n19 0.000545702504398206f
CMODEL8962 a_3200_n35917.t3 vdd.t33 0.00067208264750175f
CMODEL8963 a_3200_n35917.t3 vdd.n20 0.00108902845401155f
CMODEL8964 a_3200_n35917.t3 vdd.t48 0.000673367125230401f
CMODEL8965 a_3200_n35917.t3 vdd.n21 0.00193314440135645f
CMODEL8966 a_3200_n35917.t3 vdd.n22 0.00847175389023487f
CMODEL8967 a_3200_n35917.t3 vdd.t47 9.57794936199115e-06f
CMODEL8968 a_3200_n35917.t3 vdd.t45 9.47960822955922e-06f
CMODEL8969 a_3200_n35917.t3 vdd.n23 0.000108246244233112f
CMODEL8970 a_3200_n35917.t3 vdd.t46 0.000258335569917901f
CMODEL8971 a_3200_n35917.t3 vdd.n24 0.000277558294002196f
CMODEL8972 a_3200_n35917.t3 vdd.t44 0.000258335569917901f
CMODEL8973 a_3200_n35917.t3 vdd.n25 0.000437735918607281f
CMODEL8974 a_3200_n35917.t3 vdd.t43 0.000258895157789138f
CMODEL8975 a_3200_n35917.t3 vdd.n26 0.00234213403358077f
CMODEL8976 a_3200_n35917.t3 vdd.n27 0.00156576480188199f
CMODEL8977 a_3200_n35917.t3 vdd.n28 0.000353678503702189f
CMODEL8978 a_3200_n35917.t3 vdd.t29 2.958444874894e-05f
CMODEL8979 a_3200_n35917.t3 vdd.t28 0.000233849738988489f
CMODEL8980 a_3200_n35917.t3 vdd.n29 5.2795286489892e-05f
CMODEL8981 a_3200_n35917.t3 vdd.n30 1.68428632597058e-05f
CMODEL8982 a_3200_n35917.t3 vdd.t38 7.75483104658126e-06f
CMODEL8983 a_3200_n35917.t3 vdd.t40 7.75483104658126e-06f
CMODEL8984 a_3200_n35917.t3 vdd.t37 0.000156701947105576f
CMODEL8985 a_3200_n35917.t3 vdd.t39 0.000156701947105576f
CMODEL8986 a_3200_n35917.t3 vdd.n31 5.07520455460047e-05f
CMODEL8987 a_3200_n35917.t3 vdd.n32 0.000612470957470407f
CMODEL8988 a_3200_n35917.t3 vdd.n33 0.000310339574769046f
CMODEL8989 a_3200_n35917.t3 vdd.t17 2.958444874894e-05f
CMODEL8990 a_3200_n35917.t3 vdd.t16 0.000233849738988489f
CMODEL8991 a_3200_n35917.t3 vdd.n34 5.2795286489892e-05f
CMODEL8992 a_3200_n35917.t3 vdd.n35 1.68428632597058e-05f
CMODEL8993 a_3200_n35917.t3 vdd.t1 7.75483104658126e-06f
CMODEL8994 a_3200_n35917.t3 vdd.t31 7.75483104658126e-06f
CMODEL8995 a_3200_n35917.t3 vdd.t0 0.000156701947105576f
CMODEL8996 a_3200_n35917.t3 vdd.t30 0.000156701947105576f
CMODEL8997 a_3200_n35917.t3 vdd.n36 5.07520455460047e-05f
CMODEL8998 a_3200_n35917.t3 vdd.n37 0.000593976104099013f
CMODEL8999 a_3200_n35917.t3 vdd.n38 0.000342633079183243f
CMODEL9000 a_3200_n35917.t3 vdd.t19 2.958444874894e-05f
CMODEL9001 a_3200_n35917.t3 vdd.t18 0.000233849738988489f
CMODEL9002 a_3200_n35917.t3 vdd.n39 0.000289134852771807f
CMODEL9003 a_3200_n35917.t3 vdd.t21 2.95847197358026e-05f
CMODEL9004 a_3200_n35917.t3 vdd.t20 0.000233849738988489f
CMODEL9005 a_3200_n35917.t3 vdd.n40 0.000289134852771807f
CMODEL9006 a_3200_n35917.t3 vdd.t11 2.958444874894e-05f
CMODEL9007 a_3200_n35917.t3 vdd.t10 0.000233849738988489f
CMODEL9008 a_3200_n35917.t3 vdd.n41 0.00124391099532173f
CMODEL9009 a_3200_n35917.t3 vdd.n42 0.00238270889651555f
CMODEL9010 a_3200_n35917.t3 vdd.n43 0.000289134852771807f
CMODEL9011 a_3200_n35917.t3 vdd.t13 2.958444874894e-05f
CMODEL9012 a_3200_n35917.t3 vdd.t12 0.000233849738988489f
CMODEL9013 a_3200_n35917.t3 vdd.n44 0.000289134852771807f
CMODEL9014 a_3200_n35917.t3 vdd.t23 2.958444874894e-05f
CMODEL9015 a_3200_n35917.t3 vdd.t22 0.000233849738988489f
CMODEL9016 a_3200_n35917.t3 vdd.n45 0.000356924926315951f
CMODEL9017 a_3200_n35917.t3 vdd.n46 0.00589141698470505f
CMODEL9018 a_3200_n35917.t2 vdd 2.63651299991954e-06f
CMODEL9019 a_3200_n35917.t2 vdd.n0 0.000884764701289663f
CMODEL9020 a_3200_n35917.t2 vdd.n1 8.19918154365384e-05f
CMODEL9021 a_3200_n35917.t2 vdd.t7 6.75911024189832e-06f
CMODEL9022 a_3200_n35917.t2 vdd.t6 5.3427264414348e-05f
CMODEL9023 a_3200_n35917.t2 vdd.n2 7.35253601263463e-05f
CMODEL9024 a_3200_n35917.t2 vdd.t27 6.75911024189832e-06f
CMODEL9025 a_3200_n35917.t2 vdd.t26 5.3427264414348e-05f
CMODEL9026 a_3200_n35917.t2 vdd.n3 0.000137906329398467f
CMODEL9027 a_3200_n35917.t2 vdd.n4 7.35253601263463e-05f
CMODEL9028 a_3200_n35917.t2 vdd.t36 6.75911024189832e-06f
CMODEL9029 a_3200_n35917.t2 vdd.t35 5.3427264414348e-05f
CMODEL9030 a_3200_n35917.t2 vdd.n5 0.000104909132420968f
CMODEL9031 a_3200_n35917.t2 vdd.t3 1.07668546776911e-05f
CMODEL9032 a_3200_n35917.t2 vdd.n6 0.00010301215113611f
CMODEL9033 a_3200_n35917.t2 vdd.t2 0.000135004517622316f
CMODEL9034 a_3200_n35917.t2 vdd.n7 0.000138092065163956f
CMODEL9035 a_3200_n35917.t2 vdd.t25 1.07668546776911e-05f
CMODEL9036 a_3200_n35917.t2 vdd.n8 6.22202432002691e-05f
CMODEL9037 a_3200_n35917.t2 vdd.t24 0.000135004517622316f
CMODEL9038 a_3200_n35917.t2 vdd.n9 0.000138092065163956f
CMODEL9039 a_3200_n35917.t2 vdd.t5 1.07668546776911e-05f
CMODEL9040 a_3200_n35917.t2 vdd.n10 0.000184239973457272f
CMODEL9041 a_3200_n35917.t2 vdd.t4 0.000135078811928511f
CMODEL9042 a_3200_n35917.t2 vdd.n11 0.000445461230517415f
CMODEL9043 a_3200_n35917.t2 vdd.n12 0.00109834225802509f
CMODEL9044 a_3200_n35917.t2 vdd.n13 8.32529612842065e-05f
CMODEL9045 a_3200_n35917.t2 vdd.t42 6.75911024189832e-06f
CMODEL9046 a_3200_n35917.t2 vdd.t41 5.3427264414348e-05f
CMODEL9047 a_3200_n35917.t2 vdd.n14 7.48508943727172e-05f
CMODEL9048 a_3200_n35917.t2 vdd.t9 6.75911024189832e-06f
CMODEL9049 a_3200_n35917.t2 vdd.t8 5.3427264414348e-05f
CMODEL9050 a_3200_n35917.t2 vdd.n15 0.000143703761758587f
CMODEL9051 a_3200_n35917.t2 vdd.t15 1.13830021237389e-05f
CMODEL9052 a_3200_n35917.t2 vdd.n16 8.95364022306883e-05f
CMODEL9053 a_3200_n35917.t2 vdd.t14 0.000153549614687141f
CMODEL9054 a_3200_n35917.t2 vdd.n17 0.000125421171242318f
CMODEL9055 a_3200_n35917.t2 vdd.t32 0.000153549614687141f
CMODEL9056 a_3200_n35917.t2 vdd.n18 0.00012380774655944f
CMODEL9057 a_3200_n35917.t2 vdd.t34 1.13830021237389e-05f
CMODEL9058 a_3200_n35917.t2 vdd.n19 0.00012467575170349f
CMODEL9059 a_3200_n35917.t2 vdd.t33 0.000153549614687141f
CMODEL9060 a_3200_n35917.t2 vdd.n20 0.000248808535852536f
CMODEL9061 a_3200_n35917.t2 vdd.t48 0.000153843077196613f
CMODEL9062 a_3200_n35917.t2 vdd.n21 0.000441662314993954f
CMODEL9063 a_3200_n35917.t2 vdd.n22 0.00193552764738874f
CMODEL9064 a_3200_n35917.t2 vdd.t47 2.18825830348917e-06f
CMODEL9065 a_3200_n35917.t2 vdd.t45 2.16579046705723e-06f
CMODEL9066 a_3200_n35917.t2 vdd.n23 2.47308409986606e-05f
CMODEL9067 a_3200_n35917.t2 vdd.t46 5.90215018470231e-05f
CMODEL9068 a_3200_n35917.t2 vdd.n24 6.34132859339247e-05f
CMODEL9069 a_3200_n35917.t2 vdd.t44 5.90215018470231e-05f
CMODEL9070 a_3200_n35917.t2 vdd.n25 0.000100008803808158f
CMODEL9071 a_3200_n35917.t2 vdd.t43 5.91493499656012e-05f
CMODEL9072 a_3200_n35917.t2 vdd.n26 0.000535103502134432f
CMODEL9073 a_3200_n35917.t2 vdd.n27 0.000357727703450404f
CMODEL9074 a_3200_n35917.t2 vdd.n28 8.08043447758475e-05f
CMODEL9075 a_3200_n35917.t2 vdd.t29 6.75911024189832e-06f
CMODEL9076 a_3200_n35917.t2 vdd.t28 5.3427264414348e-05f
CMODEL9077 a_3200_n35917.t2 vdd.n29 1.20620520823654e-05f
CMODEL9078 a_3200_n35917.t2 vdd.n30 3.84806120700997e-06f
CMODEL9079 a_3200_n35917.t2 vdd.t38 1.77173346699646e-06f
CMODEL9080 a_3200_n35917.t2 vdd.t40 1.77173346699646e-06f
CMODEL9081 a_3200_n35917.t2 vdd.t37 3.58014355648475e-05f
CMODEL9082 a_3200_n35917.t2 vdd.t39 3.58014355648475e-05f
CMODEL9083 a_3200_n35917.t2 vdd.n31 1.15952361917706e-05f
CMODEL9084 a_3200_n35917.t2 vdd.n32 0.000139930230123075f
CMODEL9085 a_3200_n35917.t2 vdd.n33 7.09027711176463e-05f
CMODEL9086 a_3200_n35917.t2 vdd.t17 6.75911024189832e-06f
CMODEL9087 a_3200_n35917.t2 vdd.t16 5.3427264414348e-05f
CMODEL9088 a_3200_n35917.t2 vdd.n34 1.20620520823654e-05f
CMODEL9089 a_3200_n35917.t2 vdd.n35 3.84806120700997e-06f
CMODEL9090 a_3200_n35917.t2 vdd.t1 1.77173346699646e-06f
CMODEL9091 a_3200_n35917.t2 vdd.t31 1.77173346699646e-06f
CMODEL9092 a_3200_n35917.t2 vdd.t0 3.58014355648475e-05f
CMODEL9093 a_3200_n35917.t2 vdd.t30 3.58014355648475e-05f
CMODEL9094 a_3200_n35917.t2 vdd.n36 1.15952361917706e-05f
CMODEL9095 a_3200_n35917.t2 vdd.n37 0.000135704741458208f
CMODEL9096 a_3200_n35917.t2 vdd.n38 7.82808148420747e-05f
CMODEL9097 a_3200_n35917.t2 vdd.t19 6.75911024189832e-06f
CMODEL9098 a_3200_n35917.t2 vdd.t18 5.3427264414348e-05f
CMODEL9099 a_3200_n35917.t2 vdd.n39 6.60581632344834e-05f
CMODEL9100 a_3200_n35917.t2 vdd.t21 6.75917215382015e-06f
CMODEL9101 a_3200_n35917.t2 vdd.t20 5.3427264414348e-05f
CMODEL9102 a_3200_n35917.t2 vdd.n40 6.60581632344834e-05f
CMODEL9103 a_3200_n35917.t2 vdd.t11 6.75911024189832e-06f
CMODEL9104 a_3200_n35917.t2 vdd.t10 5.3427264414348e-05f
CMODEL9105 a_3200_n35917.t2 vdd.n41 0.00028419429477422f
CMODEL9106 a_3200_n35917.t2 vdd.n42 0.000544373574189972f
CMODEL9107 a_3200_n35917.t2 vdd.n43 6.60581632344834e-05f
CMODEL9108 a_3200_n35917.t2 vdd.t13 6.75911024189832e-06f
CMODEL9109 a_3200_n35917.t2 vdd.t12 5.3427264414348e-05f
CMODEL9110 a_3200_n35917.t2 vdd.n44 6.60581632344834e-05f
CMODEL9111 a_3200_n35917.t2 vdd.t23 6.75911024189832e-06f
CMODEL9112 a_3200_n35917.t2 vdd.t22 5.3427264414348e-05f
CMODEL9113 a_3200_n35917.t2 vdd.n45 8.15460495993656e-05f
CMODEL9114 a_3200_n35917.t2 vdd.n46 0.00134600232772769f
CMODEL9115 a_0_n11917.t2 pc_b 8.29860491236744e-06f
CMODEL9116 a_0_n11917.t2 pc_b.t0 2.53201668585759e-05f
CMODEL9117 a_0_n11917.t2 pc_b.n0 0.000465494369717061f
CMODEL9118 a_0_n11917.t2 pc_b.t1 2.53201668585759e-05f
CMODEL9119 a_0_n11917.t2 pc_b.n1 0.00114927388358985f
CMODEL9120 a_0_n11917.t2 pc_b.t2 2.83281550264194e-05f
CMODEL9121 a_0_n11917.t1 pc_b 1.29820171629636e-05f
CMODEL9122 a_0_n11917.t1 pc_b.t0 3.96098915659018e-05f
CMODEL9123 a_0_n11917.t1 pc_b.n0 0.000728201421894881f
CMODEL9124 a_0_n11917.t1 pc_b.t1 3.96098915659018e-05f
CMODEL9125 a_0_n11917.t1 pc_b.n1 0.00179787969655888f
CMODEL9126 a_0_n11917.t1 pc_b.t2 4.43154721343586e-05f
CMODEL9127 a_0_n11917.n0 pc_b 0.000353996102630027f
CMODEL9128 a_0_n11917.n0 pc_b.t0 0.00108009002483296f
CMODEL9129 a_0_n11917.n0 pc_b.n0 0.0198567342843957f
CMODEL9130 a_0_n11917.n0 pc_b.t1 0.00108009002483296f
CMODEL9131 a_0_n11917.n0 pc_b.n1 0.0490249240615092f
CMODEL9132 a_0_n11917.n0 pc_b.t2 0.00120840268695125f
CMODEL9133 a_0_n11917.t6 pc_b 2.21180592554202e-05f
CMODEL9134 a_0_n11917.t6 pc_b.t0 6.74851926135789e-05f
CMODEL9135 a_0_n11917.t6 pc_b.n0 0.0012406702284528f
CMODEL9136 a_0_n11917.t6 pc_b.t1 6.74851926135789e-05f
CMODEL9137 a_0_n11917.t6 pc_b.n1 0.00306313026422839f
CMODEL9138 a_0_n11917.t6 pc_b.t2 7.55023064825395e-05f
CMODEL9139 a_0_n11917.n1 pc_b 0.00137237323892381f
CMODEL9140 a_0_n11917.n1 pc_b.t0 0.00418729651173161f
CMODEL9141 a_0_n11917.n1 pc_b.n0 0.0769806518825044f
CMODEL9142 a_0_n11917.n1 pc_b.t1 0.00418729651173161f
CMODEL9143 a_0_n11917.n1 pc_b.n1 0.190059984622497f
CMODEL9144 a_0_n11917.n1 pc_b.t2 0.00468473945643619f
CMODEL9145 a_0_n11917.t4 pc_b 1.7558950432362e-06f
CMODEL9146 a_0_n11917.t4 pc_b.t0 5.35747344889604e-06f
CMODEL9147 a_0_n11917.t4 pc_b.n0 9.84935739286048e-05f
CMODEL9148 a_0_n11917.t4 pc_b.t1 5.35747344889604e-06f
CMODEL9149 a_0_n11917.t4 pc_b.n1 0.000243173923427633f
CMODEL9150 a_0_n11917.t4 pc_b.t2 5.99393121135178e-06f
CMODEL9151 a_0_n11917.t5 pc_b 1.77280488241715e-06f
CMODEL9152 a_0_n11917.t5 pc_b.t0 5.40906765709546e-06f
CMODEL9153 a_0_n11917.t5 pc_b.n0 9.94420990138058e-05f
CMODEL9154 a_0_n11917.t5 pc_b.t1 5.40906765709546e-06f
CMODEL9155 a_0_n11917.t5 pc_b.n1 0.000245515767237719f
CMODEL9156 a_0_n11917.t5 pc_b.t2 6.05165471438009e-06f
CMODEL9157 a_0_n11917.n2 pc_b 0.000445837211976302f
CMODEL9158 a_0_n11917.n2 pc_b.t0 0.00136030968074871f
CMODEL9159 a_0_n11917.n2 pc_b.n0 0.025008385647572f
CMODEL9160 a_0_n11917.n2 pc_b.t1 0.00136030968074871f
CMODEL9161 a_0_n11917.n2 pc_b.n1 0.0617440002828979f
CMODEL9162 a_0_n11917.n2 pc_b.t2 0.00152191191058983f
CMODEL9163 a_0_n11917.t0 pc_b 3.51394668858059e-06f
CMODEL9164 a_0_n11917.t0 pc_b.t0 1.07215269827345e-05f
CMODEL9165 a_0_n11917.t0 pc_b.n0 0.00019710811832751f
CMODEL9166 a_0_n11917.t0 pc_b.t1 1.07215269827345e-05f
CMODEL9167 a_0_n11917.t0 pc_b.n1 0.000486646514704433f
CMODEL9168 a_0_n11917.t0 pc_b.t2 1.19952242093528e-05f
CMODEL9169 a_0_n11917.t3 pc_b 6.31058153281474e-06f
CMODEL9170 a_0_n11917.t3 pc_b.t0 1.92544384354759e-05f
CMODEL9171 a_0_n11917.t3 pc_b.n0 0.000353980000757465f
CMODEL9172 a_0_n11917.t3 pc_b.t1 1.92544384354759e-05f
CMODEL9173 a_0_n11917.t3 pc_b.n1 0.000873952504368512f
CMODEL9174 a_0_n11917.t3 pc_b.t2 2.15418294829313e-05f
CMODEL9175 a_0_n11917.n3 pc_b 0.000978416598386662f
CMODEL9176 a_0_n11917.n3 pc_b.t0 0.00298528147682151f
CMODEL9177 a_0_n11917.n3 pc_b.n0 0.0548824076572142f
CMODEL9178 a_0_n11917.n3 pc_b.t1 0.00298528147682151f
CMODEL9179 a_0_n11917.n3 pc_b.n1 0.135500925236338f
CMODEL9180 a_0_n11917.n3 pc_b.t2 0.00333992729768506f
CMODEL9181 a_0_n11917.n4 pc_b 0.00178221598221945f
CMODEL9182 a_0_n11917.n4 pc_b.t0 0.00543778219644676f
CMODEL9183 a_0_n11917.n4 pc_b.n0 0.0999699966564915f
CMODEL9184 a_0_n11917.n4 pc_b.t1 0.00543778219644676f
CMODEL9185 a_0_n11917.n4 pc_b.n1 0.246819110550584f
CMODEL9186 a_0_n11917.n4 pc_b.t2 0.00608378048696284f
CMODEL9187 a_19896_16041.t2 vdd 1.3715698112714e-05f
CMODEL9188 a_19896_16041.t2 vdd.n0 0.00460273305841654f
CMODEL9189 a_19896_16041.t2 vdd.n1 0.000426538760960119f
CMODEL9190 a_19896_16041.t2 vdd.t7 3.51623206831372e-05f
CMODEL9191 a_19896_16041.t2 vdd.t6 0.000277939926606738f
CMODEL9192 a_19896_16041.t2 vdd.n2 0.000382494470215897f
CMODEL9193 a_19896_16041.t2 vdd.t27 3.51623206831372e-05f
CMODEL9194 a_19896_16041.t2 vdd.t26 0.000277939926606738f
CMODEL9195 a_19896_16041.t2 vdd.n3 0.000717417885638947f
CMODEL9196 a_19896_16041.t2 vdd.n4 0.000382494470215897f
CMODEL9197 a_19896_16041.t2 vdd.t36 3.51623206831372e-05f
CMODEL9198 a_19896_16041.t2 vdd.t35 0.000277939926606738f
CMODEL9199 a_19896_16041.t2 vdd.n5 0.000545759489749015f
CMODEL9200 a_19896_16041.t2 vdd.t3 5.60114546703091e-05f
CMODEL9201 a_19896_16041.t2 vdd.n6 0.00053589099199104f
CMODEL9202 a_19896_16041.t2 vdd.t2 0.000702322047195206f
CMODEL9203 a_19896_16041.t2 vdd.n7 0.000718384122364598f
CMODEL9204 a_19896_16041.t2 vdd.t25 5.60114546703091e-05f
CMODEL9205 a_19896_16041.t2 vdd.n8 0.000323682861514653f
CMODEL9206 a_19896_16041.t2 vdd.t24 0.000702322047195206f
CMODEL9207 a_19896_16041.t2 vdd.n9 0.000718384122364598f
CMODEL9208 a_19896_16041.t2 vdd.t5 5.60114546703091e-05f
CMODEL9209 a_19896_16041.t2 vdd.n10 0.000958455299219652f
CMODEL9210 a_19896_16041.t2 vdd.t4 0.000702708541885466f
CMODEL9211 a_19896_16041.t2 vdd.n11 0.00231738351333047f
CMODEL9212 a_19896_16041.t2 vdd.n12 0.00571380866924173f
CMODEL9213 a_19896_16041.t2 vdd.n13 0.000433099508327284f
CMODEL9214 a_19896_16041.t2 vdd.t42 3.51623206831372e-05f
CMODEL9215 a_19896_16041.t2 vdd.t41 0.000277939926606738f
CMODEL9216 a_19896_16041.t2 vdd.n14 0.000389390179647954f
CMODEL9217 a_19896_16041.t2 vdd.t9 3.51623206831372e-05f
CMODEL9218 a_19896_16041.t2 vdd.t8 0.000277939926606738f
CMODEL9219 a_19896_16041.t2 vdd.n15 0.000747577354635576f
CMODEL9220 a_19896_16041.t2 vdd.t15 5.92167839681995e-05f
CMODEL9221 a_19896_16041.t2 vdd.n16 0.000465787296756031f
CMODEL9222 a_19896_16041.t2 vdd.t14 0.000798797563462295f
CMODEL9223 a_19896_16041.t2 vdd.n17 0.000652467452940739f
CMODEL9224 a_19896_16041.t2 vdd.t32 0.000798797563462295f
CMODEL9225 a_19896_16041.t2 vdd.n18 0.000644074076583925f
CMODEL9226 a_19896_16041.t2 vdd.t34 5.92167839681995e-05f
CMODEL9227 a_19896_16041.t2 vdd.n19 0.000648589622881797f
CMODEL9228 a_19896_16041.t2 vdd.t33 0.000798797563462295f
CMODEL9229 a_19896_16041.t2 vdd.n20 0.00129435461373561f
CMODEL9230 a_19896_16041.t2 vdd.t48 0.000800324217488822f
CMODEL9231 a_19896_16041.t2 vdd.n21 0.00229762075150183f
CMODEL9232 a_19896_16041.t2 vdd.n22 0.0100690240864375f
CMODEL9233 a_19896_16041.t2 vdd.t47 1.13837823990298e-05f
CMODEL9234 a_19896_16041.t2 vdd.t45 1.1266899963117e-05f
CMODEL9235 a_19896_16041.t2 vdd.n23 0.000128655064178144f
CMODEL9236 a_19896_16041.t2 vdd.t46 0.000307042332625505f
CMODEL9237 a_19896_16041.t2 vdd.n24 0.000329889322082413f
CMODEL9238 a_19896_16041.t2 vdd.t44 0.000307042332625505f
CMODEL9239 a_19896_16041.t2 vdd.n25 0.000520266944137276f
CMODEL9240 a_19896_16041.t2 vdd.t43 0.000307707425571661f
CMODEL9241 a_19896_16041.t2 vdd.n26 0.00278372156502012f
CMODEL9242 a_19896_16041.t2 vdd.n27 0.00186097515439141f
CMODEL9243 a_19896_16041.t2 vdd.n28 0.000420361287494129f
CMODEL9244 a_19896_16041.t2 vdd.t29 3.51623206831372e-05f
CMODEL9245 a_19896_16041.t2 vdd.t28 0.000277939926606738f
CMODEL9246 a_19896_16041.t2 vdd.n29 6.27493454371767e-05f
CMODEL9247 a_19896_16041.t2 vdd.n30 2.00184280662396e-05f
CMODEL9248 a_19896_16041.t2 vdd.t38 9.21693212597746e-06f
CMODEL9249 a_19896_16041.t2 vdd.t40 9.21693212597746e-06f
CMODEL9250 a_19896_16041.t2 vdd.t37 0.0001862466379738f
CMODEL9251 a_19896_16041.t2 vdd.t39 0.0001862466379738f
CMODEL9252 a_19896_16041.t2 vdd.n31 6.03208704667091e-05f
CMODEL9253 a_19896_16041.t2 vdd.n32 0.000727946645159449f
CMODEL9254 a_19896_16041.t2 vdd.n33 0.000368851207649716f
CMODEL9255 a_19896_16041.t2 vdd.t17 3.51623206831372e-05f
CMODEL9256 a_19896_16041.t2 vdd.t16 0.000277939926606738f
CMODEL9257 a_19896_16041.t2 vdd.n34 6.27493454371767e-05f
CMODEL9258 a_19896_16041.t2 vdd.n35 2.00184280662396e-05f
CMODEL9259 a_19896_16041.t2 vdd.t1 9.21693212597746e-06f
CMODEL9260 a_19896_16041.t2 vdd.t31 9.21693212597746e-06f
CMODEL9261 a_19896_16041.t2 vdd.t0 0.0001862466379738f
CMODEL9262 a_19896_16041.t2 vdd.t30 0.0001862466379738f
CMODEL9263 a_19896_16041.t2 vdd.n36 6.03208704667091e-05f
CMODEL9264 a_19896_16041.t2 vdd.n37 0.000705964759650907f
CMODEL9265 a_19896_16041.t2 vdd.n38 0.000407233351181628f
CMODEL9266 a_19896_16041.t2 vdd.t19 3.51623206831372e-05f
CMODEL9267 a_19896_16041.t2 vdd.t18 0.000277939926606738f
CMODEL9268 a_19896_16041.t2 vdd.n39 0.000343648533055672f
CMODEL9269 a_19896_16041.t2 vdd.t21 3.51626427620458e-05f
CMODEL9270 a_19896_16041.t2 vdd.t20 0.000277939926606738f
CMODEL9271 a_19896_16041.t2 vdd.n40 0.000343648533055672f
CMODEL9272 a_19896_16041.t2 vdd.t11 3.51623206831372e-05f
CMODEL9273 a_19896_16041.t2 vdd.t10 0.000277939926606738f
CMODEL9274 a_19896_16041.t2 vdd.n41 0.0014784388139174f
CMODEL9275 a_19896_16041.t2 vdd.n42 0.00283194643999732f
CMODEL9276 a_19896_16041.t2 vdd.n43 0.000343648533055672f
CMODEL9277 a_19896_16041.t2 vdd.t13 3.51623206831372e-05f
CMODEL9278 a_19896_16041.t2 vdd.t12 0.000277939926606738f
CMODEL9279 a_19896_16041.t2 vdd.n44 0.000343648533055672f
CMODEL9280 a_19896_16041.t2 vdd.t23 3.51623206831372e-05f
CMODEL9281 a_19896_16041.t2 vdd.t22 0.000277939926606738f
CMODEL9282 a_19896_16041.t2 vdd.n45 0.000424219792818559f
CMODEL9283 a_19896_16041.t2 vdd.n46 0.00700218871922373f
CMODEL9284 a_19896_16041.t1 vdd 6.4938244569835e-06f
CMODEL9285 a_19896_16041.t1 vdd.n0 0.00217920664760077f
CMODEL9286 a_19896_16041.t1 vdd.n1 0.000201948731665848f
CMODEL9287 a_19896_16041.t1 vdd.t7 1.66479267872476e-05f
CMODEL9288 a_19896_16041.t1 vdd.t6 0.000131593235585869f
CMODEL9289 a_19896_16041.t1 vdd.n2 0.000181095553790768f
CMODEL9290 a_19896_16041.t1 vdd.t27 1.66479267872476e-05f
CMODEL9291 a_19896_16041.t1 vdd.t26 0.000131593235585869f
CMODEL9292 a_19896_16041.t1 vdd.n3 0.00033966815056399f
CMODEL9293 a_19896_16041.t1 vdd.n4 0.000181095553790768f
CMODEL9294 a_19896_16041.t1 vdd.t36 1.66479267872476e-05f
CMODEL9295 a_19896_16041.t1 vdd.t35 0.000131593235585869f
CMODEL9296 a_19896_16041.t1 vdd.n5 0.000258394891243468f
CMODEL9297 a_19896_16041.t1 vdd.t3 2.65191426072663e-05f
CMODEL9298 a_19896_16041.t1 vdd.n6 0.000253722559469483f
CMODEL9299 a_19896_16041.t1 vdd.t2 0.000332520885869255f
CMODEL9300 a_19896_16041.t1 vdd.n7 0.000340125624301652f
CMODEL9301 a_19896_16041.t1 vdd.t25 2.65191426072663e-05f
CMODEL9302 a_19896_16041.t1 vdd.n8 0.000153250652291758f
CMODEL9303 a_19896_16041.t1 vdd.t24 0.000332520885869255f
CMODEL9304 a_19896_16041.t1 vdd.n9 0.000340125624301652f
CMODEL9305 a_19896_16041.t1 vdd.t5 2.65191426072663e-05f
CMODEL9306 a_19896_16041.t1 vdd.n10 0.000453789549161083f
CMODEL9307 a_19896_16041.t1 vdd.t4 0.00033270387536432f
CMODEL9308 a_19896_16041.t1 vdd.n11 0.00109718671345836f
CMODEL9309 a_19896_16041.t1 vdd.n12 0.00270525569853798f
CMODEL9310 a_19896_16041.t1 vdd.n13 0.000205054978344571f
CMODEL9311 a_19896_16041.t1 vdd.t42 1.66479267872476e-05f
CMODEL9312 a_19896_16041.t1 vdd.t41 0.000131593235585869f
CMODEL9313 a_19896_16041.t1 vdd.n14 0.000184360391365214f
CMODEL9314 a_19896_16041.t1 vdd.t9 1.66479267872476e-05f
CMODEL9315 a_19896_16041.t1 vdd.t8 0.000131593235585869f
CMODEL9316 a_19896_16041.t1 vdd.n15 0.000353947430828871f
CMODEL9317 a_19896_16041.t1 vdd.t15 2.80367354863361e-05f
CMODEL9318 a_19896_16041.t1 vdd.n16 0.000220531314889667f
CMODEL9319 a_19896_16041.t1 vdd.t14 0.000378198113662319f
CMODEL9320 a_19896_16041.t1 vdd.n17 0.00030891676591837f
CMODEL9321 a_19896_16041.t1 vdd.t32 0.000378198113662319f
CMODEL9322 a_19896_16041.t1 vdd.n18 0.000304942844050548f
CMODEL9323 a_19896_16041.t1 vdd.t34 2.80367354863361e-05f
CMODEL9324 a_19896_16041.t1 vdd.n19 0.000307080771317887f
CMODEL9325 a_19896_16041.t1 vdd.t33 0.000378198113662319f
CMODEL9326 a_19896_16041.t1 vdd.n20 0.000612824194409343f
CMODEL9327 a_19896_16041.t1 vdd.t48 0.000378920922167825f
CMODEL9328 a_19896_16041.t1 vdd.n21 0.00108782985061072f
CMODEL9329 a_19896_16041.t1 vdd.n22 0.00476727282367441f
CMODEL9330 a_19896_16041.t1 vdd.t47 5.38975733851071e-06f
CMODEL9331 a_19896_16041.t1 vdd.t45 5.33441826537823e-06f
CMODEL9332 a_19896_16041.t1 vdd.n23 6.09129331521496e-05f
CMODEL9333 a_19896_16041.t1 vdd.t46 0.000145372039581748f
CMODEL9334 a_19896_16041.t1 vdd.n24 0.000156189158600005f
CMODEL9335 a_19896_16041.t1 vdd.t44 0.000145372039581748f
CMODEL9336 a_19896_16041.t1 vdd.n25 0.000246325209131493f
CMODEL9337 a_19896_16041.t1 vdd.t43 0.000145686934004505f
CMODEL9338 a_19896_16041.t1 vdd.n26 0.00131797878837849f
CMODEL9339 a_19896_16041.t1 vdd.n27 0.000881095943648928f
CMODEL9340 a_19896_16041.t1 vdd.n28 0.000199023949569731f
CMODEL9341 a_19896_16041.t1 vdd.t29 1.66479267872476e-05f
CMODEL9342 a_19896_16041.t1 vdd.t28 0.000131593235585869f
CMODEL9343 a_19896_16041.t1 vdd.n29 2.97092594712273e-05f
CMODEL9344 a_19896_16041.t1 vdd.n30 9.4779103986263e-06f
CMODEL9345 a_19896_16041.t1 vdd.t38 4.36384198355513e-06f
CMODEL9346 a_19896_16041.t1 vdd.t40 4.36384198355513e-06f
CMODEL9347 a_19896_16041.t1 vdd.t37 8.81801978117386e-05f
CMODEL9348 a_19896_16041.t1 vdd.t39 8.81801978117386e-05f
CMODEL9349 a_19896_16041.t1 vdd.n31 2.85594754772375e-05f
CMODEL9350 a_19896_16041.t1 vdd.n32 0.000344653089392044f
CMODEL9351 a_19896_16041.t1 vdd.n33 0.000174636024614984f
CMODEL9352 a_19896_16041.t1 vdd.t17 1.66479267872476e-05f
CMODEL9353 a_19896_16041.t1 vdd.t16 0.000131593235585869f
CMODEL9354 a_19896_16041.t1 vdd.n34 2.97092594712273e-05f
CMODEL9355 a_19896_16041.t1 vdd.n35 9.4779103986263e-06f
CMODEL9356 a_19896_16041.t1 vdd.t1 4.36384198355513e-06f
CMODEL9357 a_19896_16041.t1 vdd.t31 4.36384198355513e-06f
CMODEL9358 a_19896_16041.t1 vdd.t0 8.81801978117386e-05f
CMODEL9359 a_19896_16041.t1 vdd.t30 8.81801978117386e-05f
CMODEL9360 a_19896_16041.t1 vdd.n36 2.85594754772375e-05f
CMODEL9361 a_19896_16041.t1 vdd.n37 0.00033424556186024f
CMODEL9362 a_19896_16041.t1 vdd.n38 0.000192808406387367f
CMODEL9363 a_19896_16041.t1 vdd.t19 1.66479267872476e-05f
CMODEL9364 a_19896_16041.t1 vdd.t18 0.000131593235585869f
CMODEL9365 a_19896_16041.t1 vdd.n39 0.000162703584624308f
CMODEL9366 a_19896_16041.t1 vdd.t21 1.66480792784935e-05f
CMODEL9367 a_19896_16041.t1 vdd.t20 0.000131593235585869f
CMODEL9368 a_19896_16041.t1 vdd.n40 0.000162703584624308f
CMODEL9369 a_19896_16041.t1 vdd.t11 1.66479267872476e-05f
CMODEL9370 a_19896_16041.t1 vdd.t10 0.000131593235585869f
CMODEL9371 a_19896_16041.t1 vdd.n41 0.000699980565996195f
CMODEL9372 a_19896_16041.t1 vdd.n42 0.00134081130262519f
CMODEL9373 a_19896_16041.t1 vdd.n43 0.000162703584624308f
CMODEL9374 a_19896_16041.t1 vdd.t13 1.66479267872476e-05f
CMODEL9375 a_19896_16041.t1 vdd.t12 0.000131593235585869f
CMODEL9376 a_19896_16041.t1 vdd.n44 0.000162703584624308f
CMODEL9377 a_19896_16041.t1 vdd.t23 1.66479267872476e-05f
CMODEL9378 a_19896_16041.t1 vdd.t22 0.000131593235585869f
CMODEL9379 a_19896_16041.t1 vdd.n45 0.00020085079469546f
CMODEL9380 a_19896_16041.t1 vdd.n46 0.00331525118033612f
CMODEL9381 a_19896_16041.n0 vdd 1.94551387483015e-05f
CMODEL9382 a_19896_16041.n0 vdd.n0 0.00652878253348844f
CMODEL9383 a_19896_16041.n0 vdd.n1 0.000605027225578506f
CMODEL9384 a_19896_16041.n0 vdd.t7 4.98762674696505e-05f
CMODEL9385 a_19896_16041.n0 vdd.t6 0.000394246052325572f
CMODEL9386 a_19896_16041.n0 vdd.n2 0.000542552258540184f
CMODEL9387 a_19896_16041.n0 vdd.t27 4.98762674696505e-05f
CMODEL9388 a_19896_16041.n0 vdd.t26 0.000394246052325572f
CMODEL9389 a_19896_16041.n0 vdd.n3 0.00101762698412563f
CMODEL9390 a_19896_16041.n0 vdd.n4 0.000542552258540184f
CMODEL9391 a_19896_16041.n0 vdd.t36 4.98762674696505e-05f
CMODEL9392 a_19896_16041.n0 vdd.t35 0.000394246052325572f
CMODEL9393 a_19896_16041.n0 vdd.n5 0.000774136796320043f
CMODEL9394 a_19896_16041.n0 vdd.t3 7.9449883859352e-05f
CMODEL9395 a_19896_16041.n0 vdd.n6 0.00076013874886078f
CMODEL9396 a_19896_16041.n0 vdd.t2 0.00099621417458204f
CMODEL9397 a_19896_16041.n0 vdd.n7 0.00101899755013013f
CMODEL9398 a_19896_16041.n0 vdd.t25 7.9449883859352e-05f
CMODEL9399 a_19896_16041.n0 vdd.n8 0.0004591304743998f
CMODEL9400 a_19896_16041.n0 vdd.t24 0.00099621417458204f
CMODEL9401 a_19896_16041.n0 vdd.n9 0.00101899755013013f
CMODEL9402 a_19896_16041.n0 vdd.t5 7.9449883859352e-05f
CMODEL9403 a_19896_16041.n0 vdd.n10 0.00135952837960745f
CMODEL9404 a_19896_16041.n0 vdd.t4 0.000996762400983839f
CMODEL9405 a_19896_16041.n0 vdd.n11 0.00328711068254543f
CMODEL9406 a_19896_16041.n0 vdd.n12 0.00810479638205955f
CMODEL9407 a_19896_16041.n0 vdd.n13 0.00061433336874904f
CMODEL9408 a_19896_16041.n0 vdd.t42 4.98762674696505e-05f
CMODEL9409 a_19896_16041.n0 vdd.t41 0.000394246052325572f
CMODEL9410 a_19896_16041.n0 vdd.n14 0.000552333531258944f
CMODEL9411 a_19896_16041.n0 vdd.t9 4.98762674696505e-05f
CMODEL9412 a_19896_16041.n0 vdd.t8 0.000394246052325572f
CMODEL9413 a_19896_16041.n0 vdd.n15 0.00106040691767933f
CMODEL9414 a_19896_16041.n0 vdd.t15 8.39965081516034e-05f
CMODEL9415 a_19896_16041.n0 vdd.n16 0.000660699616681174f
CMODEL9416 a_19896_16041.n0 vdd.t14 0.00113306062157772f
CMODEL9417 a_19896_16041.n0 vdd.n17 0.000925497537303343f
CMODEL9418 a_19896_16041.n0 vdd.t32 0.00113306062157772f
CMODEL9419 a_19896_16041.n0 vdd.n18 0.000913591887277613f
CMODEL9420 a_19896_16041.n0 vdd.t34 8.39965081516034e-05f
CMODEL9421 a_19896_16041.n0 vdd.n19 0.000919996999071962f
CMODEL9422 a_19896_16041.n0 vdd.t33 0.00113306062157772f
CMODEL9423 a_19896_16041.n0 vdd.n20 0.00183598737685744f
CMODEL9424 a_19896_16041.n0 vdd.t48 0.00113522611586482f
CMODEL9425 a_19896_16041.n0 vdd.n21 0.00325907803920012f
CMODEL9426 a_19896_16041.n0 vdd.n22 0.0142824855907293f
CMODEL9427 a_19896_16041.n0 vdd.t47 1.61474147530484e-05f
CMODEL9428 a_19896_16041.n0 vdd.t45 1.59816219520378e-05f
CMODEL9429 a_19896_16041.n0 vdd.n23 0.000182491777209446f
CMODEL9430 a_19896_16041.n0 vdd.t46 0.000435526586670352f
CMODEL9431 a_19896_16041.n0 vdd.n24 0.000467934076702019f
CMODEL9432 a_19896_16041.n0 vdd.t44 0.000435526586670352f
CMODEL9433 a_19896_16041.n0 vdd.n25 0.000737976696568063f
CMODEL9434 a_19896_16041.n0 vdd.t43 0.000436469992936781f
CMODEL9435 a_19896_16041.n0 vdd.n26 0.00394859152184917f
CMODEL9436 a_19896_16041.n0 vdd.n27 0.00263971469321458f
CMODEL9437 a_19896_16041.n0 vdd.n28 0.000596264740256421f
CMODEL9438 a_19896_16041.n0 vdd.t29 4.98762674696505e-05f
CMODEL9439 a_19896_16041.n0 vdd.t28 0.000394246052325572f
CMODEL9440 a_19896_16041.n0 vdd.n29 8.90072974640444e-05f
CMODEL9441 a_19896_16041.n0 vdd.n30 2.8395295110102e-05f
CMODEL9442 a_19896_16041.n0 vdd.t38 1.30738291168969e-05f
CMODEL9443 a_19896_16041.n0 vdd.t40 1.30738291168969e-05f
CMODEL9444 a_19896_16041.n0 vdd.t37 0.000264182993341485f
CMODEL9445 a_19896_16041.n0 vdd.t39 0.000264182993341485f
CMODEL9446 a_19896_16041.n0 vdd.n31 8.55626082394086e-05f
CMODEL9447 a_19896_16041.n0 vdd.n32 0.0010325615850213f
CMODEL9448 a_19896_16041.n0 vdd.n33 0.000523199866556686f
CMODEL9449 a_19896_16041.n0 vdd.t17 4.98762674696505e-05f
CMODEL9450 a_19896_16041.n0 vdd.t16 0.000394246052325572f
CMODEL9451 a_19896_16041.n0 vdd.n34 8.90072974640444e-05f
CMODEL9452 a_19896_16041.n0 vdd.n35 2.8395295110102e-05f
CMODEL9453 a_19896_16041.n0 vdd.t1 1.30738291168969e-05f
CMODEL9454 a_19896_16041.n0 vdd.t31 1.30738291168969e-05f
CMODEL9455 a_19896_16041.n0 vdd.t0 0.000264182993341485f
CMODEL9456 a_19896_16041.n0 vdd.t30 0.000264182993341485f
CMODEL9457 a_19896_16041.n0 vdd.n36 8.55626082394086e-05f
CMODEL9458 a_19896_16041.n0 vdd.n37 0.00100138120841899f
CMODEL9459 a_19896_16041.n0 vdd.n38 0.000577643316808656f
CMODEL9460 a_19896_16041.n0 vdd.t19 4.98762674696505e-05f
CMODEL9461 a_19896_16041.n0 vdd.t18 0.000394246052325572f
CMODEL9462 a_19896_16041.n0 vdd.n39 0.000487450936606056f
CMODEL9463 a_19896_16041.n0 vdd.t21 4.98767243249853e-05f
CMODEL9464 a_19896_16041.n0 vdd.t20 0.000394246052325572f
CMODEL9465 a_19896_16041.n0 vdd.n40 0.000487450936606056f
CMODEL9466 a_19896_16041.n0 vdd.t11 4.98762674696505e-05f
CMODEL9467 a_19896_16041.n0 vdd.t10 0.000394246052325572f
CMODEL9468 a_19896_16041.n0 vdd.n41 0.00209710304348087f
CMODEL9469 a_19896_16041.n0 vdd.n42 0.00401699647113362f
CMODEL9470 a_19896_16041.n0 vdd.n43 0.000487450936606056f
CMODEL9471 a_19896_16041.n0 vdd.t13 4.98762674696505e-05f
CMODEL9472 a_19896_16041.n0 vdd.t12 0.000394246052325572f
CMODEL9473 a_19896_16041.n0 vdd.n44 0.000487450936606056f
CMODEL9474 a_19896_16041.n0 vdd.t23 4.98762674696505e-05f
CMODEL9475 a_19896_16041.n0 vdd.t22 0.000394246052325572f
CMODEL9476 a_19896_16041.n0 vdd.n45 0.000601737867167713f
CMODEL9477 a_19896_16041.n0 vdd.n46 0.00993230909245585f
CMODEL9478 a_19896_16041.t4 vdd 6.48335406484594e-06f
CMODEL9479 a_19896_16041.t4 vdd.n0 0.00217569297883743f
CMODEL9480 a_19896_16041.t4 vdd.n1 0.00020162311731852f
CMODEL9481 a_19896_16041.t4 vdd.t7 1.66210843120784e-05f
CMODEL9482 a_19896_16041.t4 vdd.t6 0.000131381059727349f
CMODEL9483 a_19896_16041.t4 vdd.n2 0.000180803562303299f
CMODEL9484 a_19896_16041.t4 vdd.t27 1.66210843120784e-05f
CMODEL9485 a_19896_16041.t4 vdd.t26 0.000131381059727349f
CMODEL9486 a_19896_16041.t4 vdd.n3 0.00033912048273641f
CMODEL9487 a_19896_16041.t4 vdd.n4 0.000180803562303299f
CMODEL9488 a_19896_16041.t4 vdd.t36 1.66210843120784e-05f
CMODEL9489 a_19896_16041.t4 vdd.t35 0.000131381059727349f
CMODEL9490 a_19896_16041.t4 vdd.n5 0.000257978265285131f
CMODEL9491 a_19896_16041.t4 vdd.t3 2.64763841643657e-05f
CMODEL9492 a_19896_16041.t4 vdd.n6 0.000253313466998723f
CMODEL9493 a_19896_16041.t4 vdd.t2 0.000331984742015654f
CMODEL9494 a_19896_16041.t4 vdd.n7 0.000339577218861058f
CMODEL9495 a_19896_16041.t4 vdd.t25 2.64763841643657e-05f
CMODEL9496 a_19896_16041.t4 vdd.n8 0.000153003556849702f
CMODEL9497 a_19896_16041.t4 vdd.t24 0.000331984742015654f
CMODEL9498 a_19896_16041.t4 vdd.n9 0.000339577218861058f
CMODEL9499 a_19896_16041.t4 vdd.t5 2.64763841643657e-05f
CMODEL9500 a_19896_16041.t4 vdd.n10 0.000453057876391189f
CMODEL9501 a_19896_16041.t4 vdd.t4 0.000332167436465513f
CMODEL9502 a_19896_16041.t4 vdd.n11 0.00109541765191163f
CMODEL9503 a_19896_16041.t4 vdd.n12 0.00270089384857057f
CMODEL9504 a_19896_16041.t4 vdd.n13 0.000204724355604882f
CMODEL9505 a_19896_16041.t4 vdd.t42 1.66210843120784e-05f
CMODEL9506 a_19896_16041.t4 vdd.t41 0.000131381059727349f
CMODEL9507 a_19896_16041.t4 vdd.n14 0.000184063135779539f
CMODEL9508 a_19896_16041.t4 vdd.t9 1.66210843120784e-05f
CMODEL9509 a_19896_16041.t4 vdd.t8 0.000131381059727349f
CMODEL9510 a_19896_16041.t4 vdd.n15 0.000353376739640434f
CMODEL9511 a_19896_16041.t4 vdd.t15 2.79915301351992e-05f
CMODEL9512 a_19896_16041.t4 vdd.n16 0.000220175738701736f
CMODEL9513 a_19896_16041.t4 vdd.t14 0.000377588321608043f
CMODEL9514 a_19896_16041.t4 vdd.n17 0.000308418680437547f
CMODEL9515 a_19896_16041.t4 vdd.t32 0.000377588321608043f
CMODEL9516 a_19896_16041.t4 vdd.n18 0.000304451165968102f
CMODEL9517 a_19896_16041.t4 vdd.t34 2.79915301351992e-05f
CMODEL9518 a_19896_16041.t4 vdd.n19 0.000306585646123958f
CMODEL9519 a_19896_16041.t4 vdd.t33 0.000377588321608043f
CMODEL9520 a_19896_16041.t4 vdd.n20 0.000611836100310195f
CMODEL9521 a_19896_16041.t4 vdd.t48 0.000378309964684988f
CMODEL9522 a_19896_16041.t4 vdd.n21 0.00108607587570883f
CMODEL9523 a_19896_16041.t4 vdd.n22 0.00475958625681057f
CMODEL9524 a_19896_16041.t4 vdd.t47 5.38106710161959e-06f
CMODEL9525 a_19896_16041.t4 vdd.t45 5.32581725507463e-06f
CMODEL9526 a_19896_16041.t4 vdd.n23 6.08147194876785e-05f
CMODEL9527 a_19896_16041.t4 vdd.t46 0.000145137647311008f
CMODEL9528 a_19896_16041.t4 vdd.n24 0.000155937325223693f
CMODEL9529 a_19896_16041.t4 vdd.t44 0.000145137647311008f
CMODEL9530 a_19896_16041.t4 vdd.n25 0.000245928043863159f
CMODEL9531 a_19896_16041.t4 vdd.t43 0.000145452034010141f
CMODEL9532 a_19896_16041.t4 vdd.n26 0.00131585373020442f
CMODEL9533 a_19896_16041.t4 vdd.n27 0.000879675298526484f
CMODEL9534 a_19896_16041.t4 vdd.n28 0.000198703051028268f
CMODEL9535 a_19896_16041.t4 vdd.t29 1.66210843120784e-05f
CMODEL9536 a_19896_16041.t4 vdd.t28 0.000131381059727349f
CMODEL9537 a_19896_16041.t4 vdd.n29 2.96613574069136e-05f
CMODEL9538 a_19896_16041.t4 vdd.n30 9.46262858138968e-06f
CMODEL9539 a_19896_16041.t4 vdd.t38 4.35680589302068e-06f
CMODEL9540 a_19896_16041.t4 vdd.t40 4.35680589302068e-06f
CMODEL9541 a_19896_16041.t4 vdd.t37 8.80380194612192e-05f
CMODEL9542 a_19896_16041.t4 vdd.t39 8.80380194612192e-05f
CMODEL9543 a_19896_16041.t4 vdd.n31 2.85134272802974e-05f
CMODEL9544 a_19896_16041.t4 vdd.n32 0.000344097384041328f
CMODEL9545 a_19896_16041.t4 vdd.n33 0.000174354448223264f
CMODEL9546 a_19896_16041.t4 vdd.t17 1.66210843120784e-05f
CMODEL9547 a_19896_16041.t4 vdd.t16 0.000131381059727349f
CMODEL9548 a_19896_16041.t4 vdd.n34 2.96613574069136e-05f
CMODEL9549 a_19896_16041.t4 vdd.n35 9.46262858138968e-06f
CMODEL9550 a_19896_16041.t4 vdd.t1 4.35680589302068e-06f
CMODEL9551 a_19896_16041.t4 vdd.t31 4.35680589302068e-06f
CMODEL9552 a_19896_16041.t4 vdd.t0 8.80380194612192e-05f
CMODEL9553 a_19896_16041.t4 vdd.t30 8.80380194612192e-05f
CMODEL9554 a_19896_16041.t4 vdd.n36 2.85134272802974e-05f
CMODEL9555 a_19896_16041.t4 vdd.n37 0.000333706637205578f
CMODEL9556 a_19896_16041.t4 vdd.n38 0.000192497529548045f
CMODEL9557 a_19896_16041.t4 vdd.t19 1.66210843120784e-05f
CMODEL9558 a_19896_16041.t4 vdd.t18 0.000131381059727349f
CMODEL9559 a_19896_16041.t4 vdd.n39 0.000162441247638686f
CMODEL9560 a_19896_16041.t4 vdd.t21 1.66212365574532e-05f
CMODEL9561 a_19896_16041.t4 vdd.t20 0.000131381059727349f
CMODEL9562 a_19896_16041.t4 vdd.n40 0.000162441247638686f
CMODEL9563 a_19896_16041.t4 vdd.t11 1.66210843120784e-05f
CMODEL9564 a_19896_16041.t4 vdd.t10 0.000131381059727349f
CMODEL9565 a_19896_16041.t4 vdd.n41 0.000698851944324451f
CMODEL9566 a_19896_16041.t4 vdd.n42 0.00133864943018562f
CMODEL9567 a_19896_16041.t4 vdd.n43 0.000162441247638686f
CMODEL9568 a_19896_16041.t4 vdd.t13 1.66210843120784e-05f
CMODEL9569 a_19896_16041.t4 vdd.t12 0.000131381059727349f
CMODEL9570 a_19896_16041.t4 vdd.n44 0.000162441247638686f
CMODEL9571 a_19896_16041.t4 vdd.t23 1.66210843120784e-05f
CMODEL9572 a_19896_16041.t4 vdd.t22 0.000131381059727349f
CMODEL9573 a_19896_16041.t4 vdd.n45 0.000200526950619363f
CMODEL9574 a_19896_16041.t4 vdd.n46 0.00330990579717669f
CMODEL9575 a_19896_16041.t3 vdd 6.06656106873369e-06f
CMODEL9576 a_19896_16041.t3 vdd.n0 0.00203582500522374f
CMODEL9577 a_19896_16041.t3 vdd.n1 0.000188661446197034f
CMODEL9578 a_19896_16041.t3 vdd.t7 1.5552570783467e-05f
CMODEL9579 a_19896_16041.t3 vdd.t6 0.000122935013904697f
CMODEL9580 a_19896_16041.t3 vdd.n2 0.000169180310250975f
CMODEL9581 a_19896_16041.t3 vdd.t27 1.5552570783467e-05f
CMODEL9582 a_19896_16041.t3 vdd.t26 0.000122935013904697f
CMODEL9583 a_19896_16041.t3 vdd.n3 0.000317319569099881f
CMODEL9584 a_19896_16041.t3 vdd.n4 0.000169180310250975f
CMODEL9585 a_19896_16041.t3 vdd.t36 1.5552570783467e-05f
CMODEL9586 a_19896_16041.t3 vdd.t35 0.000122935013904697f
CMODEL9587 a_19896_16041.t3 vdd.n5 0.000241393711511793f
CMODEL9588 a_19896_16041.t3 vdd.t3 2.47743066020867e-05f
CMODEL9589 a_19896_16041.t3 vdd.n6 0.000237028797395615f
CMODEL9590 a_19896_16041.t3 vdd.t2 0.000310642561116029f
CMODEL9591 a_19896_16041.t3 vdd.n7 0.000317746943197418f
CMODEL9592 a_19896_16041.t3 vdd.t25 2.47743066020867e-05f
CMODEL9593 a_19896_16041.t3 vdd.n8 0.000143167473514226f
CMODEL9594 a_19896_16041.t3 vdd.t24 0.000310642561116029f
CMODEL9595 a_19896_16041.t3 vdd.n9 0.000317746943197418f
CMODEL9596 a_19896_16041.t3 vdd.t5 2.47743066020867e-05f
CMODEL9597 a_19896_16041.t3 vdd.n10 0.000423932311471448f
CMODEL9598 a_19896_16041.t3 vdd.t4 0.000310813510755044f
CMODEL9599 a_19896_16041.t3 vdd.n11 0.00102499694056871f
CMODEL9600 a_19896_16041.t3 vdd.n12 0.00252726247998147f
CMODEL9601 a_19896_16041.t3 vdd.n13 0.00019156331631931f
CMODEL9602 a_19896_16041.t3 vdd.t42 1.5552570783467e-05f
CMODEL9603 a_19896_16041.t3 vdd.t41 0.000122935013904697f
CMODEL9604 a_19896_16041.t3 vdd.n14 0.000172230336727064f
CMODEL9605 a_19896_16041.t3 vdd.t9 1.5552570783467e-05f
CMODEL9606 a_19896_16041.t3 vdd.t8 0.000122935013904697f
CMODEL9607 a_19896_16041.t3 vdd.n15 0.000330659339264335f
CMODEL9608 a_19896_16041.t3 vdd.t15 2.61920489416492e-05f
CMODEL9609 a_19896_16041.t3 vdd.n16 0.000206021382038985f
CMODEL9610 a_19896_16041.t3 vdd.t14 0.000353314440174768f
CMODEL9611 a_19896_16041.t3 vdd.n17 0.000288591482263448f
CMODEL9612 a_19896_16041.t3 vdd.t32 0.000353314440174768f
CMODEL9613 a_19896_16041.t3 vdd.n18 0.000284879025936177f
CMODEL9614 a_19896_16041.t3 vdd.t34 2.61920489416492e-05f
CMODEL9615 a_19896_16041.t3 vdd.n19 0.000286876287552f
CMODEL9616 a_19896_16041.t3 vdd.t33 0.000353314440174768f
CMODEL9617 a_19896_16041.t3 vdd.n20 0.000572503218158866f
CMODEL9618 a_19896_16041.t3 vdd.t48 0.000353989691248876f
CMODEL9619 a_19896_16041.t3 vdd.n21 0.00101625571569375f
CMODEL9620 a_19896_16041.t3 vdd.n22 0.0044536084872195f
CMODEL9621 a_19896_16041.t3 vdd.t47 5.03513642173802e-06f
CMODEL9622 a_19896_16041.t3 vdd.t45 4.9834384017393e-06f
CMODEL9623 a_19896_16041.t3 vdd.n23 5.69051460031093e-05f
CMODEL9624 a_19896_16041.t3 vdd.t46 0.000135807236806445f
CMODEL9625 a_19896_16041.t3 vdd.n24 0.000145912639800739f
CMODEL9626 a_19896_16041.t3 vdd.t44 0.000135807236806445f
CMODEL9627 a_19896_16041.t3 vdd.n25 0.000230118158238443f
CMODEL9628 a_19896_16041.t3 vdd.t43 0.000136101412643583f
CMODEL9629 a_19896_16041.t3 vdd.n26 0.00123126192584329f
CMODEL9630 a_19896_16041.t3 vdd.n27 0.000823123936436482f
CMODEL9631 a_19896_16041.t3 vdd.n28 0.000185929101133448f
CMODEL9632 a_19896_16041.t3 vdd.t29 1.5552570783467e-05f
CMODEL9633 a_19896_16041.t3 vdd.t28 0.000122935013904697f
CMODEL9634 a_19896_16041.t3 vdd.n29 2.77545286422443e-05f
CMODEL9635 a_19896_16041.t3 vdd.n30 8.85430806116393e-06f
CMODEL9636 a_19896_16041.t3 vdd.t38 4.07672151640492e-06f
CMODEL9637 a_19896_16041.t3 vdd.t40 4.07672151640492e-06f
CMODEL9638 a_19896_16041.t3 vdd.t37 8.23783517127014e-05f
CMODEL9639 a_19896_16041.t3 vdd.t39 8.23783517127014e-05f
CMODEL9640 a_19896_16041.t3 vdd.n31 2.66803950771014e-05f
CMODEL9641 a_19896_16041.t3 vdd.n32 0.000321976522182709f
CMODEL9642 a_19896_16041.t3 vdd.n33 0.000163145787993754f
CMODEL9643 a_19896_16041.t3 vdd.t17 1.5552570783467e-05f
CMODEL9644 a_19896_16041.t3 vdd.t16 0.000122935013904697f
CMODEL9645 a_19896_16041.t3 vdd.n34 2.77545286422443e-05f
CMODEL9646 a_19896_16041.t3 vdd.n35 8.85430806116393e-06f
CMODEL9647 a_19896_16041.t3 vdd.t1 4.07672151640492e-06f
CMODEL9648 a_19896_16041.t3 vdd.t31 4.07672151640492e-06f
CMODEL9649 a_19896_16041.t3 vdd.t0 8.23783517127014e-05f
CMODEL9650 a_19896_16041.t3 vdd.t30 8.23783517127014e-05f
CMODEL9651 a_19896_16041.t3 vdd.n36 2.66803950771014e-05f
CMODEL9652 a_19896_16041.t3 vdd.n37 0.000312253761463743f
CMODEL9653 a_19896_16041.t3 vdd.n38 0.000180122511728246f
CMODEL9654 a_19896_16041.t3 vdd.t19 1.5552570783467e-05f
CMODEL9655 a_19896_16041.t3 vdd.t18 0.000122935013904697f
CMODEL9656 a_19896_16041.t3 vdd.n39 0.000151998446949665f
CMODEL9657 a_19896_16041.t3 vdd.t21 1.55527132414995e-05f
CMODEL9658 a_19896_16041.t3 vdd.t20 0.000122935013904697f
CMODEL9659 a_19896_16041.t3 vdd.n40 0.000151998446949665f
CMODEL9660 a_19896_16041.t3 vdd.t11 1.5552570783467e-05f
CMODEL9661 a_19896_16041.t3 vdd.t10 0.000122935013904697f
CMODEL9662 a_19896_16041.t3 vdd.n41 0.00065392510664128f
CMODEL9663 a_19896_16041.t3 vdd.n42 0.00125259216705136f
CMODEL9664 a_19896_16041.t3 vdd.n43 0.000151998446949665f
CMODEL9665 a_19896_16041.t3 vdd.t13 1.5552570783467e-05f
CMODEL9666 a_19896_16041.t3 vdd.t12 0.000122935013904697f
CMODEL9667 a_19896_16041.t3 vdd.n44 0.000151998446949665f
CMODEL9668 a_19896_16041.t3 vdd.t23 1.5552570783467e-05f
CMODEL9669 a_19896_16041.t3 vdd.t22 0.000122935013904697f
CMODEL9670 a_19896_16041.t3 vdd.n45 0.000187635748362946f
CMODEL9671 a_19896_16041.t3 vdd.n46 0.00309712310163724f
CMODEL9672 a_19896_16041.t0 vdd 6.10066916433332e-06f
CMODEL9673 a_19896_16041.t0 vdd.n0 0.00204727104740737f
CMODEL9674 a_19896_16041.t0 vdd.n1 0.000189722159601209f
CMODEL9675 a_19896_16041.t0 vdd.t7 1.56400121798516e-05f
CMODEL9676 a_19896_16041.t0 vdd.t6 0.000123626192837753f
CMODEL9677 a_19896_16041.t0 vdd.n2 0.000170131494641973f
CMODEL9678 a_19896_16041.t0 vdd.t27 1.56400121798516e-05f
CMODEL9679 a_19896_16041.t0 vdd.t26 0.000123626192837753f
CMODEL9680 a_19896_16041.t0 vdd.n3 0.000319103638538212f
CMODEL9681 a_19896_16041.t0 vdd.n4 0.000170131494641973f
CMODEL9682 a_19896_16041.t0 vdd.t36 1.56400121798516e-05f
CMODEL9683 a_19896_16041.t0 vdd.t35 0.000123626192837753f
CMODEL9684 a_19896_16041.t0 vdd.n5 0.000242750902133648f
CMODEL9685 a_19896_16041.t0 vdd.t3 2.49135954691111e-05f
CMODEL9686 a_19896_16041.t0 vdd.n6 0.000238361447110971f
CMODEL9687 a_19896_16041.t0 vdd.t2 0.000312389090336095f
CMODEL9688 a_19896_16041.t0 vdd.n7 0.00031953341546602f
CMODEL9689 a_19896_16041.t0 vdd.t25 2.49135954691111e-05f
CMODEL9690 a_19896_16041.t0 vdd.n8 0.000143972405636075f
CMODEL9691 a_19896_16041.t0 vdd.t24 0.000312389090336095f
CMODEL9692 a_19896_16041.t0 vdd.n9 0.00031953341546602f
CMODEL9693 a_19896_16041.t0 vdd.t5 2.49135954691111e-05f
CMODEL9694 a_19896_16041.t0 vdd.n10 0.000426315790949131f
CMODEL9695 a_19896_16041.t0 vdd.t4 0.000312561001107219f
CMODEL9696 a_19896_16041.t0 vdd.n11 0.00103075979257698f
CMODEL9697 a_19896_16041.t0 vdd.n12 0.0025414715366935f
CMODEL9698 a_19896_16041.t0 vdd.n13 0.000192640344941024f
CMODEL9699 a_19896_16041.t0 vdd.t42 1.56400121798516e-05f
CMODEL9700 a_19896_16041.t0 vdd.t41 0.000123626192837753f
CMODEL9701 a_19896_16041.t0 vdd.n14 0.000173198669316761f
CMODEL9702 a_19896_16041.t0 vdd.t9 1.56400121798516e-05f
CMODEL9703 a_19896_16041.t0 vdd.t8 0.000123626192837753f
CMODEL9704 a_19896_16041.t0 vdd.n15 0.000332518409044851f
CMODEL9705 a_19896_16041.t0 vdd.t15 2.63393087976253e-05f
CMODEL9706 a_19896_16041.t0 vdd.n16 0.00020717969840876f
CMODEL9707 a_19896_16041.t0 vdd.t14 0.000355300883987939f
CMODEL9708 a_19896_16041.t0 vdd.n17 0.000290214033450975f
CMODEL9709 a_19896_16041.t0 vdd.t32 0.000355300883987939f
CMODEL9710 a_19896_16041.t0 vdd.n18 0.000286480704538085f
CMODEL9711 a_19896_16041.t0 vdd.t34 2.63393087976253e-05f
CMODEL9712 a_19896_16041.t0 vdd.n19 0.000288489195380707f
CMODEL9713 a_19896_16041.t0 vdd.t33 0.000355300883987939f
CMODEL9714 a_19896_16041.t0 vdd.n20 0.000575722009542456f
CMODEL9715 a_19896_16041.t0 vdd.t48 0.000355979931533876f
CMODEL9716 a_19896_16041.t0 vdd.n21 0.00102196942181355f
CMODEL9717 a_19896_16041.t0 vdd.n22 0.00447864806109412f
CMODEL9718 a_19896_16041.t0 vdd.t47 5.06344552676211e-06f
CMODEL9719 a_19896_16041.t0 vdd.t45 5.01145684439497e-06f
CMODEL9720 a_19896_16041.t0 vdd.n23 5.72250844555529e-05f
CMODEL9721 a_19896_16041.t0 vdd.t46 0.00013657078738537f
CMODEL9722 a_19896_16041.t0 vdd.n24 0.00014673300610236f
CMODEL9723 a_19896_16041.t0 vdd.t44 0.00013657078738537f
CMODEL9724 a_19896_16041.t0 vdd.n25 0.00023141195418832f
CMODEL9725 a_19896_16041.t0 vdd.t43 0.000136866617170678f
CMODEL9726 a_19896_16041.t0 vdd.n26 0.00123818446383459f
CMODEL9727 a_19896_16041.t0 vdd.n27 0.000827751795547473f
CMODEL9728 a_19896_16041.t0 vdd.n28 0.000186974452442759f
CMODEL9729 a_19896_16041.t0 vdd.t29 1.56400121798516e-05f
CMODEL9730 a_19896_16041.t0 vdd.t28 0.000123626192837753f
CMODEL9731 a_19896_16041.t0 vdd.n29 2.79105732456905e-05f
CMODEL9732 a_19896_16041.t0 vdd.n30 8.90408973852563e-06f
CMODEL9733 a_19896_16041.t0 vdd.t38 4.09964211435806e-06f
CMODEL9734 a_19896_16041.t0 vdd.t40 4.09964211435806e-06f
CMODEL9735 a_19896_16041.t0 vdd.t37 8.28415084606056e-05f
CMODEL9736 a_19896_16041.t0 vdd.t39 8.28415084606056e-05f
CMODEL9737 a_19896_16041.t0 vdd.n31 2.68304005671337e-05f
CMODEL9738 a_19896_16041.t0 vdd.n32 0.000323786774461557f
CMODEL9739 a_19896_16041.t0 vdd.n33 0.000164063044421328f
CMODEL9740 a_19896_16041.t0 vdd.t17 1.56400121798516e-05f
CMODEL9741 a_19896_16041.t0 vdd.t16 0.000123626192837753f
CMODEL9742 a_19896_16041.t0 vdd.n34 2.79105732456905e-05f
CMODEL9743 a_19896_16041.t0 vdd.n35 8.90408973852563e-06f
CMODEL9744 a_19896_16041.t0 vdd.t1 4.09964211435806e-06f
CMODEL9745 a_19896_16041.t0 vdd.t31 4.09964211435806e-06f
CMODEL9746 a_19896_16041.t0 vdd.t0 8.28415084606056e-05f
CMODEL9747 a_19896_16041.t0 vdd.t30 8.28415084606056e-05f
CMODEL9748 a_19896_16041.t0 vdd.n36 2.68304005671337e-05f
CMODEL9749 a_19896_16041.t0 vdd.n37 0.000314009349353931f
CMODEL9750 a_19896_16041.t0 vdd.n38 0.000181135216583611f
CMODEL9751 a_19896_16041.t0 vdd.t19 1.56400121798516e-05f
CMODEL9752 a_19896_16041.t0 vdd.t18 0.000123626192837753f
CMODEL9753 a_19896_16041.t0 vdd.n39 0.000152853029554343f
CMODEL9754 a_19896_16041.t0 vdd.t21 1.56401554388275e-05f
CMODEL9755 a_19896_16041.t0 vdd.t20 0.000123626192837753f
CMODEL9756 a_19896_16041.t0 vdd.n40 0.000152853029554343f
CMODEL9757 a_19896_16041.t0 vdd.t11 1.56400121798516e-05f
CMODEL9758 a_19896_16041.t0 vdd.t10 0.000123626192837753f
CMODEL9759 a_19896_16041.t0 vdd.n41 0.000657601677238628f
CMODEL9760 a_19896_16041.t0 vdd.n42 0.00125963463030147f
CMODEL9761 a_19896_16041.t0 vdd.n43 0.000152853029554343f
CMODEL9762 a_19896_16041.t0 vdd.t13 1.56400121798516e-05f
CMODEL9763 a_19896_16041.t0 vdd.t12 0.000123626192837753f
CMODEL9764 a_19896_16041.t0 vdd.n44 0.000152853029554343f
CMODEL9765 a_19896_16041.t0 vdd.t23 1.56400121798516e-05f
CMODEL9766 a_19896_16041.t0 vdd.t22 0.000123626192837753f
CMODEL9767 a_19896_16041.t0 vdd.n45 0.000188690694974471f
CMODEL9768 a_19896_16041.t0 vdd.n46 0.00311453609223234f
CMODEL9769 a_19896_16041.n1 vdd 0.00018425986454447f
CMODEL9770 a_19896_16041.n1 vdd.n0 0.0618341817462447f
CMODEL9771 a_19896_16041.n1 vdd.n1 0.00573022048689037f
CMODEL9772 a_19896_16041.n1 vdd.t7 0.000472378758478085f
CMODEL9773 a_19896_16041.n1 vdd.t6 0.00373390933565272f
CMODEL9774 a_19896_16041.n1 vdd.n2 0.00513851928584361f
CMODEL9775 a_19896_16041.n1 vdd.t27 0.000472378758478085f
CMODEL9776 a_19896_16041.n1 vdd.t26 0.00373390933565272f
CMODEL9777 a_19896_16041.n1 vdd.n3 0.00963795800573032f
CMODEL9778 a_19896_16041.n1 vdd.n4 0.00513851928584361f
CMODEL9779 a_19896_16041.n1 vdd.t36 0.000472378758478085f
CMODEL9780 a_19896_16041.n1 vdd.t35 0.00373390933565272f
CMODEL9781 a_19896_16041.n1 vdd.n5 0.00733185936498522f
CMODEL9782 a_19896_16041.n1 vdd.t3 0.000752470852425874f
CMODEL9783 a_19896_16041.n1 vdd.n6 0.00719928368088962f
CMODEL9784 a_19896_16041.n1 vdd.t2 0.00943515701638434f
CMODEL9785 a_19896_16041.n1 vdd.n7 0.00965093865365091f
CMODEL9786 a_19896_16041.n1 vdd.t25 0.000752470852425874f
CMODEL9787 a_19896_16041.n1 vdd.n8 0.00434843051574388f
CMODEL9788 a_19896_16041.n1 vdd.t24 0.00943515701638434f
CMODEL9789 a_19896_16041.n1 vdd.n9 0.00965093865365091f
CMODEL9790 a_19896_16041.n1 vdd.t5 0.000752470852425874f
CMODEL9791 a_19896_16041.n1 vdd.n10 0.012876110436f
CMODEL9792 a_19896_16041.n1 vdd.t4 0.00944034927555258f
CMODEL9793 a_19896_16041.n1 vdd.n11 0.0311322667468193f
CMODEL9794 a_19896_16041.n1 vdd.n12 0.0767606287901278f
CMODEL9795 a_19896_16041.n1 vdd.n13 0.00581835908627116f
CMODEL9796 a_19896_16041.n1 vdd.t42 0.000472378758478085f
CMODEL9797 a_19896_16041.n1 vdd.t41 0.00373390933565272f
CMODEL9798 a_19896_16041.n1 vdd.n14 0.0052311578431702f
CMODEL9799 a_19896_16041.n1 vdd.t9 0.000472378758478085f
CMODEL9800 a_19896_16041.n1 vdd.t8 0.00373390933565272f
CMODEL9801 a_19896_16041.n1 vdd.n15 0.0100431272961582f
CMODEL9802 a_19896_16041.n1 vdd.t15 0.000795531988461101f
CMODEL9803 a_19896_16041.n1 vdd.n16 0.00625749440542462f
CMODEL9804 a_19896_16041.n1 vdd.t14 0.0107312314424286f
CMODEL9805 a_19896_16041.n1 vdd.n17 0.00876539885250845f
CMODEL9806 a_19896_16041.n1 vdd.t32 0.0107312314424286f
CMODEL9807 a_19896_16041.n1 vdd.n18 0.00865264029090495f
CMODEL9808 a_19896_16041.n1 vdd.t34 0.000795531988461101f
CMODEL9809 a_19896_16041.n1 vdd.n19 0.0087133031855205f
CMODEL9810 a_19896_16041.n1 vdd.t33 0.0107312314424286f
CMODEL9811 a_19896_16041.n1 vdd.n20 0.0173886596102865f
CMODEL9812 a_19896_16041.n1 vdd.t48 0.0107517408661431f
CMODEL9813 a_19896_16041.n1 vdd.n21 0.0308667692280169f
CMODEL9814 a_19896_16041.n1 vdd.n22 0.135269601227382f
CMODEL9815 a_19896_16041.n1 vdd.t47 0.000152932368852925f
CMODEL9816 a_19896_16041.n1 vdd.t45 0.000151362143142798f
CMODEL9817 a_19896_16041.n1 vdd.n23 0.00172838192439145f
CMODEL9818 a_19896_16041.n1 vdd.t46 0.00412487779725552f
CMODEL9819 a_19896_16041.n1 vdd.n24 0.00443180954422045f
CMODEL9820 a_19896_16041.n1 vdd.t44 0.00412487779725552f
CMODEL9821 a_19896_16041.n1 vdd.n25 0.00698938660401372f
CMODEL9822 a_19896_16041.n1 vdd.t43 0.00413381280990753f
CMODEL9823 a_19896_16041.n1 vdd.n26 0.0373971601215586f
CMODEL9824 a_19896_16041.n1 vdd.n27 0.0250007711638772f
CMODEL9825 a_19896_16041.n1 vdd.n28 0.00564723087785142f
CMODEL9826 a_19896_16041.n1 vdd.t29 0.000472378758478085f
CMODEL9827 a_19896_16041.n1 vdd.t28 0.00373390933565272f
CMODEL9828 a_19896_16041.n1 vdd.n29 0.000842989237258768f
CMODEL9829 a_19896_16041.n1 vdd.n30 0.000268932198242196f
CMODEL9830 a_19896_16041.n1 vdd.t38 0.00012382240051448f
CMODEL9831 a_19896_16041.n1 vdd.t40 0.00012382240051448f
CMODEL9832 a_19896_16041.n1 vdd.t37 0.00250208046305013f
CMODEL9833 a_19896_16041.n1 vdd.t39 0.00250208046305013f
CMODEL9834 a_19896_16041.n1 vdd.n31 0.000810364542151692f
CMODEL9835 a_19896_16041.n1 vdd.n32 0.00977940379923832f
CMODEL9836 a_19896_16041.n1 vdd.n33 0.00495523253720492f
CMODEL9837 a_19896_16041.n1 vdd.t17 0.000472378758478085f
CMODEL9838 a_19896_16041.n1 vdd.t16 0.00373390933565272f
CMODEL9839 a_19896_16041.n1 vdd.n34 0.000842989237258768f
CMODEL9840 a_19896_16041.n1 vdd.n35 0.000268932198242196f
CMODEL9841 a_19896_16041.n1 vdd.t1 0.00012382240051448f
CMODEL9842 a_19896_16041.n1 vdd.t31 0.00012382240051448f
CMODEL9843 a_19896_16041.n1 vdd.t0 0.00250208046305013f
CMODEL9844 a_19896_16041.n1 vdd.t30 0.00250208046305013f
CMODEL9845 a_19896_16041.n1 vdd.n36 0.000810364542151692f
CMODEL9846 a_19896_16041.n1 vdd.n37 0.00948409405904496f
CMODEL9847 a_19896_16041.n1 vdd.n38 0.00547086714143704f
CMODEL9848 a_19896_16041.n1 vdd.t19 0.000472378758478085f
CMODEL9849 a_19896_16041.n1 vdd.t18 0.00373390933565272f
CMODEL9850 a_19896_16041.n1 vdd.n39 0.00461665397060961f
CMODEL9851 a_19896_16041.n1 vdd.t21 0.000472383085360726f
CMODEL9852 a_19896_16041.n1 vdd.t20 0.00373390933565272f
CMODEL9853 a_19896_16041.n1 vdd.n40 0.00461665397060961f
CMODEL9854 a_19896_16041.n1 vdd.t11 0.000472378758478085f
CMODEL9855 a_19896_16041.n1 vdd.t10 0.00373390933565272f
CMODEL9856 a_19896_16041.n1 vdd.n41 0.0198616893832903f
CMODEL9857 a_19896_16041.n1 vdd.n42 0.0380450242592751f
CMODEL9858 a_19896_16041.n1 vdd.n43 0.00461665397060961f
CMODEL9859 a_19896_16041.n1 vdd.t13 0.000472378758478085f
CMODEL9860 a_19896_16041.n1 vdd.t12 0.00373390933565272f
CMODEL9861 a_19896_16041.n1 vdd.n44 0.00461665397060961f
CMODEL9862 a_19896_16041.n1 vdd.t23 0.000472378758478085f
CMODEL9863 a_19896_16041.n1 vdd.t22 0.00373390933565272f
CMODEL9864 a_19896_16041.n1 vdd.n45 0.00569906693188096f
CMODEL9865 a_19896_16041.n1 vdd.n46 0.0940690247274387f
CMODEL9866 a_20000_14483.t0 vdd 6.88084005052963e-06f
CMODEL9867 a_20000_14483.t0 vdd.n0 0.00230908187902528f
CMODEL9868 a_20000_14483.t0 vdd.n1 0.000213984367795108f
CMODEL9869 a_20000_14483.t0 vdd.t7 1.76401013231561e-05f
CMODEL9870 a_20000_14483.t0 vdd.t6 0.000139435861224163f
CMODEL9871 a_20000_14483.t0 vdd.n2 0.000191888393003341f
CMODEL9872 a_20000_14483.t0 vdd.t27 1.76401013231561e-05f
CMODEL9873 a_20000_14483.t0 vdd.t26 0.000139435861224163f
CMODEL9874 a_20000_14483.t0 vdd.n3 0.00035991151743817f
CMODEL9875 a_20000_14483.t0 vdd.n4 0.000191888393003341f
CMODEL9876 a_20000_14483.t0 vdd.t36 1.76401013231561e-05f
CMODEL9877 a_20000_14483.t0 vdd.t35 0.000139435861224163f
CMODEL9878 a_20000_14483.t0 vdd.n5 0.000273794576416099f
CMODEL9879 a_20000_14483.t0 vdd.t3 2.80996167615142e-05f
CMODEL9880 a_20000_14483.t0 vdd.n6 0.000268843785428021f
CMODEL9881 a_20000_14483.t0 vdd.t2 0.000352338293756341f
CMODEL9882 a_20000_14483.t0 vdd.n7 0.000360396255459196f
CMODEL9883 a_20000_14483.t0 vdd.t25 2.80996167615142e-05f
CMODEL9884 a_20000_14483.t0 vdd.n8 0.000162384005456894f
CMODEL9885 a_20000_14483.t0 vdd.t24 0.000352338293756341f
CMODEL9886 a_20000_14483.t0 vdd.n9 0.000360396255459196f
CMODEL9887 a_20000_14483.t0 vdd.t5 2.80996167615142e-05f
CMODEL9888 a_20000_14483.t0 vdd.n10 0.000480834264163309f
CMODEL9889 a_20000_14483.t0 vdd.t4 0.000352532188964751f
CMODEL9890 a_20000_14483.t0 vdd.n11 0.00116257628010785f
CMODEL9891 a_20000_14483.t0 vdd.n12 0.00286648212940305f
CMODEL9892 a_20000_14483.t0 vdd.n13 0.000217275738957875f
CMODEL9893 a_20000_14483.t0 vdd.t42 1.76401013231561e-05f
CMODEL9894 a_20000_14483.t0 vdd.t41 0.000139435861224163f
CMODEL9895 a_20000_14483.t0 vdd.n14 0.000195347806680063f
CMODEL9896 a_20000_14483.t0 vdd.t9 1.76401013231561e-05f
CMODEL9897 a_20000_14483.t0 vdd.t8 0.000139435861224163f
CMODEL9898 a_20000_14483.t0 vdd.n15 0.000375041806867794f
CMODEL9899 a_20000_14483.t0 vdd.t15 2.97076543565977e-05f
CMODEL9900 a_20000_14483.t0 vdd.n16 0.000233674426209183f
CMODEL9901 a_20000_14483.t0 vdd.t14 0.000400737769362381f
CMODEL9902 a_20000_14483.t0 vdd.n17 0.000327327427664804f
CMODEL9903 a_20000_14483.t0 vdd.t32 0.000400737769362381f
CMODEL9904 a_20000_14483.t0 vdd.n18 0.000323116670055492f
CMODEL9905 a_20000_14483.t0 vdd.t34 2.97076543565977e-05f
CMODEL9906 a_20000_14483.t0 vdd.n19 0.000325382012407087f
CMODEL9907 a_20000_14483.t0 vdd.t33 0.000400737769362381f
CMODEL9908 a_20000_14483.t0 vdd.n20 0.000649346973999374f
CMODEL9909 a_20000_14483.t0 vdd.t48 0.000401503655435602f
CMODEL9910 a_20000_14483.t0 vdd.n21 0.00115266177178446f
CMODEL9911 a_20000_14483.t0 vdd.n22 0.00505139028537551f
CMODEL9912 a_20000_14483.t0 vdd.t47 5.71097331058555e-06f
CMODEL9913 a_20000_14483.t0 vdd.t45 5.65233616797544e-06f
CMODEL9914 a_20000_14483.t0 vdd.n23 6.45431906582888e-05f
CMODEL9915 a_20000_14483.t0 vdd.t46 0.000154035847258784f
CMODEL9916 a_20000_14483.t0 vdd.n24 0.000165497639345284f
CMODEL9917 a_20000_14483.t0 vdd.t44 0.000154035847258784f
CMODEL9918 a_20000_14483.t0 vdd.n25 0.000261005571628031f
CMODEL9919 a_20000_14483.t0 vdd.t43 0.000154369508596591f
CMODEL9920 a_20000_14483.t0 vdd.n26 0.00139652700698902f
CMODEL9921 a_20000_14483.t0 vdd.n27 0.000933607044289425f
CMODEL9922 a_20000_14483.t0 vdd.n28 0.000210885276047349f
CMODEL9923 a_20000_14483.t0 vdd.t29 1.76401013231561e-05f
CMODEL9924 a_20000_14483.t0 vdd.t28 0.000139435861224163f
CMODEL9925 a_20000_14483.t0 vdd.n29 3.14798565614686e-05f
CMODEL9926 a_20000_14483.t0 vdd.n30 1.0042770003748e-05f
CMODEL9927 a_20000_14483.t0 vdd.t38 4.62391598256674e-06f
CMODEL9928 a_20000_14483.t0 vdd.t40 4.62391598256674e-06f
CMODEL9929 a_20000_14483.t0 vdd.t37 9.34355156635208e-05f
CMODEL9930 a_20000_14483.t0 vdd.t39 9.34355156635208e-05f
CMODEL9931 a_20000_14483.t0 vdd.n31 3.026154833529e-05f
CMODEL9932 a_20000_14483.t0 vdd.n32 0.00036519354607395f
CMODEL9933 a_20000_14483.t0 vdd.n33 0.000185043892146454f
CMODEL9934 a_20000_14483.t0 vdd.t17 1.76401013231561e-05f
CMODEL9935 a_20000_14483.t0 vdd.t16 0.000139435861224163f
CMODEL9936 a_20000_14483.t0 vdd.n34 3.14798565614686e-05f
CMODEL9937 a_20000_14483.t0 vdd.n35 1.0042770003748e-05f
CMODEL9938 a_20000_14483.t0 vdd.t1 4.62391598256674e-06f
CMODEL9939 a_20000_14483.t0 vdd.t31 4.62391598256674e-06f
CMODEL9940 a_20000_14483.t0 vdd.t0 9.34355156635208e-05f
CMODEL9941 a_20000_14483.t0 vdd.t30 9.34355156635208e-05f
CMODEL9942 a_20000_14483.t0 vdd.n36 3.026154833529e-05f
CMODEL9943 a_20000_14483.t0 vdd.n37 0.000354165756095609f
CMODEL9944 a_20000_14483.t0 vdd.n38 0.000204299302135009f
CMODEL9945 a_20000_14483.t0 vdd.t19 1.76401013231561e-05f
CMODEL9946 a_20000_14483.t0 vdd.t18 0.000139435861224163f
CMODEL9947 a_20000_14483.t0 vdd.n39 0.000172400308764694f
CMODEL9948 a_20000_14483.t0 vdd.t21 1.76402629024965e-05f
CMODEL9949 a_20000_14483.t0 vdd.t20 0.000139435861224163f
CMODEL9950 a_20000_14483.t0 vdd.n40 0.000172400308764694f
CMODEL9951 a_20000_14483.t0 vdd.t11 1.76401013231561e-05f
CMODEL9952 a_20000_14483.t0 vdd.t10 0.000139435861224163f
CMODEL9953 a_20000_14483.t0 vdd.n41 0.000741697645971839f
CMODEL9954 a_20000_14483.t0 vdd.n42 0.00142072028161842f
CMODEL9955 a_20000_14483.t0 vdd.n43 0.000172400308764694f
CMODEL9956 a_20000_14483.t0 vdd.t13 1.76401013231561e-05f
CMODEL9957 a_20000_14483.t0 vdd.t12 0.000139435861224163f
CMODEL9958 a_20000_14483.t0 vdd.n44 0.000172400308764694f
CMODEL9959 a_20000_14483.t0 vdd.t23 1.76401013231561e-05f
CMODEL9960 a_20000_14483.t0 vdd.t22 0.000139435861224163f
CMODEL9961 a_20000_14483.t0 vdd.n45 0.000212820996544646f
CMODEL9962 a_20000_14483.t0 vdd.n46 0.00351283180663908f
CMODEL9963 a_20000_14483.t1 vdd 3.25780121148487e-06f
CMODEL9964 a_20000_14483.t1 vdd.n0 0.00109325746386552f
CMODEL9965 a_20000_14483.t1 vdd.n1 0.000101312997762253f
CMODEL9966 a_20000_14483.t1 vdd.t7 8.35187899141333e-06f
CMODEL9967 a_20000_14483.t1 vdd.t6 6.60172761297581e-05f
CMODEL9968 a_20000_14483.t1 vdd.n2 9.08514417724404e-05f
CMODEL9969 a_20000_14483.t1 vdd.t27 8.35187899141333e-06f
CMODEL9970 a_20000_14483.t1 vdd.t26 6.60172761297581e-05f
CMODEL9971 a_20000_14483.t1 vdd.n3 0.000170403638062649f
CMODEL9972 a_20000_14483.t1 vdd.n4 9.08514417724404e-05f
CMODEL9973 a_20000_14483.t1 vdd.t36 8.35187899141333e-06f
CMODEL9974 a_20000_14483.t1 vdd.t35 6.60172761297581e-05f
CMODEL9975 a_20000_14483.t1 vdd.n5 0.000129630727672226f
CMODEL9976 a_20000_14483.t1 vdd.t3 1.33040391661008e-05f
CMODEL9977 a_20000_14483.t1 vdd.n6 0.00012728672711992f
CMODEL9978 a_20000_14483.t1 vdd.t2 0.000166818021029797f
CMODEL9979 a_20000_14483.t1 vdd.n7 0.000170633142033175f
CMODEL9980 a_20000_14483.t1 vdd.t25 1.33040391661008e-05f
CMODEL9981 a_20000_14483.t1 vdd.n8 7.68823000997551e-05f
CMODEL9982 a_20000_14483.t1 vdd.t24 0.000166818021029797f
CMODEL9983 a_20000_14483.t1 vdd.n9 0.000170633142033175f
CMODEL9984 a_20000_14483.t1 vdd.t5 1.33040391661008e-05f
CMODEL9985 a_20000_14483.t1 vdd.n10 0.000227655698550076f
CMODEL9986 a_20000_14483.t1 vdd.t4 0.000166909822618007f
CMODEL9987 a_20000_14483.t1 vdd.n11 0.000550433142750847f
CMODEL9988 a_20000_14483.t1 vdd.n12 0.00135716407957342f
CMODEL9989 a_20000_14483.t1 vdd.n13 0.000102871329722125f
CMODEL9990 a_20000_14483.t1 vdd.t42 8.35187899141333e-06f
CMODEL9991 a_20000_14483.t1 vdd.t41 6.60172761297581e-05f
CMODEL9992 a_20000_14483.t1 vdd.n14 9.24893351087613e-05f
CMODEL9993 a_20000_14483.t1 vdd.t9 8.35187899141333e-06f
CMODEL9994 a_20000_14483.t1 vdd.t8 6.60172761297581e-05f
CMODEL9995 a_20000_14483.t1 vdd.n15 0.000177567221996002f
CMODEL9996 a_20000_14483.t1 vdd.t15 1.40653803376592e-05f
CMODEL9997 a_20000_14483.t1 vdd.n16 0.000110635449045021f
CMODEL9998 a_20000_14483.t1 vdd.t14 0.000189733227473587f
CMODEL9999 a_20000_14483.t1 vdd.n17 0.000154976381163888f
CMODEL10000 a_20000_14483.t1 vdd.t32 0.000189733227473587f
CMODEL10001 a_20000_14483.t1 vdd.n18 0.000152982756673252f
CMODEL10002 a_20000_14483.t1 vdd.t34 1.40653803376592e-05f
CMODEL10003 a_20000_14483.t1 vdd.n19 0.000154055305228843f
CMODEL10004 a_20000_14483.t1 vdd.t33 0.000189733227473587f
CMODEL10005 a_20000_14483.t1 vdd.n20 0.000307439693850515f
CMODEL10006 a_20000_14483.t1 vdd.t48 0.000190095843747018f
CMODEL10007 a_20000_14483.t1 vdd.n21 0.000545739021540354f
CMODEL10008 a_20000_14483.t1 vdd.n22 0.00239163027632252f
CMODEL10009 a_20000_14483.t1 vdd.t47 2.70391632901731e-06f
CMODEL10010 a_20000_14483.t1 vdd.t45 2.67615399871601e-06f
CMODEL10011 a_20000_14483.t1 vdd.n23 3.055860667819e-05f
CMODEL10012 a_20000_14483.t1 vdd.t46 7.29297827193556e-05f
CMODEL10013 a_20000_14483.t1 vdd.n24 7.83564806037674e-05f
CMODEL10014 a_20000_14483.t1 vdd.t44 7.29297827193556e-05f
CMODEL10015 a_20000_14483.t1 vdd.n25 0.000123575647916514f
CMODEL10016 a_20000_14483.t1 vdd.t43 7.3087757952401e-05f
CMODEL10017 a_20000_14483.t1 vdd.n26 0.000661199409059067f
CMODEL10018 a_20000_14483.t1 vdd.n27 0.000442025412246399f
CMODEL10019 a_20000_14483.t1 vdd.n28 9.98457023773562e-05f
CMODEL10020 a_20000_14483.t1 vdd.t29 8.35187899141333e-06f
CMODEL10021 a_20000_14483.t1 vdd.t28 6.60172761297581e-05f
CMODEL10022 a_20000_14483.t1 vdd.n29 1.49044468539025e-05f
CMODEL10023 a_20000_14483.t1 vdd.n30 4.75484796109391e-06f
CMODEL10024 a_20000_14483.t1 vdd.t38 2.18923837484795e-06f
CMODEL10025 a_20000_14483.t1 vdd.t40 2.18923837484795e-06f
CMODEL10026 a_20000_14483.t1 vdd.t37 4.42379613374244e-05f
CMODEL10027 a_20000_14483.t1 vdd.t39 4.42379613374244e-05f
CMODEL10028 a_20000_14483.t1 vdd.n31 1.4327626874647e-05f
CMODEL10029 a_20000_14483.t1 vdd.n32 0.000172904466328147f
CMODEL10030 a_20000_14483.t1 vdd.n33 8.76108457086127e-05f
CMODEL10031 a_20000_14483.t1 vdd.t17 8.35187899141333e-06f
CMODEL10032 a_20000_14483.t1 vdd.t16 6.60172761297581e-05f
CMODEL10033 a_20000_14483.t1 vdd.n34 1.49044468539025e-05f
CMODEL10034 a_20000_14483.t1 vdd.n35 4.75484796109391e-06f
CMODEL10035 a_20000_14483.t1 vdd.t1 2.18923837484795e-06f
CMODEL10036 a_20000_14483.t1 vdd.t31 2.18923837484795e-06f
CMODEL10037 a_20000_14483.t1 vdd.t0 4.42379613374244e-05f
CMODEL10038 a_20000_14483.t1 vdd.t30 4.42379613374244e-05f
CMODEL10039 a_20000_14483.t1 vdd.n36 1.4327626874647e-05f
CMODEL10040 a_20000_14483.t1 vdd.n37 0.00016768325099868f
CMODEL10041 a_20000_14483.t1 vdd.n38 9.67275084311423e-05f
CMODEL10042 a_20000_14483.t1 vdd.t19 8.35187899141333e-06f
CMODEL10043 a_20000_14483.t1 vdd.t18 6.60172761297581e-05f
CMODEL10044 a_20000_14483.t1 vdd.n39 8.16246171440583e-05f
CMODEL10045 a_20000_14483.t1 vdd.t21 8.35195549273684e-06f
CMODEL10046 a_20000_14483.t1 vdd.t20 6.60172761297581e-05f
CMODEL10047 a_20000_14483.t1 vdd.n40 8.16246171440583e-05f
CMODEL10048 a_20000_14483.t1 vdd.t11 8.35187899141333e-06f
CMODEL10049 a_20000_14483.t1 vdd.t10 6.60172761297581e-05f
CMODEL10050 a_20000_14483.t1 vdd.n41 0.000351164025301903f
CMODEL10051 a_20000_14483.t1 vdd.n42 0.000672653952228022f
CMODEL10052 a_20000_14483.t1 vdd.n43 8.16246171440583e-05f
CMODEL10053 a_20000_14483.t1 vdd.t13 8.35187899141333e-06f
CMODEL10054 a_20000_14483.t1 vdd.t12 6.60172761297581e-05f
CMODEL10055 a_20000_14483.t1 vdd.n44 8.16246171440583e-05f
CMODEL10056 a_20000_14483.t1 vdd.t23 8.35187899141333e-06f
CMODEL10057 a_20000_14483.t1 vdd.t22 6.60172761297581e-05f
CMODEL10058 a_20000_14483.t1 vdd.n45 0.00010076218823299f
CMODEL10059 a_20000_14483.t1 vdd.n46 0.00166318467387285f
CMODEL10060 a_20000_14483.n0 vdd 8.8428251158936e-06f
CMODEL10061 a_20000_14483.n0 vdd.n0 0.00296748755741356f
CMODEL10062 a_20000_14483.n0 vdd.n1 0.000274999321020629f
CMODEL10063 a_20000_14483.n0 vdd.t7 2.26699545232571e-05f
CMODEL10064 a_20000_14483.n0 vdd.t6 0.000179194244690279f
CMODEL10065 a_20000_14483.n0 vdd.n2 0.000246602956708432f
CMODEL10066 a_20000_14483.n0 vdd.t27 2.26699545232571e-05f
CMODEL10067 a_20000_14483.n0 vdd.t26 0.000179194244690279f
CMODEL10068 a_20000_14483.n0 vdd.n3 0.000462535763443107f
CMODEL10069 a_20000_14483.n0 vdd.n4 0.000246602956708432f
CMODEL10070 a_20000_14483.n0 vdd.t36 2.26699545232571e-05f
CMODEL10071 a_20000_14483.n0 vdd.t35 0.000179194244690279f
CMODEL10072 a_20000_14483.n0 vdd.n5 0.000351863658964341f
CMODEL10073 a_20000_14483.n0 vdd.t3 3.61118693387702e-05f
CMODEL10074 a_20000_14483.n0 vdd.n6 0.00034550121214514f
CMODEL10075 a_20000_14483.n0 vdd.t2 0.000452803130204989f
CMODEL10076 a_20000_14483.n0 vdd.n7 0.000463158718418877f
CMODEL10077 a_20000_14483.n0 vdd.t25 3.61118693387702e-05f
CMODEL10078 a_20000_14483.n0 vdd.n8 0.00020868576384988f
CMODEL10079 a_20000_14483.n0 vdd.t24 0.000452803130204989f
CMODEL10080 a_20000_14483.n0 vdd.n9 0.000463158718418877f
CMODEL10081 a_20000_14483.n0 vdd.t5 3.61118693387702e-05f
CMODEL10082 a_20000_14483.n0 vdd.n10 0.000617938111698767f
CMODEL10083 a_20000_14483.n0 vdd.t4 0.000453052312195297f
CMODEL10084 a_20000_14483.n0 vdd.n11 0.00149407029568847f
CMODEL10085 a_20000_14483.n0 vdd.n12 0.00368382348405183f
CMODEL10086 a_20000_14483.n0 vdd.n13 0.000279229185306109f
CMODEL10087 a_20000_14483.n0 vdd.t42 2.26699545232571e-05f
CMODEL10088 a_20000_14483.n0 vdd.t41 0.000179194244690279f
CMODEL10089 a_20000_14483.n0 vdd.n14 0.000251048778718847f
CMODEL10090 a_20000_14483.n0 vdd.t9 2.26699545232571e-05f
CMODEL10091 a_20000_14483.n0 vdd.t8 0.000179194244690279f
CMODEL10092 a_20000_14483.n0 vdd.n15 0.000481980264753484f
CMODEL10093 a_20000_14483.n0 vdd.t15 3.81784186450588e-05f
CMODEL10094 a_20000_14483.n0 vdd.n16 0.000300303752136419f
CMODEL10095 a_20000_14483.n0 vdd.t14 0.000515003108019068f
CMODEL10096 a_20000_14483.n0 vdd.n17 0.000420660729971827f
CMODEL10097 a_20000_14483.n0 vdd.t32 0.000515003108019068f
CMODEL10098 a_20000_14483.n0 vdd.n18 0.000415249327748969f
CMODEL10099 a_20000_14483.n0 vdd.t34 3.81784186450588e-05f
CMODEL10100 a_20000_14483.n0 vdd.n19 0.000418160604002402f
CMODEL10101 a_20000_14483.n0 vdd.t33 0.000515003108019068f
CMODEL10102 a_20000_14483.n0 vdd.n20 0.00083450010295897f
CMODEL10103 a_20000_14483.n0 vdd.t48 0.000515987376880785f
CMODEL10104 a_20000_14483.n0 vdd.n21 0.00148132878991738f
CMODEL10105 a_20000_14483.n0 vdd.n22 0.0064917307418389f
CMODEL10106 a_20000_14483.n0 vdd.t47 7.33938557736955e-06f
CMODEL10107 a_20000_14483.n0 vdd.t45 7.26402879046721e-06f
CMODEL10108 a_20000_14483.n0 vdd.n23 8.29468703271331e-05f
CMODEL10109 a_20000_14483.n0 vdd.t46 0.000197957233257164f
CMODEL10110 a_20000_14483.n0 vdd.n24 0.000212687211310911f
CMODEL10111 a_20000_14483.n0 vdd.t44 0.000197957233257164f
CMODEL10112 a_20000_14483.n0 vdd.n25 0.000335428030186934f
CMODEL10113 a_20000_14483.n0 vdd.t43 0.000198386033932152f
CMODEL10114 a_20000_14483.n0 vdd.n26 0.00179472913216107f
CMODEL10115 a_20000_14483.n0 vdd.n27 0.00119981335985019f
CMODEL10116 a_20000_14483.n0 vdd.n28 0.000271016562208871f
CMODEL10117 a_20000_14483.n0 vdd.t29 2.26699545232571e-05f
CMODEL10118 a_20000_14483.n0 vdd.t28 0.000179194244690279f
CMODEL10119 a_20000_14483.n0 vdd.n29 4.04559420364751e-05f
CMODEL10120 a_20000_14483.n0 vdd.n30 1.29063396576774e-05f
CMODEL10121 a_20000_14483.n0 vdd.t38 5.94236751387293e-06f
CMODEL10122 a_20000_14483.n0 vdd.t40 5.94236751387293e-06f
CMODEL10123 a_20000_14483.n0 vdd.t37 0.000120077478702946f
CMODEL10124 a_20000_14483.n0 vdd.t39 0.000120077478702946f
CMODEL10125 a_20000_14483.n0 vdd.n31 3.88902485307057e-05f
CMODEL10126 a_20000_14483.n0 vdd.n32 0.000469323896162417f
CMODEL10127 a_20000_14483.n0 vdd.n33 0.000237806832450556f
CMODEL10128 a_20000_14483.n0 vdd.t17 2.26699545232571e-05f
CMODEL10129 a_20000_14483.n0 vdd.t16 0.000179194244690279f
CMODEL10130 a_20000_14483.n0 vdd.n34 4.04559420364751e-05f
CMODEL10131 a_20000_14483.n0 vdd.n35 1.29063396576774e-05f
CMODEL10132 a_20000_14483.n0 vdd.t1 5.94236751387293e-06f
CMODEL10133 a_20000_14483.n0 vdd.t31 5.94236751387293e-06f
CMODEL10134 a_20000_14483.n0 vdd.t0 0.000120077478702946f
CMODEL10135 a_20000_14483.n0 vdd.t30 0.000120077478702946f
CMODEL10136 a_20000_14483.n0 vdd.n36 3.88902485307057e-05f
CMODEL10137 a_20000_14483.n0 vdd.n37 0.000455151670463643f
CMODEL10138 a_20000_14483.n0 vdd.n38 0.000262552680604738f
CMODEL10139 a_20000_14483.n0 vdd.t19 2.26699545232571e-05f
CMODEL10140 a_20000_14483.n0 vdd.t18 0.000179194244690279f
CMODEL10141 a_20000_14483.n0 vdd.n39 0.00022155809016588f
CMODEL10142 a_20000_14483.n0 vdd.t21 2.26701621749157e-05f
CMODEL10143 a_20000_14483.n0 vdd.t20 0.000179194244690279f
CMODEL10144 a_20000_14483.n0 vdd.n40 0.00022155809016588f
CMODEL10145 a_20000_14483.n0 vdd.t11 2.26699545232571e-05f
CMODEL10146 a_20000_14483.n0 vdd.t10 0.000179194244690279f
CMODEL10147 a_20000_14483.n0 vdd.n41 0.000953183408426142f
CMODEL10148 a_20000_14483.n0 vdd.n42 0.00182582081500177f
CMODEL10149 a_20000_14483.n0 vdd.n43 0.00022155809016588f
CMODEL10150 a_20000_14483.n0 vdd.t13 2.26699545232571e-05f
CMODEL10151 a_20000_14483.n0 vdd.t12 0.000179194244690279f
CMODEL10152 a_20000_14483.n0 vdd.n44 0.00022155809016588f
CMODEL10153 a_20000_14483.n0 vdd.t23 2.26699545232571e-05f
CMODEL10154 a_20000_14483.n0 vdd.t22 0.000179194244690279f
CMODEL10155 a_20000_14483.n0 vdd.n45 0.00027350422907878f
CMODEL10156 a_20000_14483.n0 vdd.n46 0.00451447164874396f
CMODEL10157 a_20000_14483.t2 vdd 2.95359870245831e-06f
CMODEL10158 a_20000_14483.t2 vdd.n0 0.000991172762580655f
CMODEL10159 a_20000_14483.t2 vdd.n1 9.18527311236286e-05f
CMODEL10160 a_20000_14483.t2 vdd.t7 7.57200864962653e-06f
CMODEL10161 a_20000_14483.t2 vdd.t6 5.98528051463926e-05f
CMODEL10162 a_20000_14483.t2 vdd.n2 8.23680400110236e-05f
CMODEL10163 a_20000_14483.t2 vdd.t27 7.57200864962653e-06f
CMODEL10164 a_20000_14483.t2 vdd.t26 5.98528051463926e-05f
CMODEL10165 a_20000_14483.t2 vdd.n3 0.000154491920041559f
CMODEL10166 a_20000_14483.t2 vdd.n4 8.23680400110236e-05f
CMODEL10167 a_20000_14483.t2 vdd.t36 7.57200864962653e-06f
CMODEL10168 a_20000_14483.t2 vdd.t35 5.98528051463926e-05f
CMODEL10169 a_20000_14483.t2 vdd.n5 0.000117526246752454f
CMODEL10170 a_20000_14483.t2 vdd.t3 1.20617527797345e-05f
CMODEL10171 a_20000_14483.t2 vdd.n6 0.000115401121080131f
CMODEL10172 a_20000_14483.t2 vdd.t2 0.000151241115855469f
CMODEL10173 a_20000_14483.t2 vdd.n7 0.000154699993703993f
CMODEL10174 a_20000_14483.t2 vdd.t25 1.20617527797345e-05f
CMODEL10175 a_20000_14483.t2 vdd.n8 6.97032897575561e-05f
CMODEL10176 a_20000_14483.t2 vdd.t24 0.000151241115855469f
CMODEL10177 a_20000_14483.t2 vdd.n9 0.000154699993703993f
CMODEL10178 a_20000_14483.t2 vdd.t5 1.20617527797345e-05f
CMODEL10179 a_20000_14483.t2 vdd.n10 0.000206397975872282f
CMODEL10180 a_20000_14483.t2 vdd.t4 0.000151324345320443f
CMODEL10181 a_20000_14483.t2 vdd.n11 0.000499035549034604f
CMODEL10182 a_20000_14483.t2 vdd.n12 0.00123043666701322f
CMODEL10183 a_20000_14483.t2 vdd.n13 9.32655512915538e-05f
CMODEL10184 a_20000_14483.t2 vdd.t42 7.57200864962653e-06f
CMODEL10185 a_20000_14483.t2 vdd.t41 5.98528051463926e-05f
CMODEL10186 a_20000_14483.t2 vdd.n14 8.38529923819257e-05f
CMODEL10187 a_20000_14483.t2 vdd.t9 7.57200864962653e-06f
CMODEL10188 a_20000_14483.t2 vdd.t8 5.98528051463926e-05f
CMODEL10189 a_20000_14483.t2 vdd.n15 0.000160986592624991f
CMODEL10190 a_20000_14483.t2 vdd.t15 1.27520024759147e-05f
CMODEL10191 a_20000_14483.t2 vdd.n16 0.000100304683291687f
CMODEL10192 a_20000_14483.t2 vdd.t14 0.000172016577470604f
CMODEL10193 a_20000_14483.t2 vdd.n17 0.000140505208452762f
CMODEL10194 a_20000_14483.t2 vdd.t32 0.000172016577470604f
CMODEL10195 a_20000_14483.t2 vdd.n18 0.000138697741905088f
CMODEL10196 a_20000_14483.t2 vdd.t34 1.27520024759147e-05f
CMODEL10197 a_20000_14483.t2 vdd.n19 0.000139670139487528f
CMODEL10198 a_20000_14483.t2 vdd.t33 0.000172016577470604f
CMODEL10199 a_20000_14483.t2 vdd.n20 0.000278732010301875f
CMODEL10200 a_20000_14483.t2 vdd.t48 0.000172345333857249f
CMODEL10201 a_20000_14483.t2 vdd.n21 0.000494779749058959f
CMODEL10202 a_20000_14483.t2 vdd.n22 0.0021683078930671f
CMODEL10203 a_20000_14483.t2 vdd.t47 2.4514337255407e-06f
CMODEL10204 a_20000_14483.t2 vdd.t45 2.42626374817496e-06f
CMODEL10205 a_20000_14483.t2 vdd.n23 2.77051468688285e-05f
CMODEL10206 a_20000_14483.t2 vdd.t46 6.61198451431221e-05f
CMODEL10207 a_20000_14483.t2 vdd.n24 7.10398162492555e-05f
CMODEL10208 a_20000_14483.t2 vdd.t44 6.61198451431221e-05f
CMODEL10209 a_20000_14483.t2 vdd.n25 0.000112036569958577f
CMODEL10210 a_20000_14483.t2 vdd.t43 6.6263069180764e-05f
CMODEL10211 a_20000_14483.t2 vdd.n26 0.000599458834313879f
CMODEL10212 a_20000_14483.t2 vdd.n27 0.000400750567426274f
CMODEL10213 a_20000_14483.t2 vdd.n28 9.05224468418022e-05f
CMODEL10214 a_20000_14483.t2 vdd.t29 7.57200864962653e-06f
CMODEL10215 a_20000_14483.t2 vdd.t28 5.98528051463926e-05f
CMODEL10216 a_20000_14483.t2 vdd.n29 1.35127197857725e-05f
CMODEL10217 a_20000_14483.t2 vdd.n30 4.3108562667249e-06f
CMODEL10218 a_20000_14483.t2 vdd.t38 1.98481466595552e-06f
CMODEL10219 a_20000_14483.t2 vdd.t40 1.98481466595552e-06f
CMODEL10220 a_20000_14483.t2 vdd.t37 4.01071694445297e-05f
CMODEL10221 a_20000_14483.t2 vdd.t39 4.01071694445297e-05f
CMODEL10222 a_20000_14483.t2 vdd.n31 1.2989761314189e-05f
CMODEL10223 a_20000_14483.t2 vdd.n32 0.000156759229383212f
CMODEL10224 a_20000_14483.t2 vdd.n33 7.94300398974591e-05f
CMODEL10225 a_20000_14483.t2 vdd.t17 7.57200864962653e-06f
CMODEL10226 a_20000_14483.t2 vdd.t16 5.98528051463926e-05f
CMODEL10227 a_20000_14483.t2 vdd.n34 1.35127197857725e-05f
CMODEL10228 a_20000_14483.t2 vdd.n35 4.3108562667249e-06f
CMODEL10229 a_20000_14483.t2 vdd.t1 1.98481466595552e-06f
CMODEL10230 a_20000_14483.t2 vdd.t31 1.98481466595552e-06f
CMODEL10231 a_20000_14483.t2 vdd.t0 4.01071694445297e-05f
CMODEL10232 a_20000_14483.t2 vdd.t30 4.01071694445297e-05f
CMODEL10233 a_20000_14483.t2 vdd.n36 1.2989761314189e-05f
CMODEL10234 a_20000_14483.t2 vdd.n37 0.000152025553562844f
CMODEL10235 a_20000_14483.t2 vdd.n38 8.76954193482023e-05f
CMODEL10236 a_20000_14483.t2 vdd.t19 7.57200864962653e-06f
CMODEL10237 a_20000_14483.t2 vdd.t18 5.98528051463926e-05f
CMODEL10238 a_20000_14483.t2 vdd.n39 7.40027852023121e-05f
CMODEL10239 a_20000_14483.t2 vdd.t21 7.57207800751401e-06f
CMODEL10240 a_20000_14483.t2 vdd.t20 5.98528051463926e-05f
CMODEL10241 a_20000_14483.t2 vdd.n40 7.40027852023121e-05f
CMODEL10242 a_20000_14483.t2 vdd.t11 7.57200864962653e-06f
CMODEL10243 a_20000_14483.t2 vdd.t10 5.98528051463926e-05f
CMODEL10244 a_20000_14483.t2 vdd.n41 0.000318373510889878f
CMODEL10245 a_20000_14483.t2 vdd.n42 0.000609843790805947f
CMODEL10246 a_20000_14483.t2 vdd.n43 7.40027852023121e-05f
CMODEL10247 a_20000_14483.t2 vdd.t13 7.57200864962653e-06f
CMODEL10248 a_20000_14483.t2 vdd.t12 5.98528051463926e-05f
CMODEL10249 a_20000_14483.t2 vdd.n44 7.40027852023121e-05f
CMODEL10250 a_20000_14483.t2 vdd.t23 7.57200864962653e-06f
CMODEL10251 a_20000_14483.t2 vdd.t22 5.98528051463926e-05f
CMODEL10252 a_20000_14483.t2 vdd.n45 9.13533543337876e-05f
CMODEL10253 a_20000_14483.t2 vdd.n46 0.00150788208850238f
CMODEL10254 a_20000_14483.t3 vdd 3.11146599513697e-06f
CMODEL10255 a_20000_14483.t3 vdd.n0 0.00104415008833422f
CMODEL10256 a_20000_14483.t3 vdd.n1 9.67621800530173e-05f
CMODEL10257 a_20000_14483.t3 vdd.t7 7.97672595420179e-06f
CMODEL10258 a_20000_14483.t3 vdd.t6 6.30518857458727e-05f
CMODEL10259 a_20000_14483.t3 vdd.n2 8.67705404146718e-05f
CMODEL10260 a_20000_14483.t3 vdd.t27 7.97672595420179e-06f
CMODEL10261 a_20000_14483.t3 vdd.t26 6.30518857458727e-05f
CMODEL10262 a_20000_14483.t3 vdd.n3 0.000162749379369866f
CMODEL10263 a_20000_14483.t3 vdd.n4 8.67705404146718e-05f
CMODEL10264 a_20000_14483.t3 vdd.t36 7.97672595420179e-06f
CMODEL10265 a_20000_14483.t3 vdd.t35 6.30518857458727e-05f
CMODEL10266 a_20000_14483.t3 vdd.n5 0.000123807922857624f
CMODEL10267 a_20000_14483.t3 vdd.t3 1.27064430197157e-05f
CMODEL10268 a_20000_14483.t3 vdd.n6 0.000121569211058583f
CMODEL10269 a_20000_14483.t3 vdd.t2 0.000159324822515392f
CMODEL10270 a_20000_14483.t3 vdd.n7 0.000162968574389354f
CMODEL10271 a_20000_14483.t3 vdd.t25 1.27064430197157e-05f
CMODEL10272 a_20000_14483.t3 vdd.n8 7.34288702284788e-05f
CMODEL10273 a_20000_14483.t3 vdd.t24 0.000159324822515392f
CMODEL10274 a_20000_14483.t3 vdd.n9 0.000162968574389354f
CMODEL10275 a_20000_14483.t3 vdd.t5 1.27064430197157e-05f
CMODEL10276 a_20000_14483.t3 vdd.n10 0.000217429768931438f
CMODEL10277 a_20000_14483.t3 vdd.t4 0.000159412500523187f
CMODEL10278 a_20000_14483.t3 vdd.n11 0.000525708566940161f
CMODEL10279 a_20000_14483.t3 vdd.n12 0.00129620244124391f
CMODEL10280 a_20000_14483.t3 vdd.n13 9.82505142353435e-05f
CMODEL10281 a_20000_14483.t3 vdd.t42 7.97672595420179e-06f
CMODEL10282 a_20000_14483.t3 vdd.t41 6.30518857458727e-05f
CMODEL10283 a_20000_14483.t3 vdd.n14 8.83348622037539e-05f
CMODEL10284 a_20000_14483.t3 vdd.t9 7.97672595420179e-06f
CMODEL10285 a_20000_14483.t3 vdd.t8 6.30518857458727e-05f
CMODEL10286 a_20000_14483.t3 vdd.n15 0.000169591186578163f
CMODEL10287 a_20000_14483.t3 vdd.t15 1.34335859643651e-05f
CMODEL10288 a_20000_14483.t3 vdd.n16 0.000105665881744636f
CMODEL10289 a_20000_14483.t3 vdd.t14 0.000181210714561242f
CMODEL10290 a_20000_14483.t3 vdd.n17 0.000148015090159856f
CMODEL10291 a_20000_14483.t3 vdd.t32 0.000181210714561242f
CMODEL10292 a_20000_14483.t3 vdd.n18 0.000146111016090567f
CMODEL10293 a_20000_14483.t3 vdd.t34 1.34335859643651e-05f
CMODEL10294 a_20000_14483.t3 vdd.n19 0.000147135387481643f
CMODEL10295 a_20000_14483.t3 vdd.t33 0.000181210714561242f
CMODEL10296 a_20000_14483.t3 vdd.n20 0.000293629994856315f
CMODEL10297 a_20000_14483.t3 vdd.t48 0.000181557042692034f
CMODEL10298 a_20000_14483.t3 vdd.n21 0.000521225298141559f
CMODEL10299 a_20000_14483.t3 vdd.n22 0.00228420207208585f
CMODEL10300 a_20000_14483.t3 vdd.t47 2.5824607351037e-06f
CMODEL10301 a_20000_14483.t3 vdd.t45 2.55594544424625e-06f
CMODEL10302 a_20000_14483.t3 vdd.n23 2.91859629748914e-05f
CMODEL10303 a_20000_14483.t3 vdd.t46 6.96538936028499e-05f
CMODEL10304 a_20000_14483.t3 vdd.n24 7.48368329036592e-05f
CMODEL10305 a_20000_14483.t3 vdd.t44 6.96538936028499e-05f
CMODEL10306 a_20000_14483.t3 vdd.n25 0.000118024827593456f
CMODEL10307 a_20000_14483.t3 vdd.t43 6.98047728412644e-05f
CMODEL10308 a_20000_14483.t3 vdd.n26 0.000631499389845905f
CMODEL10309 a_20000_14483.t3 vdd.n27 0.000422170338184693f
CMODEL10310 a_20000_14483.t3 vdd.n28 9.53607932284216e-05f
CMODEL10311 a_20000_14483.t3 vdd.t29 7.97672595420179e-06f
CMODEL10312 a_20000_14483.t3 vdd.t28 6.30518857458727e-05f
CMODEL10313 a_20000_14483.t3 vdd.n29 1.42349629556147e-05f
CMODEL10314 a_20000_14483.t3 vdd.n30 4.54126780075905e-06f
CMODEL10315 a_20000_14483.t3 vdd.t38 2.0909012908997e-06f
CMODEL10316 a_20000_14483.t3 vdd.t40 2.0909012908997e-06f
CMODEL10317 a_20000_14483.t3 vdd.t37 4.2250862916477e-05f
CMODEL10318 a_20000_14483.t3 vdd.t39 4.2250862916477e-05f
CMODEL10319 a_20000_14483.t3 vdd.n31 1.36840528066338e-05f
CMODEL10320 a_20000_14483.t3 vdd.n32 0.000165137874432224f
CMODEL10321 a_20000_14483.t3 vdd.n33 8.36755067394958e-05f
CMODEL10322 a_20000_14483.t3 vdd.t17 7.97672595420179e-06f
CMODEL10323 a_20000_14483.t3 vdd.t16 6.30518857458727e-05f
CMODEL10324 a_20000_14483.t3 vdd.n34 1.42349629556147e-05f
CMODEL10325 a_20000_14483.t3 vdd.n35 4.54126780075905e-06f
CMODEL10326 a_20000_14483.t3 vdd.t1 2.0909012908997e-06f
CMODEL10327 a_20000_14483.t3 vdd.t31 2.0909012908997e-06f
CMODEL10328 a_20000_14483.t3 vdd.t0 4.2250862916477e-05f
CMODEL10329 a_20000_14483.t3 vdd.t30 4.2250862916477e-05f
CMODEL10330 a_20000_14483.t3 vdd.n36 1.36840528066338e-05f
CMODEL10331 a_20000_14483.t3 vdd.n37 0.000160151187738863f
CMODEL10332 a_20000_14483.t3 vdd.n38 9.23826635636394e-05f
CMODEL10333 a_20000_14483.t3 vdd.t19 7.97672595420179e-06f
CMODEL10334 a_20000_14483.t3 vdd.t18 6.30518857458727e-05f
CMODEL10335 a_20000_14483.t3 vdd.n39 7.79581699811738e-05f
CMODEL10336 a_20000_14483.t3 vdd.t21 7.97679901920829e-06f
CMODEL10337 a_20000_14483.t3 vdd.t20 6.30518857458727e-05f
CMODEL10338 a_20000_14483.t3 vdd.n40 7.79581699811738e-05f
CMODEL10339 a_20000_14483.t3 vdd.t11 7.97672595420179e-06f
CMODEL10340 a_20000_14483.t3 vdd.t10 6.30518857458727e-05f
CMODEL10341 a_20000_14483.t3 vdd.n41 0.000335390299319177f
CMODEL10342 a_20000_14483.t3 vdd.n42 0.00064243941326857f
CMODEL10343 a_20000_14483.t3 vdd.n43 7.79581699811738e-05f
CMODEL10344 a_20000_14483.t3 vdd.t13 7.97672595420179e-06f
CMODEL10345 a_20000_14483.t3 vdd.t12 6.30518857458727e-05f
CMODEL10346 a_20000_14483.t3 vdd.n44 7.79581699811738e-05f
CMODEL10347 a_20000_14483.t3 vdd.t23 7.97672595420179e-06f
CMODEL10348 a_20000_14483.t3 vdd.t22 6.30518857458727e-05f
CMODEL10349 a_20000_14483.t3 vdd.n45 9.62361120062452e-05f
CMODEL10350 a_20000_14483.t3 vdd.n46 0.00158847708022972f
CMODEL10351 a_20000_14483.t4 vdd 3.04345365986491e-06f
CMODEL10352 a_20000_14483.t4 vdd.n0 0.00102132641422268f
CMODEL10353 a_20000_14483.t4 vdd.n1 9.46470928749135e-05f
CMODEL10354 a_20000_14483.t4 vdd.t7 7.80236577773888e-06f
CMODEL10355 a_20000_14483.t4 vdd.t6 6.16736588908836e-05f
CMODEL10356 a_20000_14483.t4 vdd.n2 8.48738566342148e-05f
CMODEL10357 a_20000_14483.t4 vdd.t27 7.80236577773888e-06f
CMODEL10358 a_20000_14483.t4 vdd.t26 6.16736588908836e-05f
CMODEL10359 a_20000_14483.t4 vdd.n3 0.000159191903449408f
CMODEL10360 a_20000_14483.t4 vdd.n4 8.48738566342148e-05f
CMODEL10361 a_20000_14483.t4 vdd.t36 7.80236577773888e-06f
CMODEL10362 a_20000_14483.t4 vdd.t35 6.16736588908836e-05f
CMODEL10363 a_20000_14483.t4 vdd.n5 0.000121101653217561f
CMODEL10364 a_20000_14483.t4 vdd.t3 1.24286977819008e-05f
CMODEL10365 a_20000_14483.t4 vdd.n6 0.000118911876556391f
CMODEL10366 a_20000_14483.t4 vdd.t2 0.00015584220266256f
CMODEL10367 a_20000_14483.t4 vdd.n7 0.000159406307169497f
CMODEL10368 a_20000_14483.t4 vdd.t25 1.24286977819008e-05f
CMODEL10369 a_20000_14483.t4 vdd.n8 7.18238168714977e-05f
CMODEL10370 a_20000_14483.t4 vdd.t24 0.00015584220266256f
CMODEL10371 a_20000_14483.t4 vdd.n9 0.000159406307169497f
CMODEL10372 a_20000_14483.t4 vdd.t5 1.24286977819008e-05f
CMODEL10373 a_20000_14483.t4 vdd.n10 0.000212677055462674f
CMODEL10374 a_20000_14483.t4 vdd.t4 0.000155927964150595f
CMODEL10375 a_20000_14483.t4 vdd.n11 0.000514217306111341f
CMODEL10376 a_20000_14483.t4 vdd.n12 0.00126786925195239f
CMODEL10377 a_20000_14483.t4 vdd.n13 9.61028941343141e-05f
CMODEL10378 a_20000_14483.t4 vdd.t42 7.80236577773888e-06f
CMODEL10379 a_20000_14483.t4 vdd.t41 6.16736588908836e-05f
CMODEL10380 a_20000_14483.t4 vdd.n14 8.64039845165794e-05f
CMODEL10381 a_20000_14483.t4 vdd.t9 7.80236577773888e-06f
CMODEL10382 a_20000_14483.t4 vdd.t8 6.16736588908836e-05f
CMODEL10383 a_20000_14483.t4 vdd.n15 0.000165884158232436f
CMODEL10384 a_20000_14483.t4 vdd.t15 1.31399463893409e-05f
CMODEL10385 a_20000_14483.t4 vdd.n16 0.000103356171984906f
CMODEL10386 a_20000_14483.t4 vdd.t14 0.000177249699434325f
CMODEL10387 a_20000_14483.t4 vdd.n17 0.000144779685385062f
CMODEL10388 a_20000_14483.t4 vdd.t32 0.000177249699434325f
CMODEL10389 a_20000_14483.t4 vdd.n18 0.000142917231736561f
CMODEL10390 a_20000_14483.t4 vdd.t34 1.31399463893409e-05f
CMODEL10391 a_20000_14483.t4 vdd.n19 0.000143919211788441f
CMODEL10392 a_20000_14483.t4 vdd.t33 0.000177249699434325f
CMODEL10393 a_20000_14483.t4 vdd.n20 0.000287211650035156f
CMODEL10394 a_20000_14483.t4 vdd.t48 0.000177588457312064f
CMODEL10395 a_20000_14483.t4 vdd.n21 0.000509832035356465f
CMODEL10396 a_20000_14483.t4 vdd.n22 0.00223427257987909f
CMODEL10397 a_20000_14483.t4 vdd.t47 2.52601172180344e-06f
CMODEL10398 a_20000_14483.t4 vdd.t45 2.50007601846341e-06f
CMODEL10399 a_20000_14483.t4 vdd.n23 2.85479982655909e-05f
CMODEL10400 a_20000_14483.t4 vdd.t46 6.81313560041344e-05f
CMODEL10401 a_20000_14483.t4 vdd.n24 7.32010034335325e-05f
CMODEL10402 a_20000_14483.t4 vdd.t44 6.81313560041344e-05f
CMODEL10403 a_20000_14483.t4 vdd.n25 0.00011544496840256f
CMODEL10404 a_20000_14483.t4 vdd.t43 6.82789372314619e-05f
CMODEL10405 a_20000_14483.t4 vdd.n26 0.000617695688216698f
CMODEL10406 a_20000_14483.t4 vdd.n27 0.000412942279569427f
CMODEL10407 a_20000_14483.t4 vdd.n28 9.32763384244813e-05f
CMODEL10408 a_20000_14483.t4 vdd.t29 7.80236577773888e-06f
CMODEL10409 a_20000_14483.t4 vdd.t28 6.16736588908836e-05f
CMODEL10410 a_20000_14483.t4 vdd.n29 1.39238063899843e-05f
CMODEL10411 a_20000_14483.t4 vdd.n30 4.44200197921122e-06f
CMODEL10412 a_20000_14483.t4 vdd.t38 2.04519708592375e-06f
CMODEL10413 a_20000_14483.t4 vdd.t40 2.04519708592375e-06f
CMODEL10414 a_20000_14483.t4 vdd.t37 4.1327317597743e-05f
CMODEL10415 a_20000_14483.t4 vdd.t39 4.1327317597743e-05f
CMODEL10416 a_20000_14483.t4 vdd.n31 1.33849383734953e-05f
CMODEL10417 a_20000_14483.t4 vdd.n32 0.000161528189319305f
CMODEL10418 a_20000_14483.t4 vdd.n33 8.18464761065659e-05f
CMODEL10419 a_20000_14483.t4 vdd.t17 7.80236577773888e-06f
CMODEL10420 a_20000_14483.t4 vdd.t16 6.16736588908836e-05f
CMODEL10421 a_20000_14483.t4 vdd.n34 1.39238063899843e-05f
CMODEL10422 a_20000_14483.t4 vdd.n35 4.44200197921122e-06f
CMODEL10423 a_20000_14483.t4 vdd.t1 2.04519708592375e-06f
CMODEL10424 a_20000_14483.t4 vdd.t31 2.04519708592375e-06f
CMODEL10425 a_20000_14483.t4 vdd.t0 4.1327317597743e-05f
CMODEL10426 a_20000_14483.t4 vdd.t30 4.1327317597743e-05f
CMODEL10427 a_20000_14483.t4 vdd.n36 1.33849383734953e-05f
CMODEL10428 a_20000_14483.t4 vdd.n37 0.000156650504687293f
CMODEL10429 a_20000_14483.t4 vdd.n38 9.03633065475462e-05f
CMODEL10430 a_20000_14483.t4 vdd.t19 7.80236577773888e-06f
CMODEL10431 a_20000_14483.t4 vdd.t18 6.16736588908836e-05f
CMODEL10432 a_20000_14483.t4 vdd.n39 7.62541124075921e-05f
CMODEL10433 a_20000_14483.t4 vdd.t21 7.80243724564557e-06f
CMODEL10434 a_20000_14483.t4 vdd.t20 6.16736588908836e-05f
CMODEL10435 a_20000_14483.t4 vdd.n40 7.62541124075921e-05f
CMODEL10436 a_20000_14483.t4 vdd.t11 7.80236577773888e-06f
CMODEL10437 a_20000_14483.t4 vdd.t10 6.16736588908836e-05f
CMODEL10438 a_20000_14483.t4 vdd.n41 0.000328059132107341f
CMODEL10439 a_20000_14483.t4 vdd.n42 0.000628396577886313f
CMODEL10440 a_20000_14483.t4 vdd.n43 7.62541124075921e-05f
CMODEL10441 a_20000_14483.t4 vdd.t13 7.80236577773888e-06f
CMODEL10442 a_20000_14483.t4 vdd.t12 6.16736588908836e-05f
CMODEL10443 a_20000_14483.t4 vdd.n44 7.62541124075921e-05f
CMODEL10444 a_20000_14483.t4 vdd.t23 7.80236577773888e-06f
CMODEL10445 a_20000_14483.t4 vdd.t22 6.16736588908836e-05f
CMODEL10446 a_20000_14483.t4 vdd.n45 9.41325239467012e-05f
CMODEL10447 a_20000_14483.t4 vdd.n46 0.00155375517231834f
CMODEL10448 a_20000_14483.n1 vdd 7.75640828756313e-05f
CMODEL10449 a_20000_14483.n1 vdd.n0 0.0260290628638504f
CMODEL10450 a_20000_14483.n1 vdd.n1 0.00241213298316269f
CMODEL10451 a_20000_14483.n1 vdd.t7 0.000198847563802693f
CMODEL10452 a_20000_14483.n1 vdd.t6 0.00157178696444099f
CMODEL10453 a_20000_14483.n1 vdd.n2 0.00216305670651903f
CMODEL10454 a_20000_14483.n1 vdd.t27 0.000198847563802693f
CMODEL10455 a_20000_14483.n1 vdd.t26 0.00157178696444099f
CMODEL10456 a_20000_14483.n1 vdd.n3 0.00405709282027558f
CMODEL10457 a_20000_14483.n1 vdd.n4 0.00216305670651903f
CMODEL10458 a_20000_14483.n1 vdd.t36 0.000198847563802693f
CMODEL10459 a_20000_14483.n1 vdd.t35 0.00157178696444099f
CMODEL10460 a_20000_14483.n1 vdd.n5 0.00308634193791528f
CMODEL10461 a_20000_14483.n1 vdd.t3 0.000316752167941442f
CMODEL10462 a_20000_14483.n1 vdd.n6 0.00303053428075724f
CMODEL10463 a_20000_14483.n1 vdd.t2 0.00397172386169212f
CMODEL10464 a_20000_14483.n1 vdd.n7 0.00406255701647252f
CMODEL10465 a_20000_14483.n1 vdd.t25 0.000316752167941442f
CMODEL10466 a_20000_14483.n1 vdd.n8 0.00183046929799887f
CMODEL10467 a_20000_14483.n1 vdd.t24 0.00397172386169212f
CMODEL10468 a_20000_14483.n1 vdd.n9 0.00406255701647252f
CMODEL10469 a_20000_14483.n1 vdd.t5 0.000316752167941442f
CMODEL10470 a_20000_14483.n1 vdd.n10 0.0054201912035632f
CMODEL10471 a_20000_14483.n1 vdd.t4 0.0039739095401709f
CMODEL10472 a_20000_14483.n1 vdd.n11 0.0131051095908831f
CMODEL10473 a_20000_14483.n1 vdd.n12 0.032312342070707f
CMODEL10474 a_20000_14483.n1 vdd.n13 0.00244923487533988f
CMODEL10475 a_20000_14483.n1 vdd.t42 0.000198847563802693f
CMODEL10476 a_20000_14483.n1 vdd.t41 0.00157178696444099f
CMODEL10477 a_20000_14483.n1 vdd.n14 0.00220205285337783f
CMODEL10478 a_20000_14483.n1 vdd.t9 0.000198847563802693f
CMODEL10479 a_20000_14483.n1 vdd.t8 0.00157178696444099f
CMODEL10480 a_20000_14483.n1 vdd.n15 0.00422764859756927f
CMODEL10481 a_20000_14483.n1 vdd.t15 0.000334878728125411f
CMODEL10482 a_20000_14483.n1 vdd.n16 0.00263408863268222f
CMODEL10483 a_20000_14483.n1 vdd.t14 0.00451730563796884f
CMODEL10484 a_20000_14483.n1 vdd.n17 0.00368978955191755f
CMODEL10485 a_20000_14483.n1 vdd.t32 0.00451730563796884f
CMODEL10486 a_20000_14483.n1 vdd.n18 0.00364232390095351f
CMODEL10487 a_20000_14483.n1 vdd.t34 0.000334878728125411f
CMODEL10488 a_20000_14483.n1 vdd.n19 0.00366785991118052f
CMODEL10489 a_20000_14483.n1 vdd.t33 0.00451730563796884f
CMODEL10490 a_20000_14483.n1 vdd.n20 0.00731974615547866f
CMODEL10491 a_20000_14483.n1 vdd.t48 0.00452593906796f
CMODEL10492 a_20000_14483.n1 vdd.n21 0.0129933485646684f
CMODEL10493 a_20000_14483.n1 vdd.n22 0.0569416600087757f
CMODEL10494 a_20000_14483.n1 vdd.t47 6.43767917739463e-05f
CMODEL10495 a_20000_14483.n1 vdd.t45 6.37158061739903e-05f
CMODEL10496 a_20000_14483.n1 vdd.n23 0.000727561366419474f
CMODEL10497 a_20000_14483.n1 vdd.t46 0.00173636491109524f
CMODEL10498 a_20000_14483.n1 vdd.n24 0.00186556765157052f
CMODEL10499 a_20000_14483.n1 vdd.t44 0.00173636491109524f
CMODEL10500 a_20000_14483.n1 vdd.n25 0.00294217822825279f
CMODEL10501 a_20000_14483.n1 vdd.t43 0.00174012609947746f
CMODEL10502 a_20000_14483.n1 vdd.n26 0.0157423128153976f
CMODEL10503 a_20000_14483.n1 vdd.n27 0.0105240600892858f
CMODEL10504 a_20000_14483.n1 vdd.n28 0.00237719855547695f
CMODEL10505 a_20000_14483.n1 vdd.t29 0.000198847563802693f
CMODEL10506 a_20000_14483.n1 vdd.t28 0.00157178696444099f
CMODEL10507 a_20000_14483.n1 vdd.n29 0.000354855829421409f
CMODEL10508 a_20000_14483.n1 vdd.n30 0.000113206852528371f
CMODEL10509 a_20000_14483.n1 vdd.t38 5.21229675225712e-05f
CMODEL10510 a_20000_14483.n1 vdd.t40 5.21229675225712e-05f
CMODEL10511 a_20000_14483.n1 vdd.t37 0.00105324931654164f
CMODEL10512 a_20000_14483.n1 vdd.t39 0.00105324931654164f
CMODEL10513 a_20000_14483.n1 vdd.n31 0.000341122482979776f
CMODEL10514 a_20000_14483.n1 vdd.n32 0.00411663434483486f
CMODEL10515 a_20000_14483.n1 vdd.n33 0.00208590225621829f
CMODEL10516 a_20000_14483.n1 vdd.t17 0.000198847563802693f
CMODEL10517 a_20000_14483.n1 vdd.t16 0.00157178696444099f
CMODEL10518 a_20000_14483.n1 vdd.n34 0.000354855829421409f
CMODEL10519 a_20000_14483.n1 vdd.n35 0.000113206852528371f
CMODEL10520 a_20000_14483.n1 vdd.t1 5.21229675225712e-05f
CMODEL10521 a_20000_14483.n1 vdd.t31 5.21229675225712e-05f
CMODEL10522 a_20000_14483.n1 vdd.t0 0.00105324931654164f
CMODEL10523 a_20000_14483.n1 vdd.t30 0.00105324931654164f
CMODEL10524 a_20000_14483.n1 vdd.n36 0.000341122482979776f
CMODEL10525 a_20000_14483.n1 vdd.n37 0.00399232388135457f
CMODEL10526 a_20000_14483.n1 vdd.n38 0.00230295834314791f
CMODEL10527 a_20000_14483.n1 vdd.t19 0.000198847563802693f
CMODEL10528 a_20000_14483.n1 vdd.t18 0.00157178696444099f
CMODEL10529 a_20000_14483.n1 vdd.n39 0.00194337780541488f
CMODEL10530 a_20000_14483.n1 vdd.t21 0.000198849385201425f
CMODEL10531 a_20000_14483.n1 vdd.t20 0.00157178696444099f
CMODEL10532 a_20000_14483.n1 vdd.n40 0.00194337780541488f
CMODEL10533 a_20000_14483.n1 vdd.t11 0.000198847563802693f
CMODEL10534 a_20000_14483.n1 vdd.t10 0.00157178696444099f
CMODEL10535 a_20000_14483.n1 vdd.n41 0.00836076660093156f
CMODEL10536 a_20000_14483.n1 vdd.n42 0.0160150308475866f
CMODEL10537 a_20000_14483.n1 vdd.n43 0.00194337780541488f
CMODEL10538 a_20000_14483.n1 vdd.t13 0.000198847563802693f
CMODEL10539 a_20000_14483.n1 vdd.t12 0.00157178696444099f
CMODEL10540 a_20000_14483.n1 vdd.n44 0.00194337780541488f
CMODEL10541 a_20000_14483.n1 vdd.t23 0.000198847563802693f
CMODEL10542 a_20000_14483.n1 vdd.t22 0.00157178696444099f
CMODEL10543 a_20000_14483.n1 vdd.n45 0.00239901891229004f
CMODEL10544 a_20000_14483.n1 vdd.n46 0.0395983012797012f
CMODEL10545 a_0_n11917.t2 a_9600_n35917.t0 1.72992557351642e-06f
CMODEL10546 a_0_n11917.t2 a_9600_n35917.n0 9.49594258081066e-06f
CMODEL10547 a_0_n11917.t2 a_9600_n35917.t2 3.51087186804414e-06f
CMODEL10548 a_0_n11917.t2 a_9600_n35917.n1 0.000111063606188116f
CMODEL10549 a_0_n11917.t2 a_9600_n35917.t1 1.84465416816385e-06f
CMODEL10550 a_0_n11917.t1 a_9600_n35917.t0 2.70622878462025e-06f
CMODEL10551 a_0_n11917.t1 a_9600_n35917.n0 1.48550859890777e-05f
CMODEL10552 a_0_n11917.t1 a_9600_n35917.t2 5.49227241557069e-06f
CMODEL10553 a_0_n11917.t1 a_9600_n35917.n1 0.000173743617986439f
CMODEL10554 a_0_n11917.t1 a_9600_n35917.t1 2.88570576906808e-06f
CMODEL10555 a_0_n11917.n0 a_9600_n35917.t0 7.37939590246289e-05f
CMODEL10556 a_0_n11917.n0 a_9600_n35917.n0 0.000405071298116121f
CMODEL10557 a_0_n11917.n0 a_9600_n35917.t2 0.000149764324394915f
CMODEL10558 a_0_n11917.n0 a_9600_n35917.n1 0.00473767388010439f
CMODEL10559 a_0_n11917.n0 a_9600_n35917.t1 7.86879714272296e-05f
CMODEL10560 a_0_n11917.t6 a_9600_n35917.t0 4.61072635057973e-06f
CMODEL10561 a_0_n11917.t6 a_9600_n35917.n0 2.53092926951405e-05f
CMODEL10562 a_0_n11917.t6 a_9600_n35917.t2 9.35743692290504e-06f
CMODEL10563 a_0_n11917.t6 a_9600_n35917.n1 0.000296014986703181f
CMODEL10564 a_0_n11917.t6 a_9600_n35917.t1 4.91650953721163e-06f
CMODEL10565 a_0_n11917.n1 a_9600_n35917.t0 0.000286084659710178f
CMODEL10566 a_0_n11917.n1 a_9600_n35917.n0 0.00157038172245554f
CMODEL10567 a_0_n11917.n1 a_9600_n35917.t2 0.00058060681860075f
CMODEL10568 a_0_n11917.n1 a_9600_n35917.n1 0.0183670294658551f
CMODEL10569 a_0_n11917.n1 a_9600_n35917.t1 0.000305057782867158f
CMODEL10570 a_0_n11917.t4 a_9600_n35917.t0 3.66033540791671e-07f
CMODEL10571 a_0_n11917.t4 a_9600_n35917.n0 2.00923874368954e-06f
CMODEL10572 a_0_n11917.t4 a_9600_n35917.t2 7.42862514318377e-07f
CMODEL10573 a_0_n11917.t4 a_9600_n35917.n1 2.34998578253818e-05f
CMODEL10574 a_0_n11917.t4 a_9600_n35917.t1 3.90308870535186e-07f
CMODEL10575 a_0_n11917.t5 a_9600_n35917.t0 3.69558562593779e-07f
CMODEL10576 a_0_n11917.t5 a_9600_n35917.n0 2.02858836493416e-06f
CMODEL10577 a_0_n11917.t5 a_9600_n35917.t2 7.50016521443728e-07f
CMODEL10578 a_0_n11917.t5 a_9600_n35917.n1 2.3726169083639e-05f
CMODEL10579 a_0_n11917.t5 a_9600_n35917.t1 3.9406767164182e-07f
CMODEL10580 a_0_n11917.n2 a_9600_n35917.t0 9.29391388995571e-05f
CMODEL10581 a_0_n11917.n2 a_9600_n35917.n0 0.000510163408190003f
CMODEL10582 a_0_n11917.n2 a_9600_n35917.t2 0.000188619333223358f
CMODEL10583 a_0_n11917.n2 a_9600_n35917.n1 0.00596682081600839f
CMODEL10584 a_0_n11917.n2 a_9600_n35917.t1 9.91028588635403e-05f
CMODEL10585 a_0_n11917.t0 a_9600_n35917.t0 7.32516646441325e-07f
CMODEL10586 a_0_n11917.t0 a_9600_n35917.n0 4.02094524792502e-06f
CMODEL10587 a_0_n11917.t0 a_9600_n35917.t2 1.48663741737585e-06f
CMODEL10588 a_0_n11917.t0 a_9600_n35917.n1 4.70285783342844e-05f
CMODEL10589 a_0_n11917.t0 a_9600_n35917.t1 7.81097121051704e-07f
CMODEL10590 a_0_n11917.t3 a_9600_n35917.t0 1.31550260467362e-06f
CMODEL10591 a_0_n11917.t3 a_9600_n35917.n0 7.22108360621273e-06f
CMODEL10592 a_0_n11917.t3 a_9600_n35917.t2 2.66980334749273e-06f
CMODEL10593 a_0_n11917.t3 a_9600_n35917.n1 8.4457080386369e-05f
CMODEL10594 a_0_n11917.t3 a_9600_n35917.t1 1.40274668465011e-06f
CMODEL10595 a_0_n11917.n3 a_9600_n35917.t0 0.000203960534689338f
CMODEL10596 a_0_n11917.n3 a_9600_n35917.n0 0.00111958430802573f
CMODEL10597 a_0_n11917.n3 a_9600_n35917.t2 0.000413936480502143f
CMODEL10598 a_0_n11917.n3 a_9600_n35917.n1 0.0130945474472687f
CMODEL10599 a_0_n11917.n3 a_9600_n35917.t1 0.000217487189168976f
CMODEL10600 a_0_n11917.n4 a_9600_n35917.t0 0.000371520398636686f
CMODEL10601 a_0_n11917.n4 a_9600_n35917.n0 0.00203935731517202f
CMODEL10602 a_0_n11917.n4 a_9600_n35917.t2 0.000753998053989521f
CMODEL10603 a_0_n11917.n4 a_9600_n35917.n1 0.0238521216616058f
CMODEL10604 a_0_n11917.n4 a_9600_n35917.t1 0.000396159616572402f
CMODEL10605 a_11200_n23917.t0 a_3200_n23917.t1 0.00384692992569215f
CMODEL10606 a_11200_n23917.t0 a_3200_n23917.n0 0.00549299234470715f
CMODEL10607 a_11200_n23917.t0 a_3200_n23917.t0 0.000873347225460875f
CMODEL10608 a_11200_n23917.t0 a_3200_n23917.t3 0.00254072892273375f
CMODEL10609 a_11200_n23917.t0 a_3200_n23917.n1 0.12982527225562f
CMODEL10610 a_11200_n23917.t0 a_3200_n23917.t2 0.00325359268311664f
CMODEL10611 a_11200_n23917.t1 a_3200_n23917.t1 0.00384530163464457f
CMODEL10612 a_11200_n23917.t1 a_3200_n23917.n0 0.00549066732438391f
CMODEL10613 a_11200_n23917.t1 a_3200_n23917.t0 0.000872977563549659f
CMODEL10614 a_11200_n23917.t1 a_3200_n23917.t3 0.00253965350773032f
CMODEL10615 a_11200_n23917.t1 a_3200_n23917.n1 0.12977032107828f
CMODEL10616 a_11200_n23917.t1 a_3200_n23917.t2 0.00325221553408073f
CMODEL10617 a en 7.05663126357635e-06f
CMODEL10618 a en.t3 5.35067451519702e-05f
CMODEL10619 a en.t1 4.81616591157765e-05f
CMODEL10620 a en.n0 0.00192465746221683f
CMODEL10621 a en.t0 6.58653723373199e-05f
CMODEL10622 a en.t2 4.81616591157765e-05f
CMODEL10623 a.t3 en 3.97264231040681e-05f
CMODEL10624 a.t3 en.t3 0.000301224694536671f
CMODEL10625 a.t3 en.t1 0.000271133686310479f
CMODEL10626 a.t3 en.n0 0.0108351639498416f
CMODEL10627 a.t3 en.t0 0.000370799543244554f
CMODEL10628 a.t3 en.t2 0.000271133686310479f
CMODEL10629 a.t0 en 4.11049272331985e-05f
CMODEL10630 a.t0 en.t3 0.000311677170565713f
CMODEL10631 a.t0 en.t1 0.000280542006439031f
CMODEL10632 a.t0 en.n0 0.0112111433881498f
CMODEL10633 a.t0 en.t0 0.000383666261703029f
CMODEL10634 a.t0 en.t2 0.000280542006439031f
CMODEL10635 a.n0 en 0.0025096352056789f
CMODEL10636 a.n0 en.t3 0.0190292515449671f
CMODEL10637 a.n0 en.t1 0.0171283138889139f
CMODEL10638 a.n0 en.n0 0.684489233691939f
CMODEL10639 a.n0 en.t0 0.0234244997476477f
CMODEL10640 a.n0 en.t2 0.0171283138889139f
CMODEL10641 a.t2 en 7.84147181099206e-05f
CMODEL10642 a.t2 en.t3 0.000594577806513399f
CMODEL10643 a.t2 en.t1 0.000535182126174423f
CMODEL10644 a.t2 en.n0 0.0213871841563958f
CMODEL10645 a.t2 en.t0 0.000731909378869591f
CMODEL10646 a.t2 en.t2 0.000535182126174423f
CMODEL10647 a.t1 en 4.8161391420554e-05f
CMODEL10648 a.t1 en.t3 0.00036518264886606f
CMODEL10649 a.t1 en.t1 0.000328702525256031f
CMODEL10650 a.t1 en.n0 0.013135755281244f
CMODEL10651 a.t1 en.t0 0.000449530074579881f
CMODEL10652 a.t1 en.t2 0.000328702525256031f
CMODEL10653 a_9600_n35917.t0 sa_en 2.95997306680953e-05f
CMODEL10654 a_9600_n35917.t0 sa_en.t1 0.000200562655400729f
CMODEL10655 a_9600_n35917.t0 sa_en.n0 0.00878786787933467f
CMODEL10656 a_9600_n35917.t0 sa_en.t0 0.000245707939481469f
CMODEL10657 a_9600_n35917.n0 sa_en 0.000162479442546391f
CMODEL10658 a_9600_n35917.n0 sa_en.t1 0.00110093260004759f
CMODEL10659 a_9600_n35917.n0 sa_en.n0 0.0482385427832514f
CMODEL10660 a_9600_n35917.n0 sa_en.t0 0.00134874501000791f
CMODEL10661 a_9600_n35917.t2 sa_en 6.00724466388802e-05f
CMODEL10662 a_9600_n35917.t2 sa_en.t1 0.000407040508219858f
CMODEL10663 a_9600_n35917.t2 sa_en.n0 0.0178349164784759f
CMODEL10664 a_9600_n35917.t2 sa_en.t0 0.000498662546925113f
CMODEL10665 a_9600_n35917.n1 sa_en 0.00190034350640486f
CMODEL10666 a_9600_n35917.n1 sa_en.t1 0.0128763989136195f
CMODEL10667 a_9600_n35917.n1 sa_en.n0 0.564193230232258f
CMODEL10668 a_9600_n35917.n1 sa_en.t0 0.0157747883756598f
CMODEL10669 a_9600_n35917.t1 sa_en 3.15627836187433e-05f
CMODEL10670 a_9600_n35917.t1 sa_en.t1 0.000213863962662237f
CMODEL10671 a_9600_n35917.t1 sa_en.n0 0.00937067892460637f
CMODEL10672 a_9600_n35917.t1 sa_en.t0 0.000262003280172412f
CMODEL10673 a_19896_8041.t1 a_20000_6483.t1 0.00419583609581212f
CMODEL10674 a_19896_8041.t1 a_20000_6483.t0 0.00198656394475723f
CMODEL10675 a_19896_8041.t1 a_20000_6483.n0 0.00539221956376031f
CMODEL10676 a_19896_8041.t1 a_20000_6483.t2 0.0018010563237163f
CMODEL10677 a_19896_8041.t1 a_20000_6483.t3 0.00189732469377873f
CMODEL10678 a_19896_8041.t1 a_20000_6483.t4 0.00185585605270641f
CMODEL10679 a_19896_8041.t1 a_20000_6483.n1 0.0472974353231706f
CMODEL10680 a_19896_8041.t0 a_20000_6483.t1 0.00198656108316176f
CMODEL10681 a_19896_8041.t0 a_20000_6483.t0 0.000940558813964625f
CMODEL10682 a_19896_8041.t0 a_20000_6483.n0 0.00255300094966087f
CMODEL10683 a_19896_8041.t0 a_20000_6483.t2 0.000852728352484578f
CMODEL10684 a_19896_8041.t0 a_20000_6483.t3 0.000898307587025294f
CMODEL10685 a_19896_8041.t0 a_20000_6483.t4 0.000878673839032112f
CMODEL10686 a_19896_8041.t0 a_20000_6483.n1 0.022393449648844f
CMODEL10687 a_19896_8041.n0 a_20000_6483.t1 0.00595161622012283f
CMODEL10688 a_19896_8041.n0 a_20000_6483.t0 0.00281785701966031f
CMODEL10689 a_19896_8041.n0 a_20000_6483.n0 0.00764863562000696f
CMODEL10690 a_19896_8041.n0 a_20000_6483.t2 0.0025547222972517f
CMODEL10691 a_19896_8041.n0 a_20000_6483.t3 0.00269127491266968f
CMODEL10692 a_19896_8041.n0 a_20000_6483.t4 0.00263245339743489f
CMODEL10693 a_19896_8041.n0 a_20000_6483.n1 0.0670894136023461f
CMODEL10694 a_19896_8041.t3 a_20000_6483.t1 0.00198335410837423f
CMODEL10695 a_19896_8041.t3 a_20000_6483.t0 0.000939040437093086f
CMODEL10696 a_19896_8041.t3 a_20000_6483.n0 0.00254887955125661f
CMODEL10697 a_19896_8041.t3 a_20000_6483.t2 0.000851351763387867f
CMODEL10698 a_19896_8041.t3 a_20000_6483.t3 0.000896857417781844f
CMODEL10699 a_19896_8041.t3 a_20000_6483.t4 0.000877255365232277f
CMODEL10700 a_19896_8041.t3 a_20000_6483.n1 0.0223572991226717f
CMODEL10701 a_19896_8041.t4 a_20000_6483.t1 0.00185585757463908f
CMODEL10702 a_19896_8041.t4 a_20000_6483.t0 0.000878675825317003f
CMODEL10703 a_19896_8041.t4 a_20000_6483.n0 0.00238502917964546f
CMODEL10704 a_19896_8041.t4 a_20000_6483.t2 0.000796624068336863f
CMODEL10705 a_19896_8041.t4 a_20000_6483.t3 0.000839204469405634f
CMODEL10706 a_19896_8041.t4 a_20000_6483.t4 0.000820862501348096f
CMODEL10707 a_19896_8041.t4 a_20000_6483.n1 0.0209200983072525f
CMODEL10708 a_19896_8041.t2 a_20000_6483.t1 0.00186629401836344f
CMODEL10709 a_19896_8041.t2 a_20000_6483.t0 0.000883617072386927f
CMODEL10710 a_19896_8041.t2 a_20000_6483.n0 0.00239844142806069f
CMODEL10711 a_19896_8041.t2 a_20000_6483.t2 0.000801103896084577f
CMODEL10712 a_19896_8041.t2 a_20000_6483.t3 0.000843923748696175f
CMODEL10713 a_19896_8041.t2 a_20000_6483.t4 0.000825478634298076f
CMODEL10714 a_19896_8041.t2 a_20000_6483.n1 0.0210377428030777f
CMODEL10715 a_19896_8041.n1 a_20000_6483.t1 0.0563678166434914f
CMODEL10716 a_19896_8041.n1 a_20000_6483.t0 0.0266879519675262f
CMODEL10717 a_19896_8041.n1 a_20000_6483.n0 0.0724403043233409f
CMODEL10718 a_19896_8041.n1 a_20000_6483.t2 0.0241958003843788f
CMODEL10719 a_19896_8041.n1 a_20000_6483.t3 0.0254890915683844f
CMODEL10720 a_19896_8041.n1 a_20000_6483.t4 0.0249319924103043f
CMODEL10721 a_19896_8041.n1 a_20000_6483.n1 0.635404506068497f
CMODEL10722 a a_3200_83.t0 1.99828275212038e-06f
CMODEL10723 a a_3200_83.t1 1.99828275212038e-06f
CMODEL10724 a.t3 a_3200_83.t0 1.12496491777952e-05f
CMODEL10725 a.t3 a_3200_83.t1 1.12496491777952e-05f
CMODEL10726 a.t0 a_3200_83.t0 1.16400112247944e-05f
CMODEL10727 a.t0 a_3200_83.t1 1.16400112247944e-05f
CMODEL10728 a.n0 a_3200_83.t0 0.000710673486867246f
CMODEL10729 a.n0 a_3200_83.t1 0.000710673486867246f
CMODEL10730 a.t2 a_3200_83.t0 2.22053233134392e-05f
CMODEL10731 a.t2 a_3200_83.t1 2.22053233134392e-05f
CMODEL10732 a.t1 a_3200_83.t0 1.36382466646041e-05f
CMODEL10733 a.t1 a_3200_83.t1 1.36382466646041e-05f
CMODEL10734 a_19896_16041.t2 a_20000_14483.t0 0.00419583481626183f
CMODEL10735 a_19896_16041.t2 a_20000_14483.t1 0.00198655914789882f
CMODEL10736 a_19896_16041.t2 a_20000_14483.n0 0.00539222438291166f
CMODEL10737 a_19896_16041.t2 a_20000_14483.t2 0.00180106094285486f
CMODEL10738 a_19896_16041.t2 a_20000_14483.t3 0.00189732609043943f
CMODEL10739 a_19896_16041.t2 a_20000_14483.t4 0.00185585317111939f
CMODEL10740 a_19896_16041.t2 a_20000_14483.n1 0.0472974341840633f
CMODEL10741 a_19896_16041.t1 a_20000_14483.t0 0.00198655690168966f
CMODEL10742 a_19896_16041.t1 a_20000_14483.t1 0.000940554849914011f
CMODEL10743 a_19896_16041.t1 a_20000_14483.n0 0.00255299863612743f
CMODEL10744 a_19896_16041.t1 a_20000_14483.t2 0.000852729004613115f
CMODEL10745 a_19896_16041.t1 a_20000_14483.t3 0.000898306631402697f
CMODEL10746 a_19896_16041.t1 a_20000_14483.t4 0.000878670893172694f
CMODEL10747 a_19896_16041.t1 a_20000_14483.n1 0.0223934088030362f
CMODEL10748 a_19896_16041.n0 a_20000_14483.t0 0.00595161455468745f
CMODEL10749 a_19896_16041.n0 a_20000_14483.t1 0.0028178502863265f
CMODEL10750 a_19896_16041.n0 a_20000_14483.n0 0.00764864264796522f
CMODEL10751 a_19896_16041.n0 a_20000_14483.t2 0.0025547289135f
CMODEL10752 a_19896_16041.n0 a_20000_14483.t3 0.0026912769614005f
CMODEL10753 a_19896_16041.n0 a_20000_14483.t4 0.00263244937617386f
CMODEL10754 a_19896_16041.n0 a_20000_14483.n1 0.0670894136723986f
CMODEL10755 a_19896_16041.t4 a_20000_14483.t0 0.00198335385394761f
CMODEL10756 a_19896_16041.t4 a_20000_14483.t1 0.000939038335543978f
CMODEL10757 a_19896_16041.t4 a_20000_14483.n0 0.00254888227957607f
CMODEL10758 a_19896_16041.t4 a_20000_14483.t2 0.000851354097249278f
CMODEL10759 a_19896_16041.t4 a_20000_14483.t3 0.000896858236431003f
CMODEL10760 a_19896_16041.t4 a_20000_14483.t4 0.000877254158108122f
CMODEL10761 a_19896_16041.t4 a_20000_14483.n1 0.0223573025342238f
CMODEL10762 a_19896_16041.t3 a_20000_14483.t0 0.00185585071485177f
CMODEL10763 a_19896_16041.t3 a_20000_14483.t1 0.000878670723745973f
CMODEL10764 a_19896_16041.t3 a_20000_14483.n0 0.00238502322276437f
CMODEL10765 a_19896_16041.t3 a_20000_14483.t2 0.000796623409800173f
CMODEL10766 a_19896_16041.t3 a_20000_14483.t3 0.000839202241137322f
CMODEL10767 a_19896_16041.t3 a_20000_14483.t4 0.000820858442980924f
CMODEL10768 a_19896_16041.t3 a_20000_14483.n1 0.020920026856384f
CMODEL10769 a_19896_16041.t0 a_20000_14483.t0 0.00186628488552666f
CMODEL10770 a_19896_16041.t0 a_20000_14483.t1 0.000883610884193807f
CMODEL10771 a_19896_16041.t0 a_20000_14483.n0 0.00239843256607563f
CMODEL10772 a_19896_16041.t0 a_20000_14483.t2 0.000801102274697521f
CMODEL10773 a_19896_16041.t0 a_20000_14483.t3 0.000843920497484507f
CMODEL10774 a_19896_16041.t0 a_20000_14483.t4 0.000825473564782179f
CMODEL10775 a_19896_16041.t0 a_20000_14483.n1 0.0210376457623638f
CMODEL10776 a_19896_16041.n1 a_20000_14483.t0 0.0563678165370754f
CMODEL10777 a_19896_16041.n1 a_20000_14483.t1 0.0266878956137204f
CMODEL10778 a_19896_16041.n1 a_20000_14483.n0 0.0724403910193737f
CMODEL10779 a_19896_16041.n1 a_20000_14483.t2 0.0241958697719618f
CMODEL10780 a_19896_16041.n1 a_20000_14483.t3 0.0254891180564108f
CMODEL10781 a_19896_16041.n1 a_20000_14483.t4 0.0249319612545203f
CMODEL10782 a_19896_16041.n1 a_20000_14483.n1 0.635404683337112f
CMODEL10783 a_3200_n23917.t1 din 5.85230462541691e-06f
CMODEL10784 a_3200_n23917.t1 din.t0 3.29463711613999e-05f
CMODEL10785 a_3200_n23917.t1 din.t1 3.40896211759262e-05f
CMODEL10786 a_3200_n23917.t1 din.n0 0.0019191011876994f
CMODEL10787 a_3200_n23917.t1 din.t2 5.80666672541718e-05f
CMODEL10788 a_3200_n23917.t1 din.n1 0.0025297211687048f
CMODEL10789 a_3200_n23917.t1 din.t3 4.2752539996733e-05f
CMODEL10790 a_3200_n23917.n0 din 8.35644660216299e-06f
CMODEL10791 a_3200_n23917.n0 din.t0 4.70437902616302e-05f
CMODEL10792 a_3200_n23917.n0 din.t1 4.8676225398007e-05f
CMODEL10793 a_3200_n23917.n0 din.n0 0.00274026518194363f
CMODEL10794 a_3200_n23917.n0 din.t2 8.29128070619677e-05f
CMODEL10795 a_3200_n23917.n0 din.n1 0.00361216327886162f
CMODEL10796 a_3200_n23917.n0 din.t3 6.10459195917346e-05f
CMODEL10797 a_3200_n23917.t0 din 1.32861635275046e-06f
CMODEL10798 a_3200_n23917.t0 din.t0 7.47963243381299e-06f
CMODEL10799 a_3200_n23917.t0 din.t1 7.73917816183013e-06f
CMODEL10800 a_3200_n23917.t0 din.n0 0.000435682928992886f
CMODEL10801 a_3200_n23917.t0 din.t2 1.31825543271539e-05f
CMODEL10802 a_3200_n23917.t0 din.n1 0.000574308606227203f
CMODEL10803 a_3200_n23917.t0 din.t3 9.70587271116823e-06f
CMODEL10804 a_3200_n23917.t3 din 3.86519118197089e-06f
CMODEL10805 a_3200_n23917.t3 din.t0 2.17596368339953e-05f
CMODEL10806 a_3200_n23917.t3 din.t1 2.25147034543732e-05f
CMODEL10807 a_3200_n23917.t3 din.n0 0.00126748237878632f
CMODEL10808 a_3200_n23917.t3 din.t2 3.83504934556058e-05f
CMODEL10809 a_3200_n23917.t3 din.n1 0.00167077016320324f
CMODEL10810 a_3200_n23917.t3 din.t3 2.8236182355333e-05f
CMODEL10811 a_3200_n23917.n1 din 0.000197502178618675f
CMODEL10812 a_3200_n23917.n1 din.t0 0.00111186626439365f
CMODEL10813 a_3200_n23917.n1 din.t1 0.00115044839280749f
CMODEL10814 a_3200_n23917.n1 din.n0 0.0647653684864903f
CMODEL10815 a_3200_n23917.n1 din.t2 0.00195962001670541f
CMODEL10816 a_3200_n23917.n1 din.n1 0.0853724257529374f
CMODEL10817 a_3200_n23917.n1 din.t3 0.00144280250794964f
CMODEL10818 a_3200_n23917.t2 din 4.94966528541593e-06f
CMODEL10819 a_3200_n23917.t2 din.t0 2.78648361723639e-05f
CMODEL10820 a_3200_n23917.t2 din.t1 2.88317552361591e-05f
CMODEL10821 a_3200_n23917.t2 din.n0 0.00162310562008373f
CMODEL10822 a_3200_n23917.t2 din.t2 4.91106641816851e-05f
CMODEL10823 a_3200_n23917.t2 din.n1 0.00213954567507291f
CMODEL10824 a_3200_n23917.t2 din.t3 3.61585352488569e-05f
CMODEL10825 a a_3200_169.t2 1.21750928033395e-05f
CMODEL10826 a a_3200_169.n0 0.000218786568820903f
CMODEL10827 a a_3200_169.t1 1.77744535893676e-05f
CMODEL10828 a a_3200_169.t3 3.52554754744726e-05f
CMODEL10829 a a_3200_169.t4 7.90178067535456e-06f
CMODEL10830 a a_3200_169.t0 1.97632478256052e-05f
CMODEL10831 a a_3200_169.n1 1.78687952582703e-05f
CMODEL10832 a.t3 a_3200_169.t2 6.85416128419935e-05f
CMODEL10833 a.t3 a_3200_169.n0 0.00123169363366473f
CMODEL10834 a.t3 a_3200_169.t1 0.00010006410103636f
CMODEL10835 a.t3 a_3200_169.t3 0.000198476281829153f
CMODEL10836 a.t3 a_3200_169.t4 4.44843255456701e-05f
CMODEL10837 a.t3 a_3200_169.t0 0.000111260333111502f
CMODEL10838 a.t3 a_3200_169.n1 0.000100595212400293f
CMODEL10839 a.t0 a_3200_169.t2 7.09200020584712e-05f
CMODEL10840 a.t0 a_3200_169.n0 0.0012744333174108f
CMODEL10841 a.t0 a_3200_169.t1 0.000103536318409039f
CMODEL10842 a.t0 a_3200_169.t3 0.000205363395056519f
CMODEL10843 a.t0 a_3200_169.t4 4.60279285598567e-05f
CMODEL10844 a.t0 a_3200_169.t0 0.000115121058961419f
CMODEL10845 a.t0 a_3200_169.n1 0.000104085859300501f
CMODEL10846 a.n0 a_3200_169.t2 0.00432997564849137f
CMODEL10847 a.n0 a_3200_169.n0 0.0778097161568781f
CMODEL10848 a.n0 a_3200_169.t1 0.00632134411214443f
CMODEL10849 a.n0 a_3200_169.t3 0.0125383315549414f
CMODEL10850 a.n0 a_3200_169.t4 0.00281020592258816f
CMODEL10851 a.n0 a_3200_169.t0 0.00702864308323782f
CMODEL10852 a.n0 a_3200_169.n1 0.00635489598198107f
CMODEL10853 a.t2 a_3200_169.t2 0.000135292101071487f
CMODEL10854 a.t2 a_3200_169.n0 0.00243120073580733f
CMODEL10855 a.t2 a_3200_169.t1 0.000197513334012829f
CMODEL10856 a.t2 a_3200_169.t3 0.000391765995402301f
CMODEL10857 a.t2 a_3200_169.t4 8.78061898207106e-05f
CMODEL10858 a.t2 a_3200_169.t0 0.000219613219012937f
CMODEL10859 a.t2 a_3200_169.n1 0.000198561677775838f
CMODEL10860 a.t1 a_3200_169.t2 8.30948065984144e-05f
CMODEL10861 a.t1 a_3200_169.n0 0.0014932147061349f
CMODEL10862 a.t1 a_3200_169.t1 0.000121310351161831f
CMODEL10863 a.t1 a_3200_169.t3 0.000240618035805272f
CMODEL10864 a.t1 a_3200_169.t4 5.39295221488234e-05f
CMODEL10865 a.t1 a_3200_169.t0 0.000134883838862793f
CMODEL10866 a.t1 a_3200_169.n1 0.000121954231488517f
CMODEL10867 a_1600_n11917.t5 a_19896_8041.t1 1.54074952818733e-05f
CMODEL10868 a_1600_n11917.t5 a_19896_8041.t0 7.29483464487991e-06f
CMODEL10869 a_1600_n11917.t5 a_19896_8041.n0 2.18548810623439e-05f
CMODEL10870 a_1600_n11917.t5 a_19896_8041.t3 7.28305833909016e-06f
CMODEL10871 a_1600_n11917.t5 a_19896_8041.t4 6.8148793642393e-06f
CMODEL10872 a_1600_n11917.t5 a_19896_8041.t2 6.85320294356195e-06f
CMODEL10873 a_1600_n11917.t5 a_19896_8041.n1 0.000206987796747097f
CMODEL10874 a_1600_n11917.t4 a_19896_8041.t1 2.44906222947279e-05f
CMODEL10875 a_1600_n11917.t4 a_19896_8041.t0 1.15953330974201e-05f
CMODEL10876 a_1600_n11917.t4 a_19896_8041.n0 3.47389129512677e-05f
CMODEL10877 a_1600_n11917.t4 a_19896_8041.t3 1.15766143471075e-05f
CMODEL10878 a_1600_n11917.t4 a_19896_8041.t4 1.08324314523773e-05f
CMODEL10879 a_1600_n11917.t4 a_19896_8041.t2 1.08933477978963e-05f
CMODEL10880 a_1600_n11917.t4 a_19896_8041.n1 0.000329012591405105f
CMODEL10881 a_1600_n11917.n0 a_19896_8041.t1 0.000426353956436933f
CMODEL10882 a_1600_n11917.n0 a_19896_8041.t0 0.000201861597586003f
CMODEL10883 a_1600_n11917.n0 a_19896_8041.n0 0.000604765072967524f
CMODEL10884 a_1600_n11917.n0 a_19896_8041.t3 0.000201535725374212f
CMODEL10885 a_1600_n11917.n0 a_19896_8041.t4 0.000188580345242888f
CMODEL10886 a_1600_n11917.n0 a_19896_8041.t2 0.000189640829725934f
CMODEL10887 a_1600_n11917.n0 a_19896_8041.n1 0.00572773604422995f
CMODEL10888 a_1600_n11917.t6 a_19896_8041.t1 4.52129854458014e-05f
CMODEL10889 a_1600_n11917.t6 a_19896_8041.t0 2.14065457489715e-05f
CMODEL10890 a_1600_n11917.t6 a_19896_8041.n0 6.41327095231363e-05f
CMODEL10891 a_1600_n11917.t6 a_19896_8041.t3 2.1371988416158e-05f
CMODEL10892 a_1600_n11917.t6 a_19896_8041.t4 1.9998126617812e-05f
CMODEL10893 a_1600_n11917.t6 a_19896_8041.t2 2.0110586391607e-05f
CMODEL10894 a_1600_n11917.t6 a_19896_8041.n1 0.000607401532213688f
CMODEL10895 a_1600_n11917.n1 a_19896_8041.t1 0.00251177666485086f
CMODEL10896 a_1600_n11917.n1 a_19896_8041.t0 0.00118922609416676f
CMODEL10897 a_1600_n11917.n1 a_19896_8041.n0 0.00356284907191041f
CMODEL10898 a_1600_n11917.n1 a_19896_8041.t3 0.00118730628503882f
CMODEL10899 a_1600_n11917.n1 a_19896_8041.t4 0.00111098232695929f
CMODEL10900 a_1600_n11917.n1 a_19896_8041.t2 0.00111722995322788f
CMODEL10901 a_1600_n11917.n1 a_19896_8041.n1 0.0337437791326093f
CMODEL10902 a_1600_n11917.t2 a_19896_8041.t1 3.15799768772273e-06f
CMODEL10903 a_1600_n11917.t2 a_19896_8041.t0 1.49518598055021e-06f
CMODEL10904 a_1600_n11917.t2 a_19896_8041.n0 4.47948628882824e-06f
CMODEL10905 a_1600_n11917.t2 a_19896_8041.t3 1.49277224971508e-06f
CMODEL10906 a_1600_n11917.t2 a_19896_8041.t4 1.39681193345531e-06f
CMODEL10907 a_1600_n11917.t2 a_19896_8041.t2 1.40466692692908e-06f
CMODEL10908 a_1600_n11917.t2 a_19896_8041.n1 4.24252593660169e-05f
CMODEL10909 a_1600_n11917.t3 a_19896_8041.t1 3.15799768772273e-06f
CMODEL10910 a_1600_n11917.t3 a_19896_8041.t0 1.49518598055021e-06f
CMODEL10911 a_1600_n11917.t3 a_19896_8041.n0 4.47948628882824e-06f
CMODEL10912 a_1600_n11917.t3 a_19896_8041.t3 1.49277224971508e-06f
CMODEL10913 a_1600_n11917.t3 a_19896_8041.t4 1.39681193345531e-06f
CMODEL10914 a_1600_n11917.t3 a_19896_8041.t2 1.40466692692908e-06f
CMODEL10915 a_1600_n11917.t3 a_19896_8041.n1 4.24252593660169e-05f
CMODEL10916 a_1600_n11917.n2 a_19896_8041.t1 0.000766066745817366f
CMODEL10917 a_1600_n11917.n2 a_19896_8041.t0 0.000362702057371617f
CMODEL10918 a_1600_n11917.n2 a_19896_8041.n0 0.00108663331121395f
CMODEL10919 a_1600_n11917.n2 a_19896_8041.t3 0.000362116534800358f
CMODEL10920 a_1600_n11917.n2 a_19896_8041.t4 0.000338838491408967f
CMODEL10921 a_1600_n11917.n2 a_19896_8041.t2 0.000340743954896878f
CMODEL10922 a_1600_n11917.n2 a_19896_8041.n1 0.0102915149397778f
CMODEL10923 a_1600_n11917.t1 a_19896_8041.t1 1.11568806864042e-05f
CMODEL10924 a_1600_n11917.t1 a_19896_8041.t0 5.28233812641334e-06f
CMODEL10925 a_1600_n11917.t1 a_19896_8041.n0 1.58255638549499e-05f
CMODEL10926 a_1600_n11917.t1 a_19896_8041.t3 5.27381066388818e-06f
CMODEL10927 a_1600_n11917.t1 a_19896_8041.t4 4.93479274652173e-06f
CMODEL10928 a_1600_n11917.t1 a_19896_8041.t2 4.96254362972218e-06f
CMODEL10929 a_1600_n11917.t1 a_19896_8041.n1 0.000149884073277371f
CMODEL10930 a_1600_n11917.t0 a_19896_8041.t1 1.53346437952149e-05f
CMODEL10931 a_1600_n11917.t0 a_19896_8041.t0 7.26034237088701e-06f
CMODEL10932 a_1600_n11917.t0 a_19896_8041.n0 2.17515443066281e-05f
CMODEL10933 a_1600_n11917.t0 a_19896_8041.t3 7.24862174717721e-06f
CMODEL10934 a_1600_n11917.t0 a_19896_8041.t4 6.78265646986227e-06f
CMODEL10935 a_1600_n11917.t0 a_19896_8041.t2 6.82079884324089e-06f
CMODEL10936 a_1600_n11917.t0 a_19896_8041.n1 0.000206009093301969f
CMODEL10937 a_1600_n11917.n3 a_19896_8041.t1 0.00212565464484784f
CMODEL10938 a_1600_n11917.n3 a_19896_8041.t0 0.00100641271424103f
CMODEL10939 a_1600_n11917.n3 a_19896_8041.n0 0.00301515130090113f
CMODEL10940 a_1600_n11917.n3 a_19896_8041.t3 0.00100478802712329f
CMODEL10941 a_1600_n11917.n3 a_19896_8041.t4 0.000940196943737873f
CMODEL10942 a_1600_n11917.n3 a_19896_8041.t2 0.000945484155767088f
CMODEL10943 a_1600_n11917.n3 a_19896_8041.n1 0.0285565280750028f
CMODEL10944 a_1600_n11917.n4 a_19896_8041.t1 0.00311654455196416f
CMODEL10945 a_1600_n11917.n4 a_19896_8041.t0 0.00147555957370481f
CMODEL10946 a_1600_n11917.n4 a_19896_8041.n0 0.00442068676722588f
CMODEL10947 a_1600_n11917.n4 a_19896_8041.t3 0.00147317752646223f
CMODEL10948 a_1600_n11917.n4 a_19896_8041.t4 0.00137847682354316f
CMODEL10949 a_1600_n11917.n4 a_19896_8041.t2 0.00138622870924325f
CMODEL10950 a_1600_n11917.n4 a_19896_8041.n1 0.041868368509849f
CMODEL10951 a_19896_8041.t1 vdd 1.4633342763157e-05f
CMODEL10952 a_19896_8041.t1 vdd.n0 0.00491067752713868f
CMODEL10953 a_19896_8041.t1 vdd.n1 0.000455076208269404f
CMODEL10954 a_19896_8041.t1 vdd.t7 3.75148451559624e-05f
CMODEL10955 a_19896_8041.t1 vdd.t6 0.000296535413668294f
CMODEL10956 a_19896_8041.t1 vdd.n2 0.00040808514752107f
CMODEL10957 a_19896_8041.t1 vdd.t27 3.75148451559624e-05f
CMODEL10958 a_19896_8041.t1 vdd.t26 0.000296535413668294f
CMODEL10959 a_19896_8041.t1 vdd.n3 0.000765416513158931f
CMODEL10960 a_19896_8041.t1 vdd.n4 0.00040808514752107f
CMODEL10961 a_19896_8041.t1 vdd.t36 3.75148451559624e-05f
CMODEL10962 a_19896_8041.t1 vdd.t35 0.000296535413668294f
CMODEL10963 a_19896_8041.t1 vdd.n5 0.000582273364003249f
CMODEL10964 a_19896_8041.t1 vdd.t3 5.97588841718446e-05f
CMODEL10965 a_19896_8041.t1 vdd.n6 0.000571744617375615f
CMODEL10966 a_19896_8041.t1 vdd.t2 0.000749310692191659f
CMODEL10967 a_19896_8041.t1 vdd.n7 0.000766447395661636f
CMODEL10968 a_19896_8041.t1 vdd.t25 5.97588841718446e-05f
CMODEL10969 a_19896_8041.t1 vdd.n8 0.000345338765856384f
CMODEL10970 a_19896_8041.t1 vdd.t24 0.000749310692191659f
CMODEL10971 a_19896_8041.t1 vdd.n9 0.000766447395661636f
CMODEL10972 a_19896_8041.t1 vdd.t5 5.97588841718446e-05f
CMODEL10973 a_19896_8041.t1 vdd.n10 0.00102258046228389f
CMODEL10974 a_19896_8041.t1 vdd.t4 0.000749723045192741f
CMODEL10975 a_19896_8041.t1 vdd.n11 0.00247242735918919f
CMODEL10976 a_19896_8041.t1 vdd.n12 0.00609608931699994f
CMODEL10977 a_19896_8041.t1 vdd.n13 0.000462075900462776f
CMODEL10978 a_19896_8041.t1 vdd.t42 3.75148451559624e-05f
CMODEL10979 a_19896_8041.t1 vdd.t41 0.000296535413668294f
CMODEL10980 a_19896_8041.t1 vdd.n14 0.00041544221231538f
CMODEL10981 a_19896_8041.t1 vdd.t9 3.75148451559624e-05f
CMODEL10982 a_19896_8041.t1 vdd.t8 0.000296535413668294f
CMODEL10983 a_19896_8041.t1 vdd.n15 0.000797593792343384f
CMODEL10984 a_19896_8041.t1 vdd.t15 6.31786650608203e-05f
CMODEL10985 a_19896_8041.t1 vdd.n16 0.000496950655529309f
CMODEL10986 a_19896_8041.t1 vdd.t14 0.000852240873811812f
CMODEL10987 a_19896_8041.t1 vdd.n17 0.000696120591327055f
CMODEL10988 a_19896_8041.t1 vdd.t32 0.000852240873811812f
CMODEL10989 a_19896_8041.t1 vdd.n18 0.000687165658653552f
CMODEL10990 a_19896_8041.t1 vdd.t34 6.31786650608203e-05f
CMODEL10991 a_19896_8041.t1 vdd.n19 0.000691983316216196f
CMODEL10992 a_19896_8041.t1 vdd.t33 0.000852240873811812f
CMODEL10993 a_19896_8041.t1 vdd.n20 0.00138095301924948f
CMODEL10994 a_19896_8041.t1 vdd.t48 0.000853869668166087f
CMODEL10995 a_19896_8041.t1 vdd.n21 0.00245134237573385f
CMODEL10996 a_19896_8041.t1 vdd.n22 0.0107426891096955f
CMODEL10997 a_19896_8041.t1 vdd.t47 1.21454109311271e-05f
CMODEL10998 a_19896_8041.t1 vdd.t45 1.20207085110498e-05f
CMODEL10999 a_19896_8041.t1 vdd.n23 0.000137262692490263f
CMODEL11000 a_19896_8041.t1 vdd.t46 0.000327584907394787f
CMODEL11001 a_19896_8041.t1 vdd.n24 0.000351960467798764f
CMODEL11002 a_19896_8041.t1 vdd.t44 0.000327584907394787f
CMODEL11003 a_19896_8041.t1 vdd.n25 0.000555075247306864f
CMODEL11004 a_19896_8041.t1 vdd.t43 0.00032829449818415f
CMODEL11005 a_19896_8041.t1 vdd.n26 0.00296996561774504f
CMODEL11006 a_19896_8041.t1 vdd.n27 0.00198548313648615f
CMODEL11007 a_19896_8041.t1 vdd.n28 0.000448485432802106f
CMODEL11008 a_19896_8041.t1 vdd.t29 3.75148451559624e-05f
CMODEL11009 a_19896_8041.t1 vdd.t28 0.000296535413668294f
CMODEL11010 a_19896_8041.t1 vdd.n29 6.69475714907122e-05f
CMODEL11011 a_19896_8041.t1 vdd.n30 2.13577549655561e-05f
CMODEL11012 a_19896_8041.t1 vdd.t38 9.83358819330947e-06f
CMODEL11013 a_19896_8041.t1 vdd.t40 9.83358819330947e-06f
CMODEL11014 a_19896_8041.t1 vdd.t37 0.000198707413181532f
CMODEL11015 a_19896_8041.t1 vdd.t39 0.000198707413181532f
CMODEL11016 a_19896_8041.t1 vdd.n31 6.43566201339119e-05f
CMODEL11017 a_19896_8041.t1 vdd.n32 0.000776649696163414f
CMODEL11018 a_19896_8041.t1 vdd.n33 0.000393529086582866f
CMODEL11019 a_19896_8041.t1 vdd.t17 3.75148451559624e-05f
CMODEL11020 a_19896_8041.t1 vdd.t16 0.000296535413668294f
CMODEL11021 a_19896_8041.t1 vdd.n34 6.69475714907122e-05f
CMODEL11022 a_19896_8041.t1 vdd.n35 2.13577549655561e-05f
CMODEL11023 a_19896_8041.t1 vdd.t1 9.83358819330947e-06f
CMODEL11024 a_19896_8041.t1 vdd.t31 9.83358819330947e-06f
CMODEL11025 a_19896_8041.t1 vdd.t0 0.000198707413181532f
CMODEL11026 a_19896_8041.t1 vdd.t30 0.000198707413181532f
CMODEL11027 a_19896_8041.t1 vdd.n36 6.43566201339119e-05f
CMODEL11028 a_19896_8041.t1 vdd.n37 0.000753197119226859f
CMODEL11029 a_19896_8041.t1 vdd.n38 0.000434479175865345f
CMODEL11030 a_19896_8041.t1 vdd.t19 3.75148451559624e-05f
CMODEL11031 a_19896_8041.t1 vdd.t18 0.000296535413668294f
CMODEL11032 a_19896_8041.t1 vdd.n39 0.000366640234637293f
CMODEL11033 a_19896_8041.t1 vdd.t21 3.75151887834633e-05f
CMODEL11034 a_19896_8041.t1 vdd.t20 0.000296535413668294f
CMODEL11035 a_19896_8041.t1 vdd.n40 0.000366640234637293f
CMODEL11036 a_19896_8041.t1 vdd.t11 3.75148451559624e-05f
CMODEL11037 a_19896_8041.t1 vdd.t10 0.000296535413668294f
CMODEL11038 a_19896_8041.t1 vdd.n41 0.00157735331738996f
CMODEL11039 a_19896_8041.t1 vdd.n42 0.00302141696345508f
CMODEL11040 a_19896_8041.t1 vdd.n43 0.000366640234637293f
CMODEL11041 a_19896_8041.t1 vdd.t13 3.75148451559624e-05f
CMODEL11042 a_19896_8041.t1 vdd.t12 0.000296535413668294f
CMODEL11043 a_19896_8041.t1 vdd.n44 0.000366640234637293f
CMODEL11044 a_19896_8041.t1 vdd.t23 3.75148451559624e-05f
CMODEL11045 a_19896_8041.t1 vdd.t22 0.000296535413668294f
CMODEL11046 a_19896_8041.t1 vdd.n45 0.00045260209026291f
CMODEL11047 a_19896_8041.t1 vdd.n46 0.0074706680461077f
CMODEL11048 a_19896_8041.t0 vdd 6.92830429645939e-06f
CMODEL11049 a_19896_8041.t0 vdd.n0 0.00232500999672213f
CMODEL11050 a_19896_8041.t0 vdd.n1 0.000215460438534083f
CMODEL11051 a_19896_8041.t0 vdd.t7 1.77617832836841e-05f
CMODEL11052 a_19896_8041.t0 vdd.t6 0.000140397694075961f
CMODEL11053 a_19896_8041.t0 vdd.n2 0.000193212045029793f
CMODEL11054 a_19896_8041.t0 vdd.t27 1.77617832836841e-05f
CMODEL11055 a_19896_8041.t0 vdd.t26 0.000140397694075961f
CMODEL11056 a_19896_8041.t0 vdd.n3 0.000362394198135758f
CMODEL11057 a_19896_8041.t0 vdd.n4 0.000193212045029793f
CMODEL11058 a_19896_8041.t0 vdd.t36 1.77617832836841e-05f
CMODEL11059 a_19896_8041.t0 vdd.t35 0.000140397694075961f
CMODEL11060 a_19896_8041.t0 vdd.n5 0.000275683219810484f
CMODEL11061 a_19896_8041.t0 vdd.t3 2.82934487806726e-05f
CMODEL11062 a_19896_8041.t0 vdd.n6 0.000270698278114166f
CMODEL11063 a_19896_8041.t0 vdd.t2 0.000354768734124452f
CMODEL11064 a_19896_8041.t0 vdd.n7 0.000362882279894535f
CMODEL11065 a_19896_8041.t0 vdd.t25 2.82934487806726e-05f
CMODEL11066 a_19896_8041.t0 vdd.n8 0.000163504135312182f
CMODEL11067 a_19896_8041.t0 vdd.t24 0.000354768734124452f
CMODEL11068 a_19896_8041.t0 vdd.n9 0.000362882279894535f
CMODEL11069 a_19896_8041.t0 vdd.t5 2.82934487806726e-05f
CMODEL11070 a_19896_8041.t0 vdd.n10 0.000484151073680476f
CMODEL11071 a_19896_8041.t0 vdd.t4 0.000354963966827963f
CMODEL11072 a_19896_8041.t0 vdd.n11 0.0011705957669824f
CMODEL11073 a_19896_8041.t0 vdd.n12 0.00288625521114076f
CMODEL11074 a_19896_8041.t0 vdd.n13 0.000218774513676184f
CMODEL11075 a_19896_8041.t0 vdd.t42 1.77617832836841e-05f
CMODEL11076 a_19896_8041.t0 vdd.t41 0.000140397694075961f
CMODEL11077 a_19896_8041.t0 vdd.n14 0.000196695321848271f
CMODEL11078 a_19896_8041.t0 vdd.t9 1.77617832836841e-05f
CMODEL11079 a_19896_8041.t0 vdd.t8 0.000140397694075961f
CMODEL11080 a_19896_8041.t0 vdd.n15 0.00037762885676641f
CMODEL11081 a_19896_8041.t0 vdd.t15 2.99125786684583e-05f
CMODEL11082 a_19896_8041.t0 vdd.n16 0.000235286319575638f
CMODEL11083 a_19896_8041.t0 vdd.t14 0.000403502070799223f
CMODEL11084 a_19896_8041.t0 vdd.n17 0.000329585342310712f
CMODEL11085 a_19896_8041.t0 vdd.t32 0.000403502070799223f
CMODEL11086 a_19896_8041.t0 vdd.n18 0.000325345538766128f
CMODEL11087 a_19896_8041.t0 vdd.t34 2.99125786684583e-05f
CMODEL11088 a_19896_8041.t0 vdd.n19 0.000327626507518817f
CMODEL11089 a_19896_8041.t0 vdd.t33 0.000403502070799223f
CMODEL11090 a_19896_8041.t0 vdd.n20 0.000653826189362806f
CMODEL11091 a_19896_8041.t0 vdd.t48 0.000404273239978092f
CMODEL11092 a_19896_8041.t0 vdd.n21 0.0011606128680762f
CMODEL11093 a_19896_8041.t0 vdd.n22 0.00508623493065596f
CMODEL11094 a_19896_8041.t0 vdd.t47 5.75036777982496e-06f
CMODEL11095 a_19896_8041.t0 vdd.t45 5.6913261564048e-06f
CMODEL11096 a_19896_8041.t0 vdd.n23 6.49884115691077e-05f
CMODEL11097 a_19896_8041.t0 vdd.t46 0.00015509839126251f
CMODEL11098 a_19896_8041.t0 vdd.n24 0.000166639247142732f
CMODEL11099 a_19896_8041.t0 vdd.t44 0.00015509839126251f
CMODEL11100 a_19896_8041.t0 vdd.n25 0.000262805996074728f
CMODEL11101 a_19896_8041.t0 vdd.t43 0.000155434354206469f
CMODEL11102 a_19896_8041.t0 vdd.n26 0.00140616029316055f
CMODEL11103 a_19896_8041.t0 vdd.n27 0.000940047094345303f
CMODEL11104 a_19896_8041.t0 vdd.n28 0.000212339969156296f
CMODEL11105 a_19896_8041.t0 vdd.t29 1.77617832836841e-05f
CMODEL11106 a_19896_8041.t0 vdd.t28 0.000140397694075961f
CMODEL11107 a_19896_8041.t0 vdd.n29 3.16970055785501e-05f
CMODEL11108 a_19896_8041.t0 vdd.n30 1.01120453395752e-05f
CMODEL11109 a_19896_8041.t0 vdd.t38 4.65581189698175e-06f
CMODEL11110 a_19896_8041.t0 vdd.t40 4.65581189698175e-06f
CMODEL11111 a_19896_8041.t0 vdd.t37 9.40800367193017e-05f
CMODEL11112 a_19896_8041.t0 vdd.t39 9.40800367193017e-05f
CMODEL11113 a_19896_8041.t0 vdd.n31 3.04702934248218e-05f
CMODEL11114 a_19896_8041.t0 vdd.n32 0.00036771266236724f
CMODEL11115 a_19896_8041.t0 vdd.n33 0.00018632033059585f
CMODEL11116 a_19896_8041.t0 vdd.t17 1.77617832836841e-05f
CMODEL11117 a_19896_8041.t0 vdd.t16 0.000140397694075961f
CMODEL11118 a_19896_8041.t0 vdd.n34 3.16970055785501e-05f
CMODEL11119 a_19896_8041.t0 vdd.n35 1.01120453395752e-05f
CMODEL11120 a_19896_8041.t0 vdd.t1 4.65581189698175e-06f
CMODEL11121 a_19896_8041.t0 vdd.t31 4.65581189698175e-06f
CMODEL11122 a_19896_8041.t0 vdd.t0 9.40800367193017e-05f
CMODEL11123 a_19896_8041.t0 vdd.t30 9.40800367193017e-05f
CMODEL11124 a_19896_8041.t0 vdd.n36 3.04702934248218e-05f
CMODEL11125 a_19896_8041.t0 vdd.n37 0.000356608802355044f
CMODEL11126 a_19896_8041.t0 vdd.n38 0.000205708564993702f
CMODEL11127 a_19896_8041.t0 vdd.t19 1.77617832836841e-05f
CMODEL11128 a_19896_8041.t0 vdd.t18 0.000140397694075961f
CMODEL11129 a_19896_8041.t0 vdd.n39 0.000173589531387728f
CMODEL11130 a_19896_8041.t0 vdd.t21 1.77619459776037e-05f
CMODEL11131 a_19896_8041.t0 vdd.t20 0.000140397694075961f
CMODEL11132 a_19896_8041.t0 vdd.n40 0.000173589531387728f
CMODEL11133 a_19896_8041.t0 vdd.t11 1.77617832836841e-05f
CMODEL11134 a_19896_8041.t0 vdd.t10 0.000140397694075961f
CMODEL11135 a_19896_8041.t0 vdd.n41 0.000746813899105963f
CMODEL11136 a_19896_8041.t0 vdd.n42 0.00143052045374115f
CMODEL11137 a_19896_8041.t0 vdd.n43 0.000173589531387728f
CMODEL11138 a_19896_8041.t0 vdd.t13 1.77617832836841e-05f
CMODEL11139 a_19896_8041.t0 vdd.t12 0.000140397694075961f
CMODEL11140 a_19896_8041.t0 vdd.n44 0.000173589531387728f
CMODEL11141 a_19896_8041.t0 vdd.t23 1.77617832836841e-05f
CMODEL11142 a_19896_8041.t0 vdd.t22 0.000140397694075961f
CMODEL11143 a_19896_8041.t0 vdd.n45 0.000214289042313016f
CMODEL11144 a_19896_8041.t0 vdd.n46 0.00353706342829512f
CMODEL11145 a_19896_8041.n0 vdd 2.07567784239116e-05f
CMODEL11146 a_19896_8041.n0 vdd.n0 0.00696558858709526f
CMODEL11147 a_19896_8041.n0 vdd.n1 0.000645506373623956f
CMODEL11148 a_19896_8041.n0 vdd.t7 5.32132227825754e-05f
CMODEL11149 a_19896_8041.n0 vdd.t6 0.000420622955122239f
CMODEL11150 a_19896_8041.n0 vdd.n2 0.000578851539411127f
CMODEL11151 a_19896_8041.n0 vdd.t27 5.32132227825754e-05f
CMODEL11152 a_19896_8041.n0 vdd.t26 0.000420622955122239f
CMODEL11153 a_19896_8041.n0 vdd.n3 0.00108571098366149f
CMODEL11154 a_19896_8041.n0 vdd.n4 0.000578851539411127f
CMODEL11155 a_19896_8041.n0 vdd.t36 5.32132227825754e-05f
CMODEL11156 a_19896_8041.n0 vdd.t35 0.000420622955122239f
CMODEL11157 a_19896_8041.n0 vdd.n5 0.000825930164718807f
CMODEL11158 a_19896_8041.n0 vdd.t3 8.47654522750732e-05f
CMODEL11159 a_19896_8041.n0 vdd.n6 0.000810995582486404f
CMODEL11160 a_19896_8041.n0 vdd.t2 0.00106286555711995f
CMODEL11161 a_19896_8041.n0 vdd.n7 0.00108717324693489f
CMODEL11162 a_19896_8041.n0 vdd.t25 8.47654522750732e-05f
CMODEL11163 a_19896_8041.n0 vdd.n8 0.000489848448169719f
CMODEL11164 a_19896_8041.n0 vdd.t24 0.00106286555711995f
CMODEL11165 a_19896_8041.n0 vdd.n9 0.00108717324693489f
CMODEL11166 a_19896_8041.n0 vdd.t5 8.47654522750732e-05f
CMODEL11167 a_19896_8041.n0 vdd.n10 0.00145048717984574f
CMODEL11168 a_19896_8041.n0 vdd.t4 0.00106345046242931f
CMODEL11169 a_19896_8041.n0 vdd.n11 0.00350703374440982f
CMODEL11170 a_19896_8041.n0 vdd.n12 0.00864704512518664f
CMODEL11171 a_19896_8041.n0 vdd.n13 0.000655435141250394f
CMODEL11172 a_19896_8041.n0 vdd.t42 5.32132227825754e-05f
CMODEL11173 a_19896_8041.n0 vdd.t41 0.000420622955122239f
CMODEL11174 a_19896_8041.n0 vdd.n14 0.000589287224972346f
CMODEL11175 a_19896_8041.n0 vdd.t9 5.32132227825754e-05f
CMODEL11176 a_19896_8041.n0 vdd.t8 0.000420622955122239f
CMODEL11177 a_19896_8041.n0 vdd.n15 0.00113135309463545f
CMODEL11178 a_19896_8041.n0 vdd.t15 8.96162669740573e-05f
CMODEL11179 a_19896_8041.n0 vdd.n16 0.000704903507789772f
CMODEL11180 a_19896_8041.n0 vdd.t14 0.00120886767075879f
CMODEL11181 a_19896_8041.n0 vdd.n17 0.000987417646423029f
CMODEL11182 a_19896_8041.n0 vdd.t32 0.00120886767075879f
CMODEL11183 a_19896_8041.n0 vdd.n18 0.000974715452788028f
CMODEL11184 a_19896_8041.n0 vdd.t34 8.96162669740573e-05f
CMODEL11185 a_19896_8041.n0 vdd.n19 0.000981549096485753f
CMODEL11186 a_19896_8041.n0 vdd.t33 0.00120886767075879f
CMODEL11187 a_19896_8041.n0 vdd.n20 0.00195882351000225f
CMODEL11188 a_19896_8041.n0 vdd.t48 0.00121117804673077f
CMODEL11189 a_19896_8041.n0 vdd.n21 0.00347712558625772f
CMODEL11190 a_19896_8041.n0 vdd.n22 0.015238050603744f
CMODEL11191 a_19896_8041.n0 vdd.t47 1.72277522398697e-05f
CMODEL11192 a_19896_8041.n0 vdd.t45 1.70508671258965e-05f
CMODEL11193 a_19896_8041.n0 vdd.n23 0.000194701329696402f
CMODEL11194 a_19896_8041.n0 vdd.t46 0.000464665350075093f
CMODEL11195 a_19896_8041.n0 vdd.n24 0.000499241052595907f
CMODEL11196 a_19896_8041.n0 vdd.t44 0.000464665350075093f
CMODEL11197 a_19896_8041.n0 vdd.n25 0.000787350785355403f
CMODEL11198 a_19896_8041.n0 vdd.t43 0.000465671874628289f
CMODEL11199 a_19896_8041.n0 vdd.n26 0.00421277074226543f
CMODEL11200 a_19896_8041.n0 vdd.n27 0.00281632393879392f
CMODEL11201 a_19896_8041.n0 vdd.n28 0.00063615763709597f
CMODEL11202 a_19896_8041.n0 vdd.t29 5.32132227825754e-05f
CMODEL11203 a_19896_8041.n0 vdd.t28 0.000420622955122239f
CMODEL11204 a_19896_8041.n0 vdd.n29 9.49623015016354e-05f
CMODEL11205 a_19896_8041.n0 vdd.n30 3.02950730142401e-05f
CMODEL11206 a_19896_8041.n0 vdd.t38 1.3948529365035e-05f
CMODEL11207 a_19896_8041.n0 vdd.t40 1.3948529365035e-05f
CMODEL11208 a_19896_8041.n0 vdd.t37 0.000281858069844588f
CMODEL11209 a_19896_8041.n0 vdd.t39 0.000281858069844588f
CMODEL11210 a_19896_8041.n0 vdd.n31 9.1287146474471e-05f
CMODEL11211 a_19896_8041.n0 vdd.n32 0.00110164477913072f
CMODEL11212 a_19896_8041.n0 vdd.n33 0.000558204381990612f
CMODEL11213 a_19896_8041.n0 vdd.t17 5.32132227825754e-05f
CMODEL11214 a_19896_8041.n0 vdd.t16 0.000420622955122239f
CMODEL11215 a_19896_8041.n0 vdd.n34 9.49623015016354e-05f
CMODEL11216 a_19896_8041.n0 vdd.n35 3.02950730142401e-05f
CMODEL11217 a_19896_8041.n0 vdd.t1 1.3948529365035e-05f
CMODEL11218 a_19896_8041.n0 vdd.t31 1.3948529365035e-05f
CMODEL11219 a_19896_8041.n0 vdd.t0 0.000281858069844588f
CMODEL11220 a_19896_8041.n0 vdd.t30 0.000281858069844588f
CMODEL11221 a_19896_8041.n0 vdd.n36 9.1287146474471e-05f
CMODEL11222 a_19896_8041.n0 vdd.n37 0.0010683782896607f
CMODEL11223 a_19896_8041.n0 vdd.n38 0.000616290353421273f
CMODEL11224 a_19896_8041.n0 vdd.t19 5.32132227825754e-05f
CMODEL11225 a_19896_8041.n0 vdd.t18 0.000420622955122239f
CMODEL11226 a_19896_8041.n0 vdd.n39 0.000520063681609231f
CMODEL11227 a_19896_8041.n0 vdd.t21 5.32137102036666e-05f
CMODEL11228 a_19896_8041.n0 vdd.t20 0.000420622955122239f
CMODEL11229 a_19896_8041.n0 vdd.n40 0.000520063681609231f
CMODEL11230 a_19896_8041.n0 vdd.t11 5.32132227825754e-05f
CMODEL11231 a_19896_8041.n0 vdd.t10 0.000420622955122239f
CMODEL11232 a_19896_8041.n0 vdd.n41 0.00223740903464095f
CMODEL11233 a_19896_8041.n0 vdd.n42 0.0042857523022412f
CMODEL11234 a_19896_8041.n0 vdd.n43 0.000520063681609231f
CMODEL11235 a_19896_8041.n0 vdd.t13 5.32132227825754e-05f
CMODEL11236 a_19896_8041.n0 vdd.t12 0.000420622955122239f
CMODEL11237 a_19896_8041.n0 vdd.n44 0.000520063681609231f
CMODEL11238 a_19896_8041.n0 vdd.t23 5.32132227825754e-05f
CMODEL11239 a_19896_8041.n0 vdd.t22 0.000420622955122239f
CMODEL11240 a_19896_8041.n0 vdd.n45 0.000641996941767778f
CMODEL11241 a_19896_8041.n0 vdd.n46 0.0105968269739483f
CMODEL11242 a_19896_8041.t3 vdd 6.91711969338455e-06f
CMODEL11243 a_19896_8041.t3 vdd.n0 0.00232125665205861f
CMODEL11244 a_19896_8041.t3 vdd.n1 0.000215112613239434f
CMODEL11245 a_19896_8041.t3 vdd.t7 1.77331098179371e-05f
CMODEL11246 a_19896_8041.t3 vdd.t6 0.000140171045185602f
CMODEL11247 a_19896_8041.t3 vdd.n2 0.000192900136092127f
CMODEL11248 a_19896_8041.t3 vdd.t27 1.77331098179371e-05f
CMODEL11249 a_19896_8041.t3 vdd.t26 0.000140171045185602f
CMODEL11250 a_19896_8041.t3 vdd.n3 0.000361809172552392f
CMODEL11251 a_19896_8041.t3 vdd.n4 0.000192900136092127f
CMODEL11252 a_19896_8041.t3 vdd.t36 1.77331098179371e-05f
CMODEL11253 a_19896_8041.t3 vdd.t35 0.000140171045185602f
CMODEL11254 a_19896_8041.t3 vdd.n5 0.000275238174781277f
CMODEL11255 a_19896_8041.t3 vdd.t3 2.82477736802889e-05f
CMODEL11256 a_19896_8041.t3 vdd.n6 0.000270261280450063f
CMODEL11257 a_19896_8041.t3 vdd.t2 0.000354196018593385f
CMODEL11258 a_19896_8041.t3 vdd.n7 0.000362296466383777f
CMODEL11259 a_19896_8041.t3 vdd.t25 2.82477736802889e-05f
CMODEL11260 a_19896_8041.t3 vdd.n8 0.000163240184888484f
CMODEL11261 a_19896_8041.t3 vdd.t24 0.000354196018593385f
CMODEL11262 a_19896_8041.t3 vdd.n9 0.000362296466383777f
CMODEL11263 a_19896_8041.t3 vdd.t5 2.82477736802889e-05f
CMODEL11264 a_19896_8041.t3 vdd.n10 0.000483369491729732f
CMODEL11265 a_19896_8041.t3 vdd.t4 0.000354390936125939f
CMODEL11266 a_19896_8041.t3 vdd.n11 0.0011687060334409f
CMODEL11267 a_19896_8041.t3 vdd.n12 0.0028815958287684f
CMODEL11268 a_19896_8041.t3 vdd.n13 0.000218421338354539f
CMODEL11269 a_19896_8041.t3 vdd.t42 1.77331098179371e-05f
CMODEL11270 a_19896_8041.t3 vdd.t41 0.000140171045185602f
CMODEL11271 a_19896_8041.t3 vdd.n14 0.000196377789735446f
CMODEL11272 a_19896_8041.t3 vdd.t9 1.77331098179371e-05f
CMODEL11273 a_19896_8041.t3 vdd.t8 0.000140171045185602f
CMODEL11274 a_19896_8041.t3 vdd.n15 0.000377019237342694f
CMODEL11275 a_19896_8041.t3 vdd.t15 2.98642897502706e-05f
CMODEL11276 a_19896_8041.t3 vdd.n16 0.000234906488670299f
CMODEL11277 a_19896_8041.t3 vdd.t14 0.000402850683344421f
CMODEL11278 a_19896_8041.t3 vdd.n17 0.000329053281206682f
CMODEL11279 a_19896_8041.t3 vdd.t32 0.000402850683344421f
CMODEL11280 a_19896_8041.t3 vdd.n18 0.000324820322124716f
CMODEL11281 a_19896_8041.t3 vdd.t34 2.98642897502706e-05f
CMODEL11282 a_19896_8041.t3 vdd.n19 0.000327097608630056f
CMODEL11283 a_19896_8041.t3 vdd.t33 0.000402850683344421f
CMODEL11284 a_19896_8041.t3 vdd.n20 0.000652770694959696f
CMODEL11285 a_19896_8041.t3 vdd.t48 0.000403620607598009f
CMODEL11286 a_19896_8041.t3 vdd.n21 0.0011587392502763f
CMODEL11287 a_19896_8041.t3 vdd.n22 0.00507802404435384f
CMODEL11288 a_19896_8041.t3 vdd.t47 5.74108476071962e-06f
CMODEL11289 a_19896_8041.t3 vdd.t45 5.68213845024973e-06f
CMODEL11290 a_19896_8041.t3 vdd.n23 6.48834985114876e-05f
CMODEL11291 a_19896_8041.t3 vdd.t46 0.000154848010524369f
CMODEL11292 a_19896_8041.t3 vdd.n24 0.000166370235598748f
CMODEL11293 a_19896_8041.t3 vdd.t44 0.000154848010524369f
CMODEL11294 a_19896_8041.t3 vdd.n25 0.000262381739196565f
CMODEL11295 a_19896_8041.t3 vdd.t43 0.000155183431111639f
CMODEL11296 a_19896_8041.t3 vdd.n26 0.00140389027959509f
CMODEL11297 a_19896_8041.t3 vdd.n27 0.000938529543560579f
CMODEL11298 a_19896_8041.t3 vdd.n28 0.000211997181344111f
CMODEL11299 a_19896_8041.t3 vdd.t29 1.77331098179371e-05f
CMODEL11300 a_19896_8041.t3 vdd.t28 0.000140171045185602f
CMODEL11301 a_19896_8041.t3 vdd.n29 3.16458359978147e-05f
CMODEL11302 a_19896_8041.t3 vdd.n30 1.00957211123822e-05f
CMODEL11303 a_19896_8041.t3 vdd.t38 4.64829585758299e-06f
CMODEL11304 a_19896_8041.t3 vdd.t40 4.64829585758299e-06f
CMODEL11305 a_19896_8041.t3 vdd.t37 9.39281600373683e-05f
CMODEL11306 a_19896_8041.t3 vdd.t39 9.39281600373683e-05f
CMODEL11307 a_19896_8041.t3 vdd.n31 3.04211041682667e-05f
CMODEL11308 a_19896_8041.t3 vdd.n32 0.000367119051001719f
CMODEL11309 a_19896_8041.t3 vdd.n33 0.000186019547192969f
CMODEL11310 a_19896_8041.t3 vdd.t17 1.77331098179371e-05f
CMODEL11311 a_19896_8041.t3 vdd.t16 0.000140171045185602f
CMODEL11312 a_19896_8041.t3 vdd.n34 3.16458359978147e-05f
CMODEL11313 a_19896_8041.t3 vdd.n35 1.00957211123822e-05f
CMODEL11314 a_19896_8041.t3 vdd.t1 4.64829585758299e-06f
CMODEL11315 a_19896_8041.t3 vdd.t31 4.64829585758299e-06f
CMODEL11316 a_19896_8041.t3 vdd.t0 9.39281600373683e-05f
CMODEL11317 a_19896_8041.t3 vdd.t30 9.39281600373683e-05f
CMODEL11318 a_19896_8041.t3 vdd.n36 3.04211041682667e-05f
CMODEL11319 a_19896_8041.t3 vdd.n37 0.000356033116337707f
CMODEL11320 a_19896_8041.t3 vdd.n38 0.000205376482488358f
CMODEL11321 a_19896_8041.t3 vdd.t19 1.77331098179371e-05f
CMODEL11322 a_19896_8041.t3 vdd.t18 0.000140171045185602f
CMODEL11323 a_19896_8041.t3 vdd.n39 0.000173309299757673f
CMODEL11324 a_19896_8041.t3 vdd.t21 1.77332722492143e-05f
CMODEL11325 a_19896_8041.t3 vdd.t20 0.000140171045185602f
CMODEL11326 a_19896_8041.t3 vdd.n40 0.000173309299757673f
CMODEL11327 a_19896_8041.t3 vdd.t11 1.77331098179371e-05f
CMODEL11328 a_19896_8041.t3 vdd.t10 0.000140171045185602f
CMODEL11329 a_19896_8041.t3 vdd.n41 0.000745608291402425f
CMODEL11330 a_19896_8041.t3 vdd.n42 0.00142821111471952f
CMODEL11331 a_19896_8041.t3 vdd.n43 0.000173309299757673f
CMODEL11332 a_19896_8041.t3 vdd.t13 1.77331098179371e-05f
CMODEL11333 a_19896_8041.t3 vdd.t12 0.000140171045185602f
CMODEL11334 a_19896_8041.t3 vdd.n44 0.000173309299757673f
CMODEL11335 a_19896_8041.t3 vdd.t23 1.77331098179371e-05f
CMODEL11336 a_19896_8041.t3 vdd.t22 0.000140171045185602f
CMODEL11337 a_19896_8041.t3 vdd.n45 0.000213943108044109f
CMODEL11338 a_19896_8041.t3 vdd.n46 0.00353135342353736f
CMODEL11339 a_19896_8041.t4 vdd 6.47246445980118e-06f
CMODEL11340 a_19896_8041.t4 vdd.n0 0.00217203863002334f
CMODEL11341 a_19896_8041.t4 vdd.n1 0.000201284466044267f
CMODEL11342 a_19896_8041.t4 vdd.t7 1.65931671195629e-05f
CMODEL11343 a_19896_8041.t4 vdd.t6 0.000131160388785043f
CMODEL11344 a_19896_8041.t4 vdd.n2 0.00018049988007887f
CMODEL11345 a_19896_8041.t4 vdd.t27 1.65931671195629e-05f
CMODEL11346 a_19896_8041.t4 vdd.t26 0.000131160388785043f
CMODEL11347 a_19896_8041.t4 vdd.n3 0.000338550887418515f
CMODEL11348 a_19896_8041.t4 vdd.n4 0.00018049988007887f
CMODEL11349 a_19896_8041.t4 vdd.t36 1.65931671195629e-05f
CMODEL11350 a_19896_8041.t4 vdd.t35 0.000131160388785043f
CMODEL11351 a_19896_8041.t4 vdd.n5 0.000257544958482666f
CMODEL11352 a_19896_8041.t4 vdd.t3 2.64319137615959e-05f
CMODEL11353 a_19896_8041.t4 vdd.n6 0.00025288799530914f
CMODEL11354 a_19896_8041.t4 vdd.t2 0.000331427132067889f
CMODEL11355 a_19896_8041.t4 vdd.n7 0.000339006856397647f
CMODEL11356 a_19896_8041.t4 vdd.t25 2.64319137615959e-05f
CMODEL11357 a_19896_8041.t4 vdd.n8 0.000152746568215752f
CMODEL11358 a_19896_8041.t4 vdd.t24 0.000331427132067889f
CMODEL11359 a_19896_8041.t4 vdd.n9 0.000339006856397647f
CMODEL11360 a_19896_8041.t4 vdd.t5 2.64319137615959e-05f
CMODEL11361 a_19896_8041.t4 vdd.n10 0.000452296908952581f
CMODEL11362 a_19896_8041.t4 vdd.t4 0.000331609519659542f
CMODEL11363 a_19896_8041.t4 vdd.n11 0.00109357776078907f
CMODEL11364 a_19896_8041.t4 vdd.n12 0.00269635735912628f
CMODEL11365 a_19896_8041.t4 vdd.n13 0.000204380495412568f
CMODEL11366 a_19896_8041.t4 vdd.t42 1.65931671195629e-05f
CMODEL11367 a_19896_8041.t4 vdd.t41 0.000131160388785043f
CMODEL11368 a_19896_8041.t4 vdd.n14 0.00018375397869327f
CMODEL11369 a_19896_8041.t4 vdd.t9 1.65931671195629e-05f
CMODEL11370 a_19896_8041.t4 vdd.t8 0.000131160388785043f
CMODEL11371 a_19896_8041.t4 vdd.n15 0.000352783199153797f
CMODEL11372 a_19896_8041.t4 vdd.t15 2.79445148550337e-05f
CMODEL11373 a_19896_8041.t4 vdd.n16 0.000219805925976576f
CMODEL11374 a_19896_8041.t4 vdd.t14 0.000376954114737541f
CMODEL11375 a_19896_8041.t4 vdd.n17 0.000307900652641317f
CMODEL11376 a_19896_8041.t4 vdd.t32 0.000376954114737541f
CMODEL11377 a_19896_8041.t4 vdd.n18 0.000303939802109264f
CMODEL11378 a_19896_8041.t4 vdd.t34 2.79445148550337e-05f
CMODEL11379 a_19896_8041.t4 vdd.n19 0.000306070697138404f
CMODEL11380 a_19896_8041.t4 vdd.t33 0.000376954114737541f
CMODEL11381 a_19896_8041.t4 vdd.n20 0.000610808444961148f
CMODEL11382 a_19896_8041.t4 vdd.t48 0.000377674545724568f
CMODEL11383 a_19896_8041.t4 vdd.n21 0.00108425167526924f
CMODEL11384 a_19896_8041.t4 vdd.n22 0.00475159193566218f
CMODEL11385 a_19896_8041.t4 vdd.t47 5.37202892556598e-06f
CMODEL11386 a_19896_8041.t4 vdd.t45 5.31687187805708e-06f
CMODEL11387 a_19896_8041.t4 vdd.n23 6.07125735506365e-05f
CMODEL11388 a_19896_8041.t4 vdd.t46 0.000144893870457155f
CMODEL11389 a_19896_8041.t4 vdd.n24 0.000155675408958372f
CMODEL11390 a_19896_8041.t4 vdd.t44 0.000144893870457155f
CMODEL11391 a_19896_8041.t4 vdd.n25 0.000245514976916589f
CMODEL11392 a_19896_8041.t4 vdd.t43 0.000145207729104457f
CMODEL11393 a_19896_8041.t4 vdd.n26 0.00131364358908375f
CMODEL11394 a_19896_8041.t4 vdd.n27 0.000878197773703257f
CMODEL11395 a_19896_8041.t4 vdd.n28 0.000198369304371021f
CMODEL11396 a_19896_8041.t4 vdd.t29 1.65931671195629e-05f
CMODEL11397 a_19896_8041.t4 vdd.t28 0.000131160388785043f
CMODEL11398 a_19896_8041.t4 vdd.n29 2.96115374427373e-05f
CMODEL11399 a_19896_8041.t4 vdd.n30 9.44673491170792e-06f
CMODEL11400 a_19896_8041.t4 vdd.t38 4.34948809193236e-06f
CMODEL11401 a_19896_8041.t4 vdd.t40 4.34948809193236e-06f
CMODEL11402 a_19896_8041.t4 vdd.t37 8.78901485827716e-05f
CMODEL11403 a_19896_8041.t4 vdd.t39 8.78901485827716e-05f
CMODEL11404 a_19896_8041.t4 vdd.n31 2.8465535408521e-05f
CMODEL11405 a_19896_8041.t4 vdd.n32 0.000343519429394448f
CMODEL11406 a_19896_8041.t4 vdd.n33 0.000174061598093538f
CMODEL11407 a_19896_8041.t4 vdd.t17 1.65931671195629e-05f
CMODEL11408 a_19896_8041.t4 vdd.t16 0.000131160388785043f
CMODEL11409 a_19896_8041.t4 vdd.n34 2.96115374427373e-05f
CMODEL11410 a_19896_8041.t4 vdd.n35 9.44673491170792e-06f
CMODEL11411 a_19896_8041.t4 vdd.t1 4.34948809193236e-06f
CMODEL11412 a_19896_8041.t4 vdd.t31 4.34948809193236e-06f
CMODEL11413 a_19896_8041.t4 vdd.t0 8.78901485827716e-05f
CMODEL11414 a_19896_8041.t4 vdd.t30 8.78901485827716e-05f
CMODEL11415 a_19896_8041.t4 vdd.n36 2.8465535408521e-05f
CMODEL11416 a_19896_8041.t4 vdd.n37 0.000333146135119214f
CMODEL11417 a_19896_8041.t4 vdd.n38 0.000192174205841226f
CMODEL11418 a_19896_8041.t4 vdd.t19 1.65931671195629e-05f
CMODEL11419 a_19896_8041.t4 vdd.t18 0.000131160388785043f
CMODEL11420 a_19896_8041.t4 vdd.n39 0.0001621684072212f
CMODEL11421 a_19896_8041.t4 vdd.t21 1.65933191092226e-05f
CMODEL11422 a_19896_8041.t4 vdd.t20 0.000131160388785043f
CMODEL11423 a_19896_8041.t4 vdd.n40 0.0001621684072212f
CMODEL11424 a_19896_8041.t4 vdd.t11 1.65931671195629e-05f
CMODEL11425 a_19896_8041.t4 vdd.t10 0.000131160388785043f
CMODEL11426 a_19896_8041.t4 vdd.n41 0.000697678134968624f
CMODEL11427 a_19896_8041.t4 vdd.n42 0.00133640100083218f
CMODEL11428 a_19896_8041.t4 vdd.n43 0.0001621684072212f
CMODEL11429 a_19896_8041.t4 vdd.t13 1.65931671195629e-05f
CMODEL11430 a_19896_8041.t4 vdd.t12 0.000131160388785043f
CMODEL11431 a_19896_8041.t4 vdd.n44 0.0001621684072212f
CMODEL11432 a_19896_8041.t4 vdd.t23 1.65931671195629e-05f
CMODEL11433 a_19896_8041.t4 vdd.t22 0.000131160388785043f
CMODEL11434 a_19896_8041.t4 vdd.n45 0.000200190140494352f
CMODEL11435 a_19896_8041.t4 vdd.n46 0.0033043463958998f
CMODEL11436 a_19896_8041.t2 vdd 6.50886246362203e-06f
CMODEL11437 a_19896_8041.t2 vdd.n0 0.00218425312279431f
CMODEL11438 a_19896_8041.t2 vdd.n1 0.000202416392346784f
CMODEL11439 a_19896_8041.t2 vdd.t7 1.66864790510488e-05f
CMODEL11440 a_19896_8041.t2 vdd.t6 0.000131897971256418f
CMODEL11441 a_19896_8041.t2 vdd.n2 0.000181514923941309f
CMODEL11442 a_19896_8041.t2 vdd.t27 1.66864790510488e-05f
CMODEL11443 a_19896_8041.t2 vdd.t26 0.000131897971256418f
CMODEL11444 a_19896_8041.t2 vdd.n3 0.000340454733560946f
CMODEL11445 a_19896_8041.t2 vdd.n4 0.000181514923941309f
CMODEL11446 a_19896_8041.t2 vdd.t36 1.66864790510488e-05f
CMODEL11447 a_19896_8041.t2 vdd.t35 0.000131897971256418f
CMODEL11448 a_19896_8041.t2 vdd.n5 0.000258993266533041f
CMODEL11449 a_19896_8041.t2 vdd.t3 2.65805540367279e-05f
CMODEL11450 a_19896_8041.t2 vdd.n6 0.000254310114855207f
CMODEL11451 a_19896_8041.t2 vdd.t2 0.000333290917662119f
CMODEL11452 a_19896_8041.t2 vdd.n7 0.000340913266688671f
CMODEL11453 a_19896_8041.t2 vdd.t25 2.65805540367279e-05f
CMODEL11454 a_19896_8041.t2 vdd.n8 0.000153605540900434f
CMODEL11455 a_19896_8041.t2 vdd.t24 0.000333290917662119f
CMODEL11456 a_19896_8041.t2 vdd.n9 0.000340913266688671f
CMODEL11457 a_19896_8041.t2 vdd.t5 2.65805540367279e-05f
CMODEL11458 a_19896_8041.t2 vdd.n10 0.000454840407603282f
CMODEL11459 a_19896_8041.t2 vdd.t4 0.000333474330913209f
CMODEL11460 a_19896_8041.t2 vdd.n11 0.00109972751221108f
CMODEL11461 a_19896_8041.t2 vdd.n12 0.00271152036636555f
CMODEL11462 a_19896_8041.t2 vdd.n13 0.000205529832284038f
CMODEL11463 a_19896_8041.t2 vdd.t42 1.66864790510488e-05f
CMODEL11464 a_19896_8041.t2 vdd.t41 0.000131897971256418f
CMODEL11465 a_19896_8041.t2 vdd.n14 0.000184787322029508f
CMODEL11466 a_19896_8041.t2 vdd.t9 1.66864790510488e-05f
CMODEL11467 a_19896_8041.t2 vdd.t8 0.000131897971256418f
CMODEL11468 a_19896_8041.t2 vdd.n15 0.00035476708092101f
CMODEL11469 a_19896_8041.t2 vdd.t15 2.81016612657684e-05f
CMODEL11470 a_19896_8041.t2 vdd.n16 0.000221042007994983f
CMODEL11471 a_19896_8041.t2 vdd.t14 0.000379073922021724f
CMODEL11472 a_19896_8041.t2 vdd.n17 0.000309632136715256f
CMODEL11473 a_19896_8041.t2 vdd.t32 0.000379073922021724f
CMODEL11474 a_19896_8041.t2 vdd.n18 0.000305649012279083f
CMODEL11475 a_19896_8041.t2 vdd.t34 2.81016612657684e-05f
CMODEL11476 a_19896_8041.t2 vdd.n19 0.000307791890429319f
CMODEL11477 a_19896_8041.t2 vdd.t33 0.000379073922021724f
CMODEL11478 a_19896_8041.t2 vdd.n20 0.000614243335681921f
CMODEL11479 a_19896_8041.t2 vdd.t48 0.00037979840436353f
CMODEL11480 a_19896_8041.t2 vdd.n21 0.00109034898130534f
CMODEL11481 a_19896_8041.t2 vdd.n22 0.00477831258627425f
CMODEL11482 a_19896_8041.t2 vdd.t47 5.40223861316997e-06f
CMODEL11483 a_19896_8041.t2 vdd.t45 5.3467713891528e-06f
CMODEL11484 a_19896_8041.t2 vdd.n23 6.10539916453661e-05f
CMODEL11485 a_19896_8041.t2 vdd.t46 0.00014570868337475f
CMODEL11486 a_19896_8041.t2 vdd.n24 0.000156550852024189f
CMODEL11487 a_19896_8041.t2 vdd.t44 0.00014570868337475f
CMODEL11488 a_19896_8041.t2 vdd.n25 0.00024689563417989f
CMODEL11489 a_19896_8041.t2 vdd.t43 0.000146024307011f
CMODEL11490 a_19896_8041.t2 vdd.n26 0.00132103088408887f
CMODEL11491 a_19896_8041.t2 vdd.n27 0.00088313633244255f
CMODEL11492 a_19896_8041.t2 vdd.n28 0.000199484837216861f
CMODEL11493 a_19896_8041.t2 vdd.t29 1.66864790510488e-05f
CMODEL11494 a_19896_8041.t2 vdd.t28 0.000131897971256418f
CMODEL11495 a_19896_8041.t2 vdd.n29 2.97780583807318e-05f
CMODEL11496 a_19896_8041.t2 vdd.n30 9.49985877133611e-06f
CMODEL11497 a_19896_8041.t2 vdd.t38 4.37394750537096e-06f
CMODEL11498 a_19896_8041.t2 vdd.t40 4.37394750537096e-06f
CMODEL11499 a_19896_8041.t2 vdd.t37 8.83844001903006e-05f
CMODEL11500 a_19896_8041.t2 vdd.t39 8.83844001903006e-05f
CMODEL11501 a_19896_8041.t2 vdd.n31 2.86256117863824e-05f
CMODEL11502 a_19896_8041.t2 vdd.n32 0.000345451216209392f
CMODEL11503 a_19896_8041.t2 vdd.n33 0.000175040436177829f
CMODEL11504 a_19896_8041.t2 vdd.t17 1.66864790510488e-05f
CMODEL11505 a_19896_8041.t2 vdd.t16 0.000131897971256418f
CMODEL11506 a_19896_8041.t2 vdd.n34 2.97780583807318e-05f
CMODEL11507 a_19896_8041.t2 vdd.n35 9.49985877133611e-06f
CMODEL11508 a_19896_8041.t2 vdd.t1 4.37394750537096e-06f
CMODEL11509 a_19896_8041.t2 vdd.t31 4.37394750537096e-06f
CMODEL11510 a_19896_8041.t2 vdd.t0 8.83844001903006e-05f
CMODEL11511 a_19896_8041.t2 vdd.t30 8.83844001903006e-05f
CMODEL11512 a_19896_8041.t2 vdd.n36 2.86256117863824e-05f
CMODEL11513 a_19896_8041.t2 vdd.n37 0.000335019587553643f
CMODEL11514 a_19896_8041.t2 vdd.n38 0.000193254900454834f
CMODEL11515 a_19896_8041.t2 vdd.t19 1.66864790510488e-05f
CMODEL11516 a_19896_8041.t2 vdd.t18 0.000131897971256418f
CMODEL11517 a_19896_8041.t2 vdd.n39 0.000163080363762996f
CMODEL11518 a_19896_8041.t2 vdd.t21 1.66866318954247e-05f
CMODEL11519 a_19896_8041.t2 vdd.t20 0.000131897971256418f
CMODEL11520 a_19896_8041.t2 vdd.n40 0.000163080363762996f
CMODEL11521 a_19896_8041.t2 vdd.t11 1.66864790510488e-05f
CMODEL11522 a_19896_8041.t2 vdd.t10 0.000131897971256418f
CMODEL11523 a_19896_8041.t2 vdd.n41 0.000701601538732373f
CMODEL11524 a_19896_8041.t2 vdd.n42 0.00134391627249363f
CMODEL11525 a_19896_8041.t2 vdd.n43 0.000163080363762996f
CMODEL11526 a_19896_8041.t2 vdd.t13 1.66864790510488e-05f
CMODEL11527 a_19896_8041.t2 vdd.t12 0.000131897971256418f
CMODEL11528 a_19896_8041.t2 vdd.n44 0.000163080363762996f
CMODEL11529 a_19896_8041.t2 vdd.t23 1.66864790510488e-05f
CMODEL11530 a_19896_8041.t2 vdd.t22 0.000131897971256418f
CMODEL11531 a_19896_8041.t2 vdd.n45 0.000201315912840244f
CMODEL11532 a_19896_8041.t2 vdd.n46 0.00332292843887437f
CMODEL11533 a_19896_8041.n1 vdd 0.000196587655694721f
CMODEL11534 a_19896_8041.n1 vdd.n0 0.0659711590548893f
CMODEL11535 a_19896_8041.n1 vdd.n1 0.00611359730952028f
CMODEL11536 a_19896_8041.n1 vdd.t7 0.000503982964270429f
CMODEL11537 a_19896_8041.n1 vdd.t6 0.00398372420758752f
CMODEL11538 a_19896_8041.n1 vdd.n2 0.00548230870918887f
CMODEL11539 a_19896_8041.n1 vdd.t27 0.000503982964270429f
CMODEL11540 a_19896_8041.n1 vdd.t26 0.00398372420758752f
CMODEL11541 a_19896_8041.n1 vdd.n3 0.0102827795663196f
CMODEL11542 a_19896_8041.n1 vdd.n4 0.00548230870918887f
CMODEL11543 a_19896_8041.n1 vdd.t36 0.000503982964270429f
CMODEL11544 a_19896_8041.n1 vdd.t35 0.00398372420758752f
CMODEL11545 a_19896_8041.n1 vdd.n5 0.00782239283638446f
CMODEL11546 a_19896_8041.n1 vdd.t3 0.000802814444820728f
CMODEL11547 a_19896_8041.n1 vdd.n6 0.00768094725895005f
CMODEL11548 a_19896_8041.n1 vdd.t2 0.0100664103034492f
CMODEL11549 a_19896_8041.n1 vdd.n7 0.0102966286763817f
CMODEL11550 a_19896_8041.n1 vdd.t25 0.000802814444820728f
CMODEL11551 a_19896_8041.n1 vdd.n8 0.00463935954340813f
CMODEL11552 a_19896_8041.n1 vdd.t24 0.0100664103034492f
CMODEL11553 a_19896_8041.n1 vdd.n9 0.0102966286763817f
CMODEL11554 a_19896_8041.n1 vdd.t5 0.000802814444820728f
CMODEL11555 a_19896_8041.n1 vdd.n10 0.0137375785624148f
CMODEL11556 a_19896_8041.n1 vdd.t4 0.010071949947474f
CMODEL11557 a_19896_8041.n1 vdd.n11 0.0332151516085743f
CMODEL11558 a_19896_8041.n1 vdd.n12 0.0818962507153154f
CMODEL11559 a_19896_8041.n1 vdd.n13 0.00620763276684205f
CMODEL11560 a_19896_8041.n1 vdd.t42 0.000503982964270429f
CMODEL11561 a_19896_8041.n1 vdd.t41 0.00398372420758752f
CMODEL11562 a_19896_8041.n1 vdd.n14 0.00558114519133217f
CMODEL11563 a_19896_8041.n1 vdd.t9 0.000503982964270429f
CMODEL11564 a_19896_8041.n1 vdd.t8 0.00398372420758752f
CMODEL11565 a_19896_8041.n1 vdd.n15 0.0107150564550584f
CMODEL11566 a_19896_8041.n1 vdd.t15 0.000848756559266784f
CMODEL11567 a_19896_8041.n1 vdd.n16 0.0066761481602434f
CMODEL11568 a_19896_8041.n1 vdd.t14 0.0114491977794512f
CMODEL11569 a_19896_8041.n1 vdd.n17 0.00935184238794423f
CMODEL11570 a_19896_8041.n1 vdd.t32 0.0114491977794512f
CMODEL11571 a_19896_8041.n1 vdd.n18 0.00923153978520466f
CMODEL11572 a_19896_8041.n1 vdd.t34 0.000848756559266784f
CMODEL11573 a_19896_8041.n1 vdd.n19 0.00929626129289495f
CMODEL11574 a_19896_8041.n1 vdd.t33 0.0114491977794512f
CMODEL11575 a_19896_8041.n1 vdd.n20 0.0185520370207083f
CMODEL11576 a_19896_8041.n1 vdd.t48 0.0114710793733493f
CMODEL11577 a_19896_8041.n1 vdd.n21 0.0329318911441038f
CMODEL11578 a_19896_8041.n1 vdd.n22 0.144319729409293f
CMODEL11579 a_19896_8041.n1 vdd.t47 0.000163164213470813f
CMODEL11580 a_19896_8041.n1 vdd.t45 0.000161488932790299f
CMODEL11581 a_19896_8041.n1 vdd.n23 0.00184401823751066f
CMODEL11582 a_19896_8041.n1 vdd.t46 0.00440085016991839f
CMODEL11583 a_19896_8041.n1 vdd.n24 0.00472831699370712f
CMODEL11584 a_19896_8041.n1 vdd.t44 0.00440085016991839f
CMODEL11585 a_19896_8041.n1 vdd.n25 0.00745700714924565f
CMODEL11586 a_19896_8041.n1 vdd.t43 0.00441038297401114f
CMODEL11587 a_19896_8041.n1 vdd.n26 0.0398991937615531f
CMODEL11588 a_19896_8041.n1 vdd.n27 0.0266734321433338f
CMODEL11589 a_19896_8041.n1 vdd.n28 0.00602505533252316f
CMODEL11590 a_19896_8041.n1 vdd.t29 0.000503982964270429f
CMODEL11591 a_19896_8041.n1 vdd.t28 0.00398372420758752f
CMODEL11592 a_19896_8041.n1 vdd.n29 0.000899388905653877f
CMODEL11593 a_19896_8041.n1 vdd.n30 0.000286924938992896f
CMODEL11594 a_19896_8041.n1 vdd.t38 0.000132106660882516f
CMODEL11595 a_19896_8041.n1 vdd.t40 0.000132106660882516f
CMODEL11596 a_19896_8041.n1 vdd.t37 0.00266948059365297f
CMODEL11597 a_19896_8041.n1 vdd.t39 0.00266948059365297f
CMODEL11598 a_19896_8041.n1 vdd.n31 0.000864581475697761f
CMODEL11599 a_19896_8041.n1 vdd.n32 0.0104336887022965f
CMODEL11600 a_19896_8041.n1 vdd.n33 0.00528675927511181f
CMODEL11601 a_19896_8041.n1 vdd.t17 0.000503982964270429f
CMODEL11602 a_19896_8041.n1 vdd.t16 0.00398372420758752f
CMODEL11603 a_19896_8041.n1 vdd.n34 0.000899388905653877f
CMODEL11604 a_19896_8041.n1 vdd.n35 0.000286924938992896f
CMODEL11605 a_19896_8041.n1 vdd.t1 0.000132106660882516f
CMODEL11606 a_19896_8041.n1 vdd.t31 0.000132106660882516f
CMODEL11607 a_19896_8041.n1 vdd.t0 0.00266948059365297f
CMODEL11608 a_19896_8041.n1 vdd.t30 0.00266948059365297f
CMODEL11609 a_19896_8041.n1 vdd.n36 0.000864581475697761f
CMODEL11610 a_19896_8041.n1 vdd.n37 0.0101186214483833f
CMODEL11611 a_19896_8041.n1 vdd.n38 0.00583689209047922f
CMODEL11612 a_19896_8041.n1 vdd.t19 0.000503982964270429f
CMODEL11613 a_19896_8041.n1 vdd.t18 0.00398372420758752f
CMODEL11614 a_19896_8041.n1 vdd.n39 0.00492552832099164f
CMODEL11615 a_19896_8041.n1 vdd.t21 0.00050398758064045f
CMODEL11616 a_19896_8041.n1 vdd.t20 0.00398372420758752f
CMODEL11617 a_19896_8041.n1 vdd.n40 0.00492552832099164f
CMODEL11618 a_19896_8041.n1 vdd.t11 0.000503982964270429f
CMODEL11619 a_19896_8041.n1 vdd.t10 0.00398372420758752f
CMODEL11620 a_19896_8041.n1 vdd.n41 0.0211905233060423f
CMODEL11621 a_19896_8041.n1 vdd.n42 0.0405904028447533f
CMODEL11622 a_19896_8041.n1 vdd.n43 0.00492552832099164f
CMODEL11623 a_19896_8041.n1 vdd.t13 0.000503982964270429f
CMODEL11624 a_19896_8041.n1 vdd.t12 0.00398372420758752f
CMODEL11625 a_19896_8041.n1 vdd.n44 0.00492552832099164f
CMODEL11626 a_19896_8041.n1 vdd.t23 0.000503982964270429f
CMODEL11627 a_19896_8041.n1 vdd.t22 0.00398372420758752f
CMODEL11628 a_19896_8041.n1 vdd.n45 0.00608035944537121f
CMODEL11629 a_19896_8041.n1 vdd.n46 0.10036265407214f
CMODEL11630 a_9600_169.t1 en 6.137707070251e-05f
CMODEL11631 a_9600_169.t1 en.t3 0.000465390234743434f
CMODEL11632 a_9600_169.t1 en.t1 0.000418899818665183f
CMODEL11633 a_9600_169.t1 en.n0 0.0167402592999775f
CMODEL11634 a_9600_169.t1 en.t0 0.000572882932917484f
CMODEL11635 a_9600_169.t1 en.t2 0.000418899818665183f
CMODEL11636 a_9600_169.n0 en 0.00115564740631345f
CMODEL11637 a_9600_169.n0 en.t3 0.00876267002561371f
CMODEL11638 a_9600_169.n0 en.t1 0.0078873182347198f
CMODEL11639 a_9600_169.n0 en.n0 0.315196489822745f
CMODEL11640 a_9600_169.n0 en.t0 0.0107866124591746f
CMODEL11641 a_9600_169.n0 en.t2 0.0078873182347198f
CMODEL11642 a_9600_169.t2 en 8.96044291821023e-05f
CMODEL11643 a_9600_169.t2 en.t3 0.00067942353477949f
CMODEL11644 a_9600_169.t2 en.t1 0.000611552143273675f
CMODEL11645 a_9600_169.t2 en.n0 0.0244391164610193f
CMODEL11646 a_9600_169.t2 en.t0 0.000836352201313846f
CMODEL11647 a_9600_169.t2 en.t2 0.000611552143273675f
CMODEL11648 a_9600_169.t3 en 0.000187034050074478f
CMODEL11649 a_9600_169.t3 en.t3 0.00141818140671899f
CMODEL11650 a_9600_169.t3 en.t1 0.00127651138712961f
CMODEL11651 a_9600_169.t3 en.n0 0.0510125110295249f
CMODEL11652 a_9600_169.t3 en.t0 0.0017457433848781f
CMODEL11653 a_9600_169.t3 en.t2 0.00127651138712961f
CMODEL11654 a_9600_169.t4 en 3.98346267099442e-05f
CMODEL11655 a_9600_169.t4 en.t3 0.00030204514590332f
CMODEL11656 a_9600_169.t4 en.t1 0.000271872178232f
CMODEL11657 a_9600_169.t4 en.n0 0.0108646758897049f
CMODEL11658 a_9600_169.t4 en.t0 0.000371809496935355f
CMODEL11659 a_9600_169.t4 en.t2 0.000271872178232f
CMODEL11660 a_9600_169.t0 en 9.96303873458364e-05f
CMODEL11661 a_9600_169.t0 en.t3 0.000755445133235431f
CMODEL11662 a_9600_169.t0 en.t1 0.000679979521912995f
CMODEL11663 a_9600_169.t0 en.n0 0.0271736415445824f
CMODEL11664 a_9600_169.t0 en.t0 0.000929932755947795f
CMODEL11665 a_9600_169.t0 en.t2 0.000679979521912995f
CMODEL11666 a_9600_169.n1 en 9.00803300066803e-05f
CMODEL11667 a_9600_169.n1 en.t3 0.000683032041896724f
CMODEL11668 a_9600_169.n1 en.t1 0.000614800176567487f
CMODEL11669 a_9600_169.n1 en.n0 0.0245689157999797f
CMODEL11670 a_9600_169.n1 en.t0 0.000840794177071919f
CMODEL11671 a_9600_169.n1 en.t2 0.000614800176567487f
CMODEL11672 a_0_n23917.t1 a_3200_n23917.t1 0.00114460657844701f
CMODEL11673 a_0_n23917.t1 a_3200_n23917.n0 0.00163437216028301f
CMODEL11674 a_0_n23917.t1 a_3200_n23917.t0 0.000259853701221527f
CMODEL11675 a_0_n23917.t1 a_3200_n23917.t3 0.000755962571501322f
CMODEL11676 a_0_n23917.t1 a_3200_n23917.n1 0.0386279094090128f
CMODEL11677 a_0_n23917.t1 a_3200_n23917.t2 0.000968066395961791f
CMODEL11678 a_0_n23917.n0 a_3200_n23917.t1 0.00383132457642132f
CMODEL11679 a_0_n23917.n0 a_3200_n23917.n0 0.00547070962426853f
CMODEL11680 a_0_n23917.n0 a_3200_n23917.t0 0.000869804429321802f
CMODEL11681 a_0_n23917.n0 a_3200_n23917.t3 0.00253042227223384f
CMODEL11682 a_0_n23917.n0 a_3200_n23917.n1 0.129298626655918f
CMODEL11683 a_0_n23917.n0 a_3200_n23917.t2 0.00324039424925229f
CMODEL11684 a_0_n23917.t0 a_3200_n23917.t1 0.000259853591538341f
CMODEL11685 a_0_n23917.t0 a_3200_n23917.n0 0.000371042315986025f
CMODEL11686 a_0_n23917.t0 a_3200_n23917.t0 5.8993123758349e-05f
CMODEL11687 a_0_n23917.t0 a_3200_n23917.t3 0.000171621929291815f
CMODEL11688 a_0_n23917.t0 a_3200_n23917.n1 0.00876947693867755f
CMODEL11689 a_0_n23917.t0 a_3200_n23917.t2 0.000219774667187006f
CMODEL11690 a_0_n23917.t3 a_3200_n23917.t1 0.000751712736588076f
CMODEL11691 a_0_n23917.t3 a_3200_n23917.n0 0.00107336301603004f
CMODEL11692 a_0_n23917.t3 a_3200_n23917.t0 0.000170657185216255f
CMODEL11693 a_0_n23917.t3 a_3200_n23917.t3 0.000496473377037931f
CMODEL11694 a_0_n23917.t3 a_3200_n23917.n1 0.0253686218804741f
CMODEL11695 a_0_n23917.t3 a_3200_n23917.t2 0.000635771149153049f
CMODEL11696 a_0_n23917.n1 a_3200_n23917.t1 0.0315211802336533f
CMODEL11697 a_0_n23917.n1 a_3200_n23917.n0 0.0450087745459618f
CMODEL11698 a_0_n23917.n1 a_3200_n23917.t0 0.00715607921955068f
CMODEL11699 a_0_n23917.n1 a_3200_n23917.t3 0.0208183605746176f
CMODEL11700 a_0_n23917.n1 a_3200_n23917.n1 1.06376926138477f
CMODEL11701 a_0_n23917.n1 a_3200_n23917.t2 0.0266594617922402f
CMODEL11702 a_0_n23917.t2 a_3200_n23917.t1 0.000560751443895564f
CMODEL11703 a_0_n23917.t2 a_3200_n23917.n0 0.00080069131699809f
CMODEL11704 a_0_n23917.t2 a_3200_n23917.t0 0.000127304299053812f
CMODEL11705 a_0_n23917.t2 a_3200_n23917.t3 0.000370351797274766f
CMODEL11706 a_0_n23917.t2 a_3200_n23917.n1 0.0189241057876497f
CMODEL11707 a_0_n23917.t2 a_3200_n23917.t2 0.000474263069550828f
CMODEL11708 a_0_83.t1 vdd 4.70061204442299e-06f
CMODEL11709 a_0_83.t1 vdd.n0 0.00157743793089183f
CMODEL11710 a_0_83.t1 vdd.n1 0.000146182368604616f
CMODEL11711 a_0_83.t1 vdd.t7 1.20507484748301e-05f
CMODEL11712 a_0_83.t1 vdd.t6 9.52549229282465e-05f
CMODEL11713 a_0_83.t1 vdd.n2 0.00013108761208118f
CMODEL11714 a_0_83.t1 vdd.t27 1.20507484748301e-05f
CMODEL11715 a_0_83.t1 vdd.t26 9.52549229282465e-05f
CMODEL11716 a_0_83.t1 vdd.n3 0.000245871783295732f
CMODEL11717 a_0_83.t1 vdd.n4 0.00013108761208118f
CMODEL11718 a_0_83.t1 vdd.t36 1.20507484748301e-05f
CMODEL11719 a_0_83.t1 vdd.t35 9.52549229282465e-05f
CMODEL11720 a_0_83.t1 vdd.n5 0.000187041418511123f
CMODEL11721 a_0_83.t1 vdd.t3 1.91961150125379e-05f
CMODEL11722 a_0_83.t1 vdd.n6 0.000183659309992819f
CMODEL11723 a_0_83.t1 vdd.t2 0.00024069817277834f
CMODEL11724 a_0_83.t1 vdd.n7 0.000246202929691128f
CMODEL11725 a_0_83.t1 vdd.t25 1.91961150125379e-05f
CMODEL11726 a_0_83.t1 vdd.n8 0.000110931834814787f
CMODEL11727 a_0_83.t1 vdd.t24 0.00024069817277834f
CMODEL11728 a_0_83.t1 vdd.n9 0.000246202929691128f
CMODEL11729 a_0_83.t1 vdd.t5 1.91961150125379e-05f
CMODEL11730 a_0_83.t1 vdd.n10 0.000328479563091042f
CMODEL11731 a_0_83.t1 vdd.t4 0.000240830631336498f
CMODEL11732 a_0_83.t1 vdd.n11 0.000794208268860252f
CMODEL11733 a_0_83.t1 vdd.n12 0.00195822317095688f
CMODEL11734 a_0_83.t1 vdd.n13 0.00014843085262935f
CMODEL11735 a_0_83.t1 vdd.t42 1.20507484748301e-05f
CMODEL11736 a_0_83.t1 vdd.t41 9.52549229282465e-05f
CMODEL11737 a_0_83.t1 vdd.n14 0.000133450893522985f
CMODEL11738 a_0_83.t1 vdd.t9 1.20507484748301e-05f
CMODEL11739 a_0_83.t1 vdd.t8 9.52549229282465e-05f
CMODEL11740 a_0_83.t1 vdd.n15 0.000256207966117337f
CMODEL11741 a_0_83.t1 vdd.t15 2.02946379881959e-05f
CMODEL11742 a_0_83.t1 vdd.n16 0.000159633535185572f
CMODEL11743 a_0_83.t1 vdd.t14 0.000273762036537242f
CMODEL11744 a_0_83.t1 vdd.n17 0.000223612122597261f
CMODEL11745 a_0_83.t1 vdd.t32 0.000273762036537242f
CMODEL11746 a_0_83.t1 vdd.n18 0.000220735564242594f
CMODEL11747 a_0_83.t1 vdd.t34 2.02946379881959e-05f
CMODEL11748 a_0_83.t1 vdd.n19 0.000222283121730408f
CMODEL11749 a_0_83.t1 vdd.t33 0.000273762036537242f
CMODEL11750 a_0_83.t1 vdd.n20 0.000443598192164943f
CMODEL11751 a_0_83.t1 vdd.t48 0.000274285247841966f
CMODEL11752 a_0_83.t1 vdd.n21 0.0007874352212531f
CMODEL11753 a_0_83.t1 vdd.n22 0.00345083243356162f
CMODEL11754 a_0_83.t1 vdd.t47 3.90142333377599e-06f
CMODEL11755 a_0_83.t1 vdd.t45 3.86136565814634e-06f
CMODEL11756 a_0_83.t1 vdd.n23 4.40923633111467e-05f
CMODEL11757 a_0_83.t1 vdd.t46 0.000105228831593289f
CMODEL11758 a_0_83.t1 vdd.n24 0.000113058898494543f
CMODEL11759 a_0_83.t1 vdd.t44 0.000105228831593289f
CMODEL11760 a_0_83.t1 vdd.n25 0.000178304672779277f
CMODEL11761 a_0_83.t1 vdd.t43 0.000105456770695453f
CMODEL11762 a_0_83.t1 vdd.n26 0.0009540305574912f
CMODEL11763 a_0_83.t1 vdd.n27 0.00063778906135265f
CMODEL11764 a_0_83.t1 vdd.n28 0.000144065239316722f
CMODEL11765 a_0_83.t1 vdd.t29 1.20507484748301e-05f
CMODEL11766 a_0_83.t1 vdd.t28 9.52549229282465e-05f
CMODEL11767 a_0_83.t1 vdd.n29 2.1505309209761e-05f
CMODEL11768 a_0_83.t1 vdd.n30 6.8606689433733e-06f
CMODEL11769 a_0_83.t1 vdd.t38 3.15880546567569e-06f
CMODEL11770 a_0_83.t1 vdd.t40 3.15880546567569e-06f
CMODEL11771 a_0_83.t1 vdd.t37 6.38300130622877e-05f
CMODEL11772 a_0_83.t1 vdd.t39 6.38300130622877e-05f
CMODEL11773 a_0_83.t1 vdd.n31 2.06730279360009e-05f
CMODEL11774 a_0_83.t1 vdd.n32 0.000249480175184223f
CMODEL11775 a_0_83.t1 vdd.n33 0.000126411824978199f
CMODEL11776 a_0_83.t1 vdd.t17 1.20507484748301e-05f
CMODEL11777 a_0_83.t1 vdd.t16 9.52549229282465e-05f
CMODEL11778 a_0_83.t1 vdd.n34 2.1505309209761e-05f
CMODEL11779 a_0_83.t1 vdd.n35 6.8606689433733e-06f
CMODEL11780 a_0_83.t1 vdd.t1 3.15880546567569e-06f
CMODEL11781 a_0_83.t1 vdd.t31 3.15880546567569e-06f
CMODEL11782 a_0_83.t1 vdd.t0 6.38300130622877e-05f
CMODEL11783 a_0_83.t1 vdd.t30 6.38300130622877e-05f
CMODEL11784 a_0_83.t1 vdd.n36 2.06730279360009e-05f
CMODEL11785 a_0_83.t1 vdd.n37 0.00024194659468898f
CMODEL11786 a_0_83.t1 vdd.n38 0.000139566063624618f
CMODEL11787 a_0_83.t1 vdd.t19 1.20507484748301e-05f
CMODEL11788 a_0_83.t1 vdd.t18 9.52549229282465e-05f
CMODEL11789 a_0_83.t1 vdd.n39 0.000117774423164972f
CMODEL11790 a_0_83.t1 vdd.t21 1.20508588569619e-05f
CMODEL11791 a_0_83.t1 vdd.t20 9.52549229282465e-05f
CMODEL11792 a_0_83.t1 vdd.n40 0.000117774423164972f
CMODEL11793 a_0_83.t1 vdd.t11 1.20507484748301e-05f
CMODEL11794 a_0_83.t1 vdd.t10 9.52549229282465e-05f
CMODEL11795 a_0_83.t1 vdd.n41 0.000506687099594336f
CMODEL11796 a_0_83.t1 vdd.n42 0.000970558074085379f
CMODEL11797 a_0_83.t1 vdd.n43 0.000117774423164972f
CMODEL11798 a_0_83.t1 vdd.t13 1.20507484748301e-05f
CMODEL11799 a_0_83.t1 vdd.t12 9.52549229282465e-05f
CMODEL11800 a_0_83.t1 vdd.n44 0.000117774423164972f
CMODEL11801 a_0_83.t1 vdd.t23 1.20507484748301e-05f
CMODEL11802 a_0_83.t1 vdd.t22 9.52549229282465e-05f
CMODEL11803 a_0_83.t1 vdd.n45 0.000145387617255667f
CMODEL11804 a_0_83.t1 vdd.n46 0.00239977377457696f
CMODEL11805 a_0_83.n0 vdd 4.64391952017344e-05f
CMODEL11806 a_0_83.n0 vdd.n0 0.0155841297471504f
CMODEL11807 a_0_83.n0 vdd.n1 0.00144419311496594f
CMODEL11808 a_0_83.n0 vdd.t7 0.000119054083906712f
CMODEL11809 a_0_83.n0 vdd.t6 0.000941060848669549f
CMODEL11810 a_0_83.n0 vdd.n2 0.00129506607829714f
CMODEL11811 a_0_83.n0 vdd.t27 0.000119054083906712f
CMODEL11812 a_0_83.n0 vdd.t26 0.000941060848669549f
CMODEL11813 a_0_83.n0 vdd.n3 0.00242906405190702f
CMODEL11814 a_0_83.n0 vdd.n4 0.00129506607829714f
CMODEL11815 a_0_83.n0 vdd.t36 0.000119054083906712f
CMODEL11816 a_0_83.n0 vdd.t35 0.000941060848669549f
CMODEL11817 a_0_83.n0 vdd.n5 0.00184785573941437f
CMODEL11818 a_0_83.n0 vdd.t3 0.00018964597030292f
CMODEL11819 a_0_83.n0 vdd.n6 0.0018144425591326f
CMODEL11820 a_0_83.n0 vdd.t2 0.00237795191875406f
CMODEL11821 a_0_83.n0 vdd.n7 0.00243233557739153f
CMODEL11822 a_0_83.n0 vdd.t25 0.00018964597030292f
CMODEL11823 a_0_83.n0 vdd.n8 0.00109593922714011f
CMODEL11824 a_0_83.n0 vdd.t24 0.00237795191875406f
CMODEL11825 a_0_83.n0 vdd.n9 0.00243233557739153f
CMODEL11826 a_0_83.n0 vdd.t5 0.00018964597030292f
CMODEL11827 a_0_83.n0 vdd.n10 0.00324517879927226f
CMODEL11828 a_0_83.n0 vdd.t4 0.00237926052894787f
CMODEL11829 a_0_83.n0 vdd.n11 0.00784629586102339f
CMODEL11830 a_0_83.n0 vdd.n12 0.0193460569017856f
CMODEL11831 a_0_83.n0 vdd.n13 0.00146640677300574f
CMODEL11832 a_0_83.n0 vdd.t42 0.000119054083906712f
CMODEL11833 a_0_83.n0 vdd.t41 0.000941060848669549f
CMODEL11834 a_0_83.n0 vdd.n14 0.00131841386517157f
CMODEL11835 a_0_83.n0 vdd.t9 0.000119054083906712f
CMODEL11836 a_0_83.n0 vdd.t8 0.000941060848669549f
CMODEL11837 a_0_83.n0 vdd.n15 0.00253117926736345f
CMODEL11838 a_0_83.n0 vdd.t15 0.000200498710843526f
CMODEL11839 a_0_83.n0 vdd.n16 0.00157708248014663f
CMODEL11840 a_0_83.n0 vdd.t14 0.00270460283329719f
CMODEL11841 a_0_83.n0 vdd.n17 0.00220915210883843f
CMODEL11842 a_0_83.n0 vdd.t32 0.00270460283329719f
CMODEL11843 a_0_83.n0 vdd.n18 0.002180733457463f
CMODEL11844 a_0_83.n0 vdd.t34 0.000200498710843526f
CMODEL11845 a_0_83.n0 vdd.n19 0.0021960223865606f
CMODEL11846 a_0_83.n0 vdd.t33 0.00270460283329719f
CMODEL11847 a_0_83.n0 vdd.n20 0.00438248101362149f
CMODEL11848 a_0_83.n0 vdd.t48 0.00270977184356271f
CMODEL11849 a_0_83.n0 vdd.n21 0.00777938225978026f
CMODEL11850 a_0_83.n0 vdd.n22 0.0340921308706546f
CMODEL11851 a_0_83.n0 vdd.t47 3.8543695597424e-05f
CMODEL11852 a_0_83.n0 vdd.t45 3.81479500646481e-05f
CMODEL11853 a_0_83.n0 vdd.n23 0.000435605799279162f
CMODEL11854 a_0_83.n0 vdd.t46 0.00103959701524592f
CMODEL11855 a_0_83.n0 vdd.n24 0.0011169533258356f
CMODEL11856 a_0_83.n0 vdd.t44 0.00103959701524592f
CMODEL11857 a_0_83.n0 vdd.n25 0.00176154199204811f
CMODEL11858 a_0_83.n0 vdd.t43 0.00104184891528776f
CMODEL11859 a_0_83.n0 vdd.n26 0.00942524311069619f
CMODEL11860 a_0_83.n0 vdd.n27 0.00630096898824638f
CMODEL11861 a_0_83.n0 vdd.n28 0.00142327716203498f
CMODEL11862 a_0_83.n0 vdd.t29 0.000119054083906712f
CMODEL11863 a_0_83.n0 vdd.t28 0.000941060848669549f
CMODEL11864 a_0_83.n0 vdd.n29 0.000212459408014886f
CMODEL11865 a_0_83.n0 vdd.n30 6.77792468863272e-05f
CMODEL11866 a_0_83.n0 vdd.t38 3.1207081596717e-05f
CMODEL11867 a_0_83.n0 vdd.t40 3.1207081596717e-05f
CMODEL11868 a_0_83.n0 vdd.t37 0.000630601804257747f
CMODEL11869 a_0_83.n0 vdd.t39 0.000630601804257747f
CMODEL11870 a_0_83.n0 vdd.n31 0.000204236973963823f
CMODEL11871 a_0_83.n0 vdd.n32 0.0024647127746032f
CMODEL11872 a_0_83.n0 vdd.n33 0.00124887213845589f
CMODEL11873 a_0_83.n0 vdd.t17 0.000119054083906712f
CMODEL11874 a_0_83.n0 vdd.t16 0.000941060848669549f
CMODEL11875 a_0_83.n0 vdd.n34 0.000212459408014886f
CMODEL11876 a_0_83.n0 vdd.n35 6.77792468863272e-05f
CMODEL11877 a_0_83.n0 vdd.t1 3.1207081596717e-05f
CMODEL11878 a_0_83.n0 vdd.t31 3.1207081596717e-05f
CMODEL11879 a_0_83.n0 vdd.t0 0.000630601804257747f
CMODEL11880 a_0_83.n0 vdd.t30 0.000630601804257747f
CMODEL11881 a_0_83.n0 vdd.n36 0.000204236973963823f
CMODEL11882 a_0_83.n0 vdd.n37 0.00239028556983066f
CMODEL11883 a_0_83.n0 vdd.n38 0.00137882803578548f
CMODEL11884 a_0_83.n0 vdd.t19 0.000119054083906712f
CMODEL11885 a_0_83.n0 vdd.t18 0.000941060848669549f
CMODEL11886 a_0_83.n0 vdd.n39 0.00116353984873499f
CMODEL11887 a_0_83.n0 vdd.t21 0.000119055174415207f
CMODEL11888 a_0_83.n0 vdd.t20 0.000941060848669549f
CMODEL11889 a_0_83.n0 vdd.n40 0.00116353984873499f
CMODEL11890 a_0_83.n0 vdd.t11 0.000119054083906712f
CMODEL11891 a_0_83.n0 vdd.t10 0.000941060848669549f
CMODEL11892 a_0_83.n0 vdd.n41 0.00500576114384491f
CMODEL11893 a_0_83.n0 vdd.n42 0.00958852494762795f
CMODEL11894 a_0_83.n0 vdd.n43 0.00116353984873499f
CMODEL11895 a_0_83.n0 vdd.t13 0.000119054083906712f
CMODEL11896 a_0_83.n0 vdd.t12 0.000941060848669549f
CMODEL11897 a_0_83.n0 vdd.n44 0.00116353984873499f
CMODEL11898 a_0_83.n0 vdd.t23 0.000119054083906712f
CMODEL11899 a_0_83.n0 vdd.t22 0.000941060848669549f
CMODEL11900 a_0_83.n0 vdd.n45 0.00143634145380312f
CMODEL11901 a_0_83.n0 vdd.n46 0.0237083089828279f
CMODEL11902 a_0_83.t0 vdd 1.06715481672558e-06f
CMODEL11903 a_0_83.t0 vdd.n0 0.000358117298370554f
CMODEL11904 a_0_83.t0 vdd.n1 3.3187001459066e-05f
CMODEL11905 a_0_83.t0 vdd.t7 2.73581698692215e-06f
CMODEL11906 a_0_83.t0 vdd.t6 2.16252157929744e-05f
CMODEL11907 a_0_83.t0 vdd.n2 2.9760119602182e-05f
CMODEL11908 a_0_83.t0 vdd.t27 2.73581698692215e-06f
CMODEL11909 a_0_83.t0 vdd.t26 2.16252157929744e-05f
CMODEL11910 a_0_83.t0 vdd.n3 5.58189562042778e-05f
CMODEL11911 a_0_83.t0 vdd.n4 2.9760119602182e-05f
CMODEL11912 a_0_83.t0 vdd.t36 2.73581698692215e-06f
CMODEL11913 a_0_83.t0 vdd.t35 2.16252157929744e-05f
CMODEL11914 a_0_83.t0 vdd.n5 4.2463013072552e-05f
CMODEL11915 a_0_83.t0 vdd.t3 4.35799134335123e-06f
CMODEL11916 a_0_83.t0 vdd.n6 4.16951910608889e-05f
CMODEL11917 a_0_83.t0 vdd.t2 5.46444190735125e-05f
CMODEL11918 a_0_83.t0 vdd.n7 5.58941345996757e-05f
CMODEL11919 a_0_83.t0 vdd.t25 4.35799134335123e-06f
CMODEL11920 a_0_83.t0 vdd.n8 2.51842612689679e-05f
CMODEL11921 a_0_83.t0 vdd.t24 5.46444190735125e-05f
CMODEL11922 a_0_83.t0 vdd.n9 5.58941345996757e-05f
CMODEL11923 a_0_83.t0 vdd.t5 4.35799134335123e-06f
CMODEL11924 a_0_83.t0 vdd.n10 7.45729587202186e-05f
CMODEL11925 a_0_83.t0 vdd.t4 5.46744904316717e-05f
CMODEL11926 a_0_83.t0 vdd.n11 0.000180304856386321f
CMODEL11927 a_0_83.t0 vdd.n12 0.00044456493523851f
CMODEL11928 a_0_83.t0 vdd.n13 3.36974627638173e-05f
CMODEL11929 a_0_83.t0 vdd.t42 2.73581698692215e-06f
CMODEL11930 a_0_83.t0 vdd.t41 2.16252157929744e-05f
CMODEL11931 a_0_83.t0 vdd.n14 3.02966427506711e-05f
CMODEL11932 a_0_83.t0 vdd.t9 2.73581698692215e-06f
CMODEL11933 a_0_83.t0 vdd.t8 2.16252157929744e-05f
CMODEL11934 a_0_83.t0 vdd.n15 5.81655245192952e-05f
CMODEL11935 a_0_83.t0 vdd.t15 4.60738314035094e-06f
CMODEL11936 a_0_83.t0 vdd.n16 3.62407478801256e-05f
CMODEL11937 a_0_83.t0 vdd.t14 6.21507312593338e-05f
CMODEL11938 a_0_83.t0 vdd.n17 5.07654644656362e-05f
CMODEL11939 a_0_83.t0 vdd.t32 6.21507312593338e-05f
CMODEL11940 a_0_83.t0 vdd.n18 5.01124148042805e-05f
CMODEL11941 a_0_83.t0 vdd.t34 4.60738314035094e-06f
CMODEL11942 a_0_83.t0 vdd.n19 5.04637485054396e-05f
CMODEL11943 a_0_83.t0 vdd.t33 6.21507312593338e-05f
CMODEL11944 a_0_83.t0 vdd.n20 0.000100707725501666f
CMODEL11945 a_0_83.t0 vdd.t48 6.22695131240623e-05f
CMODEL11946 a_0_83.t0 vdd.n21 0.000178767207605785f
CMODEL11947 a_0_83.t0 vdd.n22 0.000783424034654654f
CMODEL11948 a_0_83.t0 vdd.t47 8.85719277272471e-07f
CMODEL11949 a_0_83.t0 vdd.t45 8.76625197375848e-07f
CMODEL11950 a_0_83.t0 vdd.n23 1.00100534661503e-05f
CMODEL11951 a_0_83.t0 vdd.t46 2.38895389434266e-05f
CMODEL11952 a_0_83.t0 vdd.n24 2.56671571620732e-05f
CMODEL11953 a_0_83.t0 vdd.t44 2.38895389434266e-05f
CMODEL11954 a_0_83.t0 vdd.n25 4.04795564073061e-05f
CMODEL11955 a_0_83.t0 vdd.t43 2.39412867389254e-05f
CMODEL11956 a_0_83.t0 vdd.n26 0.000216588455951824f
CMODEL11957 a_0_83.t0 vdd.n27 0.000144793840130857f
CMODEL11958 a_0_83.t0 vdd.n28 3.27063609178226e-05f
CMODEL11959 a_0_83.t0 vdd.t29 2.73581698692215e-06f
CMODEL11960 a_0_83.t0 vdd.t28 2.16252157929744e-05f
CMODEL11961 a_0_83.t0 vdd.n29 4.88223535392538e-06f
CMODEL11962 a_0_83.t0 vdd.n30 1.55754098395906e-06f
CMODEL11963 a_0_83.t0 vdd.t38 7.17126713699828e-07f
CMODEL11964 a_0_83.t0 vdd.t40 7.17126713699828e-07f
CMODEL11965 a_0_83.t0 vdd.t37 1.44909865454421e-05f
CMODEL11966 a_0_83.t0 vdd.t39 1.44909865454421e-05f
CMODEL11967 a_0_83.t0 vdd.n31 4.69328698682552e-06f
CMODEL11968 a_0_83.t0 vdd.n32 5.66381501194628e-05f
CMODEL11969 a_0_83.t0 vdd.n33 2.86986006591647e-05f
CMODEL11970 a_0_83.t0 vdd.t17 2.73581698692215e-06f
CMODEL11971 a_0_83.t0 vdd.t16 2.16252157929744e-05f
CMODEL11972 a_0_83.t0 vdd.n34 4.88223535392538e-06f
CMODEL11973 a_0_83.t0 vdd.n35 1.55754098395906e-06f
CMODEL11974 a_0_83.t0 vdd.t1 7.17126713699828e-07f
CMODEL11975 a_0_83.t0 vdd.t31 7.17126713699828e-07f
CMODEL11976 a_0_83.t0 vdd.t0 1.44909865454421e-05f
CMODEL11977 a_0_83.t0 vdd.t30 1.44909865454421e-05f
CMODEL11978 a_0_83.t0 vdd.n36 4.69328698682552e-06f
CMODEL11979 a_0_83.t0 vdd.n37 5.49278416241623e-05f
CMODEL11980 a_0_83.t0 vdd.n38 3.16849371190176e-05f
CMODEL11981 a_0_83.t0 vdd.t19 2.73581698692215e-06f
CMODEL11982 a_0_83.t0 vdd.t18 2.16252157929744e-05f
CMODEL11983 a_0_83.t0 vdd.n39 2.67376975125382e-05f
CMODEL11984 a_0_83.t0 vdd.t21 2.73584204638729e-06f
CMODEL11985 a_0_83.t0 vdd.t20 2.16252157929744e-05f
CMODEL11986 a_0_83.t0 vdd.n40 2.67376975125382e-05f
CMODEL11987 a_0_83.t0 vdd.t11 2.73581698692215e-06f
CMODEL11988 a_0_83.t0 vdd.t10 2.16252157929744e-05f
CMODEL11989 a_0_83.t0 vdd.n41 0.000115030462798208f
CMODEL11990 a_0_83.t0 vdd.n42 0.000220340609666129f
CMODEL11991 a_0_83.t0 vdd.n43 2.67376975125382e-05f
CMODEL11992 a_0_83.t0 vdd.t13 2.73581698692215e-06f
CMODEL11993 a_0_83.t0 vdd.t12 2.16252157929744e-05f
CMODEL11994 a_0_83.t0 vdd.n44 2.67376975125382e-05f
CMODEL11995 a_0_83.t0 vdd.t23 2.73581698692215e-06f
CMODEL11996 a_0_83.t0 vdd.t22 2.16252157929744e-05f
CMODEL11997 a_0_83.t0 vdd.n45 3.30065733101113e-05f
CMODEL11998 a_0_83.t0 vdd.n46 0.000544807807661966f
CMODEL11999 a_0_83.t2 vdd 4.89321052730532e-06f
CMODEL12000 a_0_83.t2 vdd.n0 0.0016420703977833f
CMODEL12001 a_0_83.t2 vdd.n1 0.00015217190829675f
CMODEL12002 a_0_83.t2 vdd.t7 1.25445045755069e-05f
CMODEL12003 a_0_83.t2 vdd.t6 9.91578090778959e-05f
CMODEL12004 a_0_83.t2 vdd.n2 0.000136458673332971f
CMODEL12005 a_0_83.t2 vdd.t27 1.25445045755069e-05f
CMODEL12006 a_0_83.t2 vdd.t26 9.91578090778959e-05f
CMODEL12007 a_0_83.t2 vdd.n3 0.000255945903856801f
CMODEL12008 a_0_83.t2 vdd.n4 0.000136458673332971f
CMODEL12009 a_0_83.t2 vdd.t36 1.25445045755069e-05f
CMODEL12010 a_0_83.t2 vdd.t35 9.91578090778959e-05f
CMODEL12011 a_0_83.t2 vdd.n5 0.000194705078711318f
CMODEL12012 a_0_83.t2 vdd.t3 1.99826386808836e-05f
CMODEL12013 a_0_83.t2 vdd.n6 0.000191184394840823f
CMODEL12014 a_0_83.t2 vdd.t2 0.000250560314659344f
CMODEL12015 a_0_83.t2 vdd.n7 0.000256290618334983f
CMODEL12016 a_0_83.t2 vdd.t25 1.99826386808836e-05f
CMODEL12017 a_0_83.t2 vdd.n8 0.000115477052094317f
CMODEL12018 a_0_83.t2 vdd.t24 0.000250560314659344f
CMODEL12019 a_0_83.t2 vdd.n9 0.000256290618334983f
CMODEL12020 a_0_83.t2 vdd.t5 1.99826386808836e-05f
CMODEL12021 a_0_83.t2 vdd.n10 0.000341938377583985f
CMODEL12022 a_0_83.t2 vdd.t4 0.000250698200450617f
CMODEL12023 a_0_83.t2 vdd.n11 0.000826749415891641f
CMODEL12024 a_0_83.t2 vdd.n12 0.00203845757624433f
CMODEL12025 a_0_83.t2 vdd.n13 0.000154512519603603f
CMODEL12026 a_0_83.t2 vdd.t42 1.25445045755069e-05f
CMODEL12027 a_0_83.t2 vdd.t41 9.91578090778959e-05f
CMODEL12028 a_0_83.t2 vdd.n14 0.000138918785658927f
CMODEL12029 a_0_83.t2 vdd.t9 1.25445045755069e-05f
CMODEL12030 a_0_83.t2 vdd.t8 9.91578090778959e-05f
CMODEL12031 a_0_83.t2 vdd.n15 0.00026670559176911f
CMODEL12032 a_0_83.t2 vdd.t15 2.1126171509838e-05f
CMODEL12033 a_0_83.t2 vdd.n16 0.000166174210400487f
CMODEL12034 a_0_83.t2 vdd.t14 0.000284978906257517f
CMODEL12035 a_0_83.t2 vdd.n17 0.000232774196633434f
CMODEL12036 a_0_83.t2 vdd.t32 0.000284978906257517f
CMODEL12037 a_0_83.t2 vdd.n18 0.000229779776866296f
CMODEL12038 a_0_83.t2 vdd.t34 2.1126171509838e-05f
CMODEL12039 a_0_83.t2 vdd.n19 0.000231390742527665f
CMODEL12040 a_0_83.t2 vdd.t33 0.000284978906257517f
CMODEL12041 a_0_83.t2 vdd.n20 0.000461773769730779f
CMODEL12042 a_0_83.t2 vdd.t48 0.000285523555133044f
CMODEL12043 a_0_83.t2 vdd.n21 0.000819698855764567f
CMODEL12044 a_0_83.t2 vdd.n22 0.00359222361520011f
CMODEL12045 a_0_83.t2 vdd.t47 4.06127660566183e-06f
CMODEL12046 a_0_83.t2 vdd.t45 4.01957764428446e-06f
CMODEL12047 a_0_83.t2 vdd.n23 4.58989625795332e-05f
CMODEL12048 a_0_83.t2 vdd.t46 0.000109540379351074f
CMODEL12049 a_0_83.t2 vdd.n24 0.000117691268092504f
CMODEL12050 a_0_83.t2 vdd.t44 0.000109540379351074f
CMODEL12051 a_0_83.t2 vdd.n25 0.000185610361728626f
CMODEL12052 a_0_83.t2 vdd.t43 0.000109777657816889f
CMODEL12053 a_0_83.t2 vdd.n26 0.000993120113544691f
CMODEL12054 a_0_83.t2 vdd.n27 0.000663921234026037f
CMODEL12055 a_0_83.t2 vdd.n28 0.000149968033732909f
CMODEL12056 a_0_83.t2 vdd.t29 1.25445045755069e-05f
CMODEL12057 a_0_83.t2 vdd.t28 9.91578090778959e-05f
CMODEL12058 a_0_83.t2 vdd.n29 2.238644764207e-05f
CMODEL12059 a_0_83.t2 vdd.n30 7.14177157800134e-06f
CMODEL12060 a_0_83.t2 vdd.t38 3.28823140737436e-06f
CMODEL12061 a_0_83.t2 vdd.t40 3.28823140737436e-06f
CMODEL12062 a_0_83.t2 vdd.t37 6.64453243370698e-05f
CMODEL12063 a_0_83.t2 vdd.t39 6.64453243370698e-05f
CMODEL12064 a_0_83.t2 vdd.n31 2.15200652535735e-05f
CMODEL12065 a_0_83.t2 vdd.n32 0.00025970214262072f
CMODEL12066 a_0_83.t2 vdd.n33 0.000131591304901047f
CMODEL12067 a_0_83.t2 vdd.t17 1.25445045755069e-05f
CMODEL12068 a_0_83.t2 vdd.t16 9.91578090778959e-05f
CMODEL12069 a_0_83.t2 vdd.n34 2.238644764207e-05f
CMODEL12070 a_0_83.t2 vdd.n35 7.14177157800134e-06f
CMODEL12071 a_0_83.t2 vdd.t1 3.28823140737436e-06f
CMODEL12072 a_0_83.t2 vdd.t31 3.28823140737436e-06f
CMODEL12073 a_0_83.t2 vdd.t0 6.64453243370698e-05f
CMODEL12074 a_0_83.t2 vdd.t30 6.64453243370698e-05f
CMODEL12075 a_0_83.t2 vdd.n36 2.15200652535735e-05f
CMODEL12076 a_0_83.t2 vdd.n37 0.000251859888242089f
CMODEL12077 a_0_83.t2 vdd.n38 0.000145284513022681f
CMODEL12078 a_0_83.t2 vdd.t19 1.25445045755069e-05f
CMODEL12079 a_0_83.t2 vdd.t18 9.91578090778959e-05f
CMODEL12080 a_0_83.t2 vdd.n39 0.00012260000226181f
CMODEL12081 a_0_83.t2 vdd.t21 1.2544619480333e-05f
CMODEL12082 a_0_83.t2 vdd.t20 9.91578090778959e-05f
CMODEL12083 a_0_83.t2 vdd.n40 0.00012260000226181f
CMODEL12084 a_0_83.t2 vdd.t11 1.25445045755069e-05f
CMODEL12085 a_0_83.t2 vdd.t10 9.91578090778959e-05f
CMODEL12086 a_0_83.t2 vdd.n41 0.000527447623065678f
CMODEL12087 a_0_83.t2 vdd.n42 0.00101032481315074f
CMODEL12088 a_0_83.t2 vdd.n43 0.00012260000226181f
CMODEL12089 a_0_83.t2 vdd.t13 1.25445045755069e-05f
CMODEL12090 a_0_83.t2 vdd.t12 9.91578090778959e-05f
CMODEL12091 a_0_83.t2 vdd.n44 0.00012260000226181f
CMODEL12092 a_0_83.t2 vdd.t23 1.25445045755069e-05f
CMODEL12093 a_0_83.t2 vdd.t22 9.91578090778959e-05f
CMODEL12094 a_0_83.t2 vdd.n45 0.000151344593549114f
CMODEL12095 a_0_83.t2 vdd.n46 0.00249809986145169f
CMODEL12096 a_0_83.t3 vdd 2.1026753468286e-06f
CMODEL12097 a_0_83.t3 vdd.n0 0.000705618718816375f
CMODEL12098 a_0_83.t3 vdd.n1 6.5390221465015e-05f
CMODEL12099 a_0_83.t3 vdd.t7 5.39053457068864e-06f
CMODEL12100 a_0_83.t3 vdd.t6 4.26093828234379e-05f
CMODEL12101 a_0_83.t3 vdd.n2 5.8638042789503e-05f
CMODEL12102 a_0_83.t3 vdd.t27 5.39053457068864e-06f
CMODEL12103 a_0_83.t3 vdd.t26 4.26093828234379e-05f
CMODEL12104 a_0_83.t3 vdd.n3 0.000109983238848672f
CMODEL12105 a_0_83.t3 vdd.n4 5.8638042789503e-05f
CMODEL12106 a_0_83.t3 vdd.t36 5.39053457068864e-06f
CMODEL12107 a_0_83.t3 vdd.t35 4.26093828234379e-05f
CMODEL12108 a_0_83.t3 vdd.n5 8.3667270521889e-05f
CMODEL12109 a_0_83.t3 vdd.t3 8.58679623212862e-06f
CMODEL12110 a_0_83.t3 vdd.n6 8.21543874899498e-05f
CMODEL12111 a_0_83.t3 vdd.t2 0.000107668982069724f
CMODEL12112 a_0_83.t3 vdd.n7 0.00011013136708287f
CMODEL12113 a_0_83.t3 vdd.t25 8.58679623212862e-06f
CMODEL12114 a_0_83.t3 vdd.n8 4.96219709346694e-05f
CMODEL12115 a_0_83.t3 vdd.t24 0.000107668982069724f
CMODEL12116 a_0_83.t3 vdd.n9 0.00011013136708287f
CMODEL12117 a_0_83.t3 vdd.t5 8.58679623212862e-06f
CMODEL12118 a_0_83.t3 vdd.n10 0.000146935308151632f
CMODEL12119 a_0_83.t3 vdd.t4 0.000107728233363403f
CMODEL12120 a_0_83.t3 vdd.n11 0.000355264831770405f
CMODEL12121 a_0_83.t3 vdd.n12 0.000875951375320315f
CMODEL12122 a_0_83.t3 vdd.n13 6.63960121752174e-05f
CMODEL12123 a_0_83.t3 vdd.t42 5.39053457068864e-06f
CMODEL12124 a_0_83.t3 vdd.t41 4.26093828234379e-05f
CMODEL12125 a_0_83.t3 vdd.n14 5.96951846208939e-05f
CMODEL12126 a_0_83.t3 vdd.t9 5.39053457068864e-06f
CMODEL12127 a_0_83.t3 vdd.t8 4.26093828234379e-05f
CMODEL12128 a_0_83.t3 vdd.n15 0.000114606814798763f
CMODEL12129 a_0_83.t3 vdd.t15 9.07818696104047e-06f
CMODEL12130 a_0_83.t3 vdd.n16 7.14071903381257e-05f
CMODEL12131 a_0_83.t3 vdd.t14 0.000122459092493584f
CMODEL12132 a_0_83.t3 vdd.n17 0.000100026058945903f
CMODEL12133 a_0_83.t3 vdd.t32 0.000122459092493584f
CMODEL12134 a_0_83.t3 vdd.n18 9.87393183515054e-05f
CMODEL12135 a_0_83.t3 vdd.t34 9.07818696104047e-06f
CMODEL12136 a_0_83.t3 vdd.n19 9.94315709659893e-05f
CMODEL12137 a_0_83.t3 vdd.t33 0.000122459092493584f
CMODEL12138 a_0_83.t3 vdd.n20 0.000198430113727341f
CMODEL12139 a_0_83.t3 vdd.t48 0.000122693135103616f
CMODEL12140 a_0_83.t3 vdd.n21 0.000352235115620281f
CMODEL12141 a_0_83.t3 vdd.n22 0.00154362457814304f
CMODEL12142 a_0_83.t3 vdd.t47 1.74518266641586e-06f
CMODEL12143 a_0_83.t3 vdd.t45 1.72726408768574e-06f
CMODEL12144 a_0_83.t3 vdd.n23 1.97233731355804e-05f
CMODEL12145 a_0_83.t3 vdd.t46 4.70709064853166e-05f
CMODEL12146 a_0_83.t3 vdd.n24 5.05734479589994e-05f
CMODEL12147 a_0_83.t3 vdd.t44 4.70709064853166e-05f
CMODEL12148 a_0_83.t3 vdd.n25 7.97591539429729e-05f
CMODEL12149 a_0_83.t3 vdd.t43 4.71728680865227e-05f
CMODEL12150 a_0_83.t3 vdd.n26 0.000426756455202023f
CMODEL12151 a_0_83.t3 vdd.n27 0.000285295472825558f
CMODEL12152 a_0_83.t3 vdd.n28 6.4443188287711e-05f
CMODEL12153 a_0_83.t3 vdd.t29 5.39053457068864e-06f
CMODEL12154 a_0_83.t3 vdd.t28 4.26093828234379e-05f
CMODEL12155 a_0_83.t3 vdd.n29 9.61974378526728e-06f
CMODEL12156 a_0_83.t3 vdd.n30 3.06891088089241e-06f
CMODEL12157 a_0_83.t3 vdd.t38 1.4129952260119e-06f
CMODEL12158 a_0_83.t3 vdd.t40 1.4129952260119e-06f
CMODEL12159 a_0_83.t3 vdd.t37 2.85524084067003e-05f
CMODEL12160 a_0_83.t3 vdd.t39 2.85524084067003e-05f
CMODEL12161 a_0_83.t3 vdd.n31 9.24744815665038e-06f
CMODEL12162 a_0_83.t3 vdd.n32 0.000111597342840647f
CMODEL12163 a_0_83.t3 vdd.n33 5.65464721226314e-05f
CMODEL12164 a_0_83.t3 vdd.t17 5.39053457068864e-06f
CMODEL12165 a_0_83.t3 vdd.t16 4.26093828234379e-05f
CMODEL12166 a_0_83.t3 vdd.n34 9.61974378526728e-06f
CMODEL12167 a_0_83.t3 vdd.n35 3.06891088089241e-06f
CMODEL12168 a_0_83.t3 vdd.t1 1.4129952260119e-06f
CMODEL12169 a_0_83.t3 vdd.t31 1.4129952260119e-06f
CMODEL12170 a_0_83.t3 vdd.t0 2.85524084067003e-05f
CMODEL12171 a_0_83.t3 vdd.t30 2.85524084067003e-05f
CMODEL12172 a_0_83.t3 vdd.n36 9.24744815665038e-06f
CMODEL12173 a_0_83.t3 vdd.n37 0.000108227425512649f
CMODEL12174 a_0_83.t3 vdd.n38 6.24306193457449e-05f
CMODEL12175 a_0_83.t3 vdd.t19 5.39053457068864e-06f
CMODEL12176 a_0_83.t3 vdd.t18 4.26093828234379e-05f
CMODEL12177 a_0_83.t3 vdd.n39 5.26827940139747e-05f
CMODEL12178 a_0_83.t3 vdd.t21 5.3905839467667e-06f
CMODEL12179 a_0_83.t3 vdd.t20 4.26093828234379e-05f
CMODEL12180 a_0_83.t3 vdd.n40 5.26827940139747e-05f
CMODEL12181 a_0_83.t3 vdd.t11 5.39053457068864e-06f
CMODEL12182 a_0_83.t3 vdd.t10 4.26093828234379e-05f
CMODEL12183 a_0_83.t3 vdd.n41 0.000226651011145907f
CMODEL12184 a_0_83.t3 vdd.n42 0.000434149535370831f
CMODEL12185 a_0_83.t3 vdd.n43 5.26827940139747e-05f
CMODEL12186 a_0_83.t3 vdd.t13 5.39053457068864e-06f
CMODEL12187 a_0_83.t3 vdd.t12 4.26093828234379e-05f
CMODEL12188 a_0_83.t3 vdd.n44 5.26827940139747e-05f
CMODEL12189 a_0_83.t3 vdd.t23 5.39053457068864e-06f
CMODEL12190 a_0_83.t3 vdd.t22 4.26093828234379e-05f
CMODEL12191 a_0_83.t3 vdd.n45 6.50347137029405e-05f
CMODEL12192 a_0_83.t3 vdd.n46 0.00107346556279953f
CMODEL12193 a_9600_n36000.t1 a_n104_n35959.t0 0.00125951580213852f
CMODEL12194 a_9600_n36000.t1 a_n104_n35959.t3 0.00109914933355341f
CMODEL12195 a_9600_n36000.t1 a_n104_n35959.t4 0.000440690311843845f
CMODEL12196 a_9600_n36000.t1 a_n104_n35959.t2 0.000603177362412026f
CMODEL12197 a_9600_n36000.t1 a_n104_n35959.n0 0.0450267527594626f
CMODEL12198 a_9600_n36000.t1 a_n104_n35959.t1 0.00111624830651092f
CMODEL12199 a_9600_n36000.t1 a_n104_n35959.n1 0.0210342602710046f
CMODEL12200 a_9600_n36000.t2 a_n104_n35959.t0 0.00164815664250551f
CMODEL12201 a_9600_n36000.t2 a_n104_n35959.t3 0.0014383069050231f
CMODEL12202 a_9600_n36000.t2 a_n104_n35959.t4 0.000576671339510017f
CMODEL12203 a_9600_n36000.t2 a_n104_n35959.t2 0.000789295993571819f
CMODEL12204 a_9600_n36000.t2 a_n104_n35959.n0 0.0589203736268801f
CMODEL12205 a_9600_n36000.t2 a_n104_n35959.t1 0.00146068200012878f
CMODEL12206 a_9600_n36000.t2 a_n104_n35959.n1 0.0275246691839704f
CMODEL12207 a_9600_n36000.t0 a_n104_n35959.t0 0.000508912115759476f
CMODEL12208 a_9600_n36000.t0 a_n104_n35959.t3 0.000444115438587219f
CMODEL12209 a_9600_n36000.t0 a_n104_n35959.t4 0.000178062584537934f
CMODEL12210 a_9600_n36000.t0 a_n104_n35959.t2 0.000243716090867722f
CMODEL12211 a_9600_n36000.t0 a_n104_n35959.n0 0.0181932294725404f
CMODEL12212 a_9600_n36000.t0 a_n104_n35959.t1 0.000451024343176068f
CMODEL12213 a_9600_n36000.t0 a_n104_n35959.n1 0.0084989722874276f
CMODEL12214 a_9600_n36000.n0 a_n104_n35959.t0 0.0261255145171617f
CMODEL12215 a_9600_n36000.n0 a_n104_n35959.t3 0.022799112025051f
CMODEL12216 a_9600_n36000.n0 a_n104_n35959.t4 0.00914102158948748f
CMODEL12217 a_9600_n36000.n0 a_n104_n35959.t2 0.0125114102668365f
CMODEL12218 a_9600_n36000.n0 a_n104_n35959.n0 0.933967704796302f
CMODEL12219 a_9600_n36000.n0 a_n104_n35959.t1 0.0231537875801108f
CMODEL12220 a_9600_n36000.n0 a_n104_n35959.n1 0.436303277128277f
CMODEL12221 a_9600_n36000.t3 a_n104_n35959.t0 0.000544574926866053f
CMODEL12222 a_9600_n36000.t3 a_n104_n35959.t3 0.000475237521370047f
CMODEL12223 a_9600_n36000.t3 a_n104_n35959.t4 0.000190540598169125f
CMODEL12224 a_9600_n36000.t3 a_n104_n35959.t2 0.000260794876463695f
CMODEL12225 a_9600_n36000.t3 a_n104_n35959.n0 0.0194681484339991f
CMODEL12226 a_9600_n36000.t3 a_n104_n35959.t1 0.000482630578235243f
CMODEL12227 a_9600_n36000.t3 a_n104_n35959.n1 0.00909455104041962f
CMODEL12228 a_9600_n36000.n1 a_n104_n35959.t0 0.013066947293316f
CMODEL12229 a_9600_n36000.n1 a_n104_n35959.t3 0.0114032125556819f
CMODEL12230 a_9600_n36000.n1 a_n104_n35959.t4 0.00457197684043442f
CMODEL12231 a_9600_n36000.n1 a_n104_n35959.t2 0.00625771172523365f
CMODEL12232 a_9600_n36000.n1 a_n104_n35959.n0 0.467133643022256f
CMODEL12233 a_9600_n36000.n1 a_n104_n35959.t1 0.0115806072164129f
CMODEL12234 a_9600_n36000.n1 a_n104_n35959.n1 0.218221613296503f
CMODEL12235 a_11200_n23917.t0 vdd 6.37208351119052e-06f
CMODEL12236 a_11200_n23917.t0 vdd.n0 0.00213835265160586f
CMODEL12237 a_11200_n23917.t0 vdd.n1 0.000198162760893531f
CMODEL12238 a_11200_n23917.t0 vdd.t7 1.63358249794458e-05f
CMODEL12239 a_11200_n23917.t0 vdd.t6 0.0001291262325022f
CMODEL12240 a_11200_n23917.t0 vdd.n2 0.000177700521457597f
CMODEL12241 a_11200_n23917.t0 vdd.t27 1.63358249794458e-05f
CMODEL12242 a_11200_n23917.t0 vdd.t26 0.0001291262325022f
CMODEL12243 a_11200_n23917.t0 vdd.n3 0.000333300327999747f
CMODEL12244 a_11200_n23917.t0 vdd.n4 0.000177700521457597f
CMODEL12245 a_11200_n23917.t0 vdd.t36 1.63358249794458e-05f
CMODEL12246 a_11200_n23917.t0 vdd.t35 0.0001291262325022f
CMODEL12247 a_11200_n23917.t0 vdd.n5 0.000253550713724283f
CMODEL12248 a_11200_n23917.t0 vdd.t3 2.60219832639527e-05f
CMODEL12249 a_11200_n23917.t0 vdd.n6 0.000248965975030923f
CMODEL12250 a_11200_n23917.t0 vdd.t2 0.000326287054417574f
CMODEL12251 a_11200_n23917.t0 vdd.n7 0.000333749225391395f
CMODEL12252 a_11200_n23917.t0 vdd.t25 2.60219832639527e-05f
CMODEL12253 a_11200_n23917.t0 vdd.n8 0.00015037763355265f
CMODEL12254 a_11200_n23917.t0 vdd.t24 0.000326287054417574f
CMODEL12255 a_11200_n23917.t0 vdd.n9 0.000333749225391395f
CMODEL12256 a_11200_n23917.t0 vdd.t5 2.60219832639527e-05f
CMODEL12257 a_11200_n23917.t0 vdd.n10 0.000445282271320144f
CMODEL12258 a_11200_n23917.t0 vdd.t4 0.000326466613374233f
CMODEL12259 a_11200_n23917.t0 vdd.n11 0.00107661754823181f
CMODEL12260 a_11200_n23917.t0 vdd.n12 0.00265453976226137f
CMODEL12261 a_11200_n23917.t0 vdd.n13 0.000201210774182818f
CMODEL12262 a_11200_n23917.t0 vdd.t42 1.63358249794458e-05f
CMODEL12263 a_11200_n23917.t0 vdd.t41 0.0001291262325022f
CMODEL12264 a_11200_n23917.t0 vdd.n14 0.000180904152509322f
CMODEL12265 a_11200_n23917.t0 vdd.t9 1.63358249794458e-05f
CMODEL12266 a_11200_n23917.t0 vdd.t8 0.0001291262325022f
CMODEL12267 a_11200_n23917.t0 vdd.n15 0.000347311911917706f
CMODEL12268 a_11200_n23917.t0 vdd.t15 2.75111255445115e-05f
CMODEL12269 a_11200_n23917.t0 vdd.n16 0.000216396972942255f
CMODEL12270 a_11200_n23917.t0 vdd.t14 0.000371107962648942f
CMODEL12271 a_11200_n23917.t0 vdd.n17 0.000303125445333199f
CMODEL12272 a_11200_n23917.t0 vdd.t32 0.000371107962648942f
CMODEL12273 a_11200_n23917.t0 vdd.n18 0.000299226023324421f
CMODEL12274 a_11200_n23917.t0 vdd.t34 2.75111255445115e-05f
CMODEL12275 a_11200_n23917.t0 vdd.n19 0.000301323870468054f
CMODEL12276 a_11200_n23917.t0 vdd.t33 0.000371107962648942f
CMODEL12277 a_11200_n23917.t0 vdd.n20 0.000601335464227858f
CMODEL12278 a_11200_n23917.t0 vdd.t48 0.000371817220527746f
CMODEL12279 a_11200_n23917.t0 vdd.n21 0.00106743610024798f
CMODEL12280 a_11200_n23917.t0 vdd.n22 0.00467789986537352f
CMODEL12281 a_11200_n23917.t0 vdd.t47 5.28871454618834e-06f
CMODEL12282 a_11200_n23917.t0 vdd.t45 5.23441292504537e-06f
CMODEL12283 a_11200_n23917.t0 vdd.n23 5.97709869627985e-05f
CMODEL12284 a_11200_n23917.t0 vdd.t46 0.000142646722673696f
CMODEL12285 a_11200_n23917.t0 vdd.n24 0.000153261051131666f
CMODEL12286 a_11200_n23917.t0 vdd.t44 0.000142646722673696f
CMODEL12287 a_11200_n23917.t0 vdd.n25 0.000241707304207982f
CMODEL12288 a_11200_n23917.t0 vdd.t43 0.000142955713711613f
CMODEL12289 a_11200_n23917.t0 vdd.n26 0.0012932703926873f
CMODEL12290 a_11200_n23917.t0 vdd.n27 0.000864577872637812f
CMODEL12291 a_11200_n23917.t0 vdd.n28 0.000195292810236265f
CMODEL12292 a_11200_n23917.t0 vdd.t29 1.63358249794458e-05f
CMODEL12293 a_11200_n23917.t0 vdd.t28 0.0001291262325022f
CMODEL12294 a_11200_n23917.t0 vdd.n29 2.91522944083749e-05f
CMODEL12295 a_11200_n23917.t0 vdd.n30 9.30022623366107e-06f
CMODEL12296 a_11200_n23917.t0 vdd.t38 4.28203221892594e-06f
CMODEL12297 a_11200_n23917.t0 vdd.t40 4.28203221892594e-06f
CMODEL12298 a_11200_n23917.t0 vdd.t37 8.65270670945588e-05f
CMODEL12299 a_11200_n23917.t0 vdd.t39 8.65270670945588e-05f
CMODEL12300 a_11200_n23917.t0 vdd.n31 2.80240656307007e-05f
CMODEL12301 a_11200_n23917.t0 vdd.n32 0.000338191813244067f
CMODEL12302 a_11200_n23917.t0 vdd.n33 0.000171362090287534f
CMODEL12303 a_11200_n23917.t0 vdd.t17 1.63358249794458e-05f
CMODEL12304 a_11200_n23917.t0 vdd.t16 0.0001291262325022f
CMODEL12305 a_11200_n23917.t0 vdd.n34 2.91522944083749e-05f
CMODEL12306 a_11200_n23917.t0 vdd.n35 9.30022623366107e-06f
CMODEL12307 a_11200_n23917.t0 vdd.t1 4.28203221892594e-06f
CMODEL12308 a_11200_n23917.t0 vdd.t31 4.28203221892594e-06f
CMODEL12309 a_11200_n23917.t0 vdd.t0 8.65270670945588e-05f
CMODEL12310 a_11200_n23917.t0 vdd.t30 8.65270670945588e-05f
CMODEL12311 a_11200_n23917.t0 vdd.n36 2.80240656307007e-05f
CMODEL12312 a_11200_n23917.t0 vdd.n37 0.000327979397584085f
CMODEL12313 a_11200_n23917.t0 vdd.n38 0.000189193791008413f
CMODEL12314 a_11200_n23917.t0 vdd.t19 1.63358249794458e-05f
CMODEL12315 a_11200_n23917.t0 vdd.t18 0.0001291262325022f
CMODEL12316 a_11200_n23917.t0 vdd.n39 0.000159653349988727f
CMODEL12317 a_11200_n23917.t0 vdd.t21 1.63359746119097e-05f
CMODEL12318 a_11200_n23917.t0 vdd.t20 0.0001291262325022f
CMODEL12319 a_11200_n23917.t0 vdd.n40 0.000159653349988727f
CMODEL12320 a_11200_n23917.t0 vdd.t11 1.63358249794458e-05f
CMODEL12321 a_11200_n23917.t0 vdd.t10 0.0001291262325022f
CMODEL12322 a_11200_n23917.t0 vdd.n41 0.00068685789895991f
CMODEL12323 a_11200_n23917.t0 vdd.n42 0.00131567486150443f
CMODEL12324 a_11200_n23917.t0 vdd.n43 0.000159653349988727f
CMODEL12325 a_11200_n23917.t0 vdd.t13 1.63358249794458e-05f
CMODEL12326 a_11200_n23917.t0 vdd.t12 0.0001291262325022f
CMODEL12327 a_11200_n23917.t0 vdd.n44 0.000159653349988727f
CMODEL12328 a_11200_n23917.t0 vdd.t23 1.63358249794458e-05f
CMODEL12329 a_11200_n23917.t0 vdd.t22 0.0001291262325022f
CMODEL12330 a_11200_n23917.t0 vdd.n45 0.000197085407153577f
CMODEL12331 a_11200_n23917.t0 vdd.n46 0.00325309954428421f
CMODEL12332 a_11200_n23917.t1 vdd 6.36938639771663e-06f
CMODEL12333 a_11200_n23917.t1 vdd.n0 0.00213744755051319f
CMODEL12334 a_11200_n23917.t1 vdd.n1 0.000198078884489292f
CMODEL12335 a_11200_n23917.t1 vdd.t7 1.63289105104842e-05f
CMODEL12336 a_11200_n23917.t1 vdd.t6 0.000129071577207601f
CMODEL12337 a_11200_n23917.t1 vdd.n2 0.000177625306110859f
CMODEL12338 a_11200_n23917.t1 vdd.t27 1.63289105104842e-05f
CMODEL12339 a_11200_n23917.t1 vdd.t26 0.000129071577207601f
CMODEL12340 a_11200_n23917.t1 vdd.n3 0.00033315925188172f
CMODEL12341 a_11200_n23917.t1 vdd.n4 0.000177625306110859f
CMODEL12342 a_11200_n23917.t1 vdd.t36 1.63289105104842e-05f
CMODEL12343 a_11200_n23917.t1 vdd.t35 0.000129071577207601f
CMODEL12344 a_11200_n23917.t1 vdd.n5 0.000253443393246593f
CMODEL12345 a_11200_n23917.t1 vdd.t3 2.60109689322109e-05f
CMODEL12346 a_11200_n23917.t1 vdd.n6 0.000248860595136793f
CMODEL12347 a_11200_n23917.t1 vdd.t2 0.000326148946809712f
CMODEL12348 a_11200_n23917.t1 vdd.n7 0.00033360795926845f
CMODEL12349 a_11200_n23917.t1 vdd.t25 2.60109689322109e-05f
CMODEL12350 a_11200_n23917.t1 vdd.n8 0.000150313983171905f
CMODEL12351 a_11200_n23917.t1 vdd.t24 0.000326148946809712f
CMODEL12352 a_11200_n23917.t1 vdd.n9 0.00033360795926845f
CMODEL12353 a_11200_n23917.t1 vdd.t5 2.60109689322109e-05f
CMODEL12354 a_11200_n23917.t1 vdd.n10 0.000445093796575336f
CMODEL12355 a_11200_n23917.t1 vdd.t4 0.000326328429764404f
CMODEL12356 a_11200_n23917.t1 vdd.n11 0.00107616184803728f
CMODEL12357 a_11200_n23917.t1 vdd.n12 0.00265341617451378f
CMODEL12358 a_11200_n23917.t1 vdd.n13 0.000201125607645188f
CMODEL12359 a_11200_n23917.t1 vdd.t42 1.63289105104842e-05f
CMODEL12360 a_11200_n23917.t1 vdd.t41 0.000129071577207601f
CMODEL12361 a_11200_n23917.t1 vdd.n14 0.00018082758116082f
CMODEL12362 a_11200_n23917.t1 vdd.t9 1.63289105104842e-05f
CMODEL12363 a_11200_n23917.t1 vdd.t8 0.000129071577207601f
CMODEL12364 a_11200_n23917.t1 vdd.n15 0.000347164905112847f
CMODEL12365 a_11200_n23917.t1 vdd.t15 2.74994809031226e-05f
CMODEL12366 a_11200_n23917.t1 vdd.n16 0.000216305378538257f
CMODEL12367 a_11200_n23917.t1 vdd.t14 0.000370950883683393f
CMODEL12368 a_11200_n23917.t1 vdd.n17 0.000302997141345743f
CMODEL12369 a_11200_n23917.t1 vdd.t32 0.000370950883683393f
CMODEL12370 a_11200_n23917.t1 vdd.n18 0.00029909936984635f
CMODEL12371 a_11200_n23917.t1 vdd.t34 2.74994809031226e-05f
CMODEL12372 a_11200_n23917.t1 vdd.n19 0.000301196329033668f
CMODEL12373 a_11200_n23917.t1 vdd.t33 0.000370950883683393f
CMODEL12374 a_11200_n23917.t1 vdd.n20 0.000601080936806795f
CMODEL12375 a_11200_n23917.t1 vdd.t48 0.000371659841354426f
CMODEL12376 a_11200_n23917.t1 vdd.n21 0.00106698428628737f
CMODEL12377 a_11200_n23917.t1 vdd.n22 0.00467591984945969f
CMODEL12378 a_11200_n23917.t1 vdd.t47 5.28647599058293e-06f
CMODEL12379 a_11200_n23917.t1 vdd.t45 5.23219735370151e-06f
CMODEL12380 a_11200_n23917.t1 vdd.n23 5.97456876813308e-05f
CMODEL12381 a_11200_n23917.t1 vdd.t46 0.000142586344557644f
CMODEL12382 a_11200_n23917.t1 vdd.n24 0.000153196180285999f
CMODEL12383 a_11200_n23917.t1 vdd.t44 0.000142586344557644f
CMODEL12384 a_11200_n23917.t1 vdd.n25 0.000241604996693372f
CMODEL12385 a_11200_n23917.t1 vdd.t43 0.000142895204808843f
CMODEL12386 a_11200_n23917.t1 vdd.n26 0.00129272298978598f
CMODEL12387 a_11200_n23917.t1 vdd.n27 0.000864211922532885f
CMODEL12388 a_11200_n23917.t1 vdd.n28 0.0001952101485968f
CMODEL12389 a_11200_n23917.t1 vdd.t29 1.63289105104842e-05f
CMODEL12390 a_11200_n23917.t1 vdd.t28 0.000129071577207601f
CMODEL12391 a_11200_n23917.t1 vdd.n29 2.91399551090067e-05f
CMODEL12392 a_11200_n23917.t1 vdd.n30 9.29628972444222e-06f
CMODEL12393 a_11200_n23917.t1 vdd.t38 4.28021976201557e-06f
CMODEL12394 a_11200_n23917.t1 vdd.t40 4.28021976201557e-06f
CMODEL12395 a_11200_n23917.t1 vdd.t37 8.64904427599738e-05f
CMODEL12396 a_11200_n23917.t1 vdd.t39 8.64904427599738e-05f
CMODEL12397 a_11200_n23917.t1 vdd.n31 2.80122038770258e-05f
CMODEL12398 a_11200_n23917.t1 vdd.n32 0.000338048666705786f
CMODEL12399 a_11200_n23917.t1 vdd.n33 0.000171289557810234f
CMODEL12400 a_11200_n23917.t1 vdd.t17 1.63289105104842e-05f
CMODEL12401 a_11200_n23917.t1 vdd.t16 0.000129071577207601f
CMODEL12402 a_11200_n23917.t1 vdd.n34 2.91399551090067e-05f
CMODEL12403 a_11200_n23917.t1 vdd.n35 9.29628972444222e-06f
CMODEL12404 a_11200_n23917.t1 vdd.t1 4.28021976201557e-06f
CMODEL12405 a_11200_n23917.t1 vdd.t31 4.28021976201557e-06f
CMODEL12406 a_11200_n23917.t1 vdd.t0 8.64904427599738e-05f
CMODEL12407 a_11200_n23917.t1 vdd.t30 8.64904427599738e-05f
CMODEL12408 a_11200_n23917.t1 vdd.n36 2.80122038770258e-05f
CMODEL12409 a_11200_n23917.t1 vdd.n37 0.000327840573657683f
CMODEL12410 a_11200_n23917.t1 vdd.n38 0.000189113710902431f
CMODEL12411 a_11200_n23917.t1 vdd.t19 1.63289105104842e-05f
CMODEL12412 a_11200_n23917.t1 vdd.t18 0.000129071577207601f
CMODEL12413 a_11200_n23917.t1 vdd.n39 0.000159585773473032f
CMODEL12414 a_11200_n23917.t1 vdd.t21 1.63290600796131e-05f
CMODEL12415 a_11200_n23917.t1 vdd.t20 0.000129071577207601f
CMODEL12416 a_11200_n23917.t1 vdd.n40 0.000159585773473032f
CMODEL12417 a_11200_n23917.t1 vdd.t11 1.63289105104842e-05f
CMODEL12418 a_11200_n23917.t1 vdd.t10 0.000129071577207601f
CMODEL12419 a_11200_n23917.t1 vdd.n41 0.000686567172435268f
CMODEL12420 a_11200_n23917.t1 vdd.n42 0.00131511797545766f
CMODEL12421 a_11200_n23917.t1 vdd.n43 0.000159585773473032f
CMODEL12422 a_11200_n23917.t1 vdd.t13 1.63289105104842e-05f
CMODEL12423 a_11200_n23917.t1 vdd.t12 0.000129071577207601f
CMODEL12424 a_11200_n23917.t1 vdd.n44 0.000159585773473032f
CMODEL12425 a_11200_n23917.t1 vdd.t23 1.63289105104842e-05f
CMODEL12426 a_11200_n23917.t1 vdd.t22 0.000129071577207601f
CMODEL12427 a_11200_n23917.t1 vdd.n45 0.000197001986761141f
CMODEL12428 a_11200_n23917.t1 vdd.n46 0.0032517226039793f
CMODEL12429 a_19896_8041.t1 a_6400_83.t1 4.29092972429727e-06f
CMODEL12430 a_19896_8041.t1 a_6400_83.n0 4.84057223517321e-05f
CMODEL12431 a_19896_8041.t1 a_6400_83.t0 9.74144772113925e-07f
CMODEL12432 a_19896_8041.t1 a_6400_83.t3 9.60737720477804e-07f
CMODEL12433 a_19896_8041.t1 a_6400_83.t2 9.60737720477804e-07f
CMODEL12434 a_19896_8041.t1 a_6400_83.n1 0.000353795469797434f
CMODEL12435 a_19896_8041.t0 a_6400_83.t1 2.03158412440824e-06f
CMODEL12436 a_19896_8041.t0 a_6400_83.n0 2.29181793641231e-05f
CMODEL12437 a_19896_8041.t0 a_6400_83.t0 4.61218705749381e-07f
CMODEL12438 a_19896_8041.t0 a_6400_83.t3 4.54871001403437e-07f
CMODEL12439 a_19896_8041.t0 a_6400_83.t2 4.54871001403437e-07f
CMODEL12440 a_19896_8041.t0 a_6400_83.n1 0.000167508047418729f
CMODEL12441 a_19896_8041.n0 a_6400_83.t1 6.08650251424844e-06f
CMODEL12442 a_19896_8041.n0 a_6400_83.n0 6.86614719251967e-05f
CMODEL12443 a_19896_8041.n0 a_6400_83.t0 1.38178319983658e-06f
CMODEL12444 a_19896_8041.n0 a_6400_83.t3 1.36276586356332e-06f
CMODEL12445 a_19896_8041.n0 a_6400_83.t2 1.36276586356332e-06f
CMODEL12446 a_19896_8041.n0 a_6400_83.n1 0.000501843925398813f
CMODEL12447 a_19896_8041.t3 a_6400_83.t1 2.02830446735619e-06f
CMODEL12448 a_19896_8041.t3 a_6400_83.n0 2.28811817484848e-05f
CMODEL12449 a_19896_8041.t3 a_6400_83.t0 4.60474144319374e-07f
CMODEL12450 a_19896_8041.t3 a_6400_83.t3 4.54136687293771e-07f
CMODEL12451 a_19896_8041.t3 a_6400_83.t2 4.54136687293771e-07f
CMODEL12452 a_19896_8041.t3 a_6400_83.n1 0.000167237633340183f
CMODEL12453 a_19896_8041.t4 a_6400_83.t1 1.89791837651364e-06f
CMODEL12454 a_19896_8041.t4 a_6400_83.n0 2.14103040326103e-05f
CMODEL12455 a_19896_8041.t4 a_6400_83.t0 4.30873349873493e-07f
CMODEL12456 a_19896_8041.t4 a_6400_83.t3 4.24943285456223e-07f
CMODEL12457 a_19896_8041.t4 a_6400_83.t2 4.24943285456223e-07f
CMODEL12458 a_19896_8041.t4 a_6400_83.n1 0.000156487047516443f
CMODEL12459 a_19896_8041.t2 a_6400_83.t1 1.90859134980674e-06f
CMODEL12460 a_19896_8041.t2 a_6400_83.n0 2.15307052079006e-05f
CMODEL12461 a_19896_8041.t2 a_6400_83.t0 4.33296372808945e-07f
CMODEL12462 a_19896_8041.t2 a_6400_83.t3 4.27332960582868e-07f
CMODEL12463 a_19896_8041.t2 a_6400_83.t2 4.27332960582868e-07f
CMODEL12464 a_19896_8041.t2 a_6400_83.n1 0.000157367054844223f
CMODEL12465 a_19896_8041.n1 a_6400_83.t1 5.76453260819e-05f
CMODEL12466 a_19896_8041.n1 a_6400_83.n0 0.000650293486140114f
CMODEL12467 a_19896_8041.n1 a_6400_83.t0 1.30868824817871e-05f
CMODEL12468 a_19896_8041.n1 a_6400_83.t3 1.29067691000682e-05f
CMODEL12469 a_19896_8041.n1 a_6400_83.t2 1.29067691000682e-05f
CMODEL12470 a_19896_8041.n1 a_6400_83.n1 0.0047529688280113f
CMODEL12471 a_1600_n11917.t5 a_9600_n36000.t1 3.38675220793143e-05f
CMODEL12472 a_1600_n11917.t5 a_9600_n36000.t2 4.431780957845e-05f
CMODEL12473 a_1600_n11917.t5 a_9600_n36000.t0 1.36843001792041e-05f
CMODEL12474 a_1600_n11917.t5 a_9600_n36000.n0 0.000702497291610882f
CMODEL12475 a_1600_n11917.t5 a_9600_n36000.t3 1.4643248880373e-05f
CMODEL12476 a_1600_n11917.t5 a_9600_n36000.n1 0.00035136131298569f
CMODEL12477 a_1600_n11917.t4 a_9600_n36000.t1 5.38333243741871e-05f
CMODEL12478 a_1600_n11917.t4 a_9600_n36000.t2 7.04443334532391e-05f
CMODEL12479 a_1600_n11917.t4 a_9600_n36000.t0 2.17515579869006e-05f
CMODEL12480 a_1600_n11917.t4 a_9600_n36000.n0 0.00111663807239015f
CMODEL12481 a_1600_n11917.t4 a_9600_n36000.t3 2.32758323748329e-05f
CMODEL12482 a_1600_n11917.t4 a_9600_n36000.n1 0.000558498123665558f
CMODEL12483 a_1600_n11917.n0 a_9600_n36000.t1 0.000937177118607899f
CMODEL12484 a_1600_n11917.n0 a_9600_n36000.t2 0.00122635594616216f
CMODEL12485 a_1600_n11917.n0 a_9600_n36000.t0 0.00037866995353478f
CMODEL12486 a_1600_n11917.n0 a_9600_n36000.n0 0.0194394023288718f
CMODEL12487 a_1600_n11917.n0 a_9600_n36000.t3 0.000405205841768632f
CMODEL12488 a_1600_n11917.n0 a_9600_n36000.n1 0.00972281887417267f
CMODEL12489 a_1600_n11917.t6 a_9600_n36000.t1 9.93835633140768e-05f
CMODEL12490 a_1600_n11917.t6 a_9600_n36000.t2 0.000130049722086732f
CMODEL12491 a_1600_n11917.t6 a_9600_n36000.t0 4.01563040273155e-05f
CMODEL12492 a_1600_n11917.t6 a_9600_n36000.n0 0.00206146419260535f
CMODEL12493 a_1600_n11917.t6 a_9600_n36000.t3 4.29703197304536e-05f
CMODEL12494 a_1600_n11917.t6 a_9600_n36000.n1 0.0010310627158802f
CMODEL12495 a_1600_n11917.n1 a_9600_n36000.t1 0.00552118628621122f
CMODEL12496 a_1600_n11917.n1 a_9600_n36000.t2 0.00722482388603532f
CMODEL12497 a_1600_n11917.n1 a_9600_n36000.t0 0.00223085616682793f
CMODEL12498 a_1600_n11917.n1 a_9600_n36000.n0 0.114523241572241f
CMODEL12499 a_1600_n11917.n1 a_9600_n36000.t3 0.00238718689588672f
CMODEL12500 a_1600_n11917.n1 a_9600_n36000.n1 0.0572799881319524f
CMODEL12501 a_1600_n11917.t2 a_9600_n36000.t1 6.941657580204e-06f
CMODEL12502 a_1600_n11917.t2 a_9600_n36000.t2 9.08360104048431e-06f
CMODEL12503 a_1600_n11917.t2 a_9600_n36000.t0 2.8048029568357e-06f
CMODEL12504 a_1600_n11917.t2 a_9600_n36000.n0 0.000143987376400411f
CMODEL12505 a_1600_n11917.t2 a_9600_n36000.t3 3.00135390334151e-06f
CMODEL12506 a_1600_n11917.t2 a_9600_n36000.n1 7.20167810318565e-05f
CMODEL12507 a_1600_n11917.t3 a_9600_n36000.t1 6.941657580204e-06f
CMODEL12508 a_1600_n11917.t3 a_9600_n36000.t2 9.08360104048431e-06f
CMODEL12509 a_1600_n11917.t3 a_9600_n36000.t0 2.8048029568357e-06f
CMODEL12510 a_1600_n11917.t3 a_9600_n36000.n0 0.000143987376400411f
CMODEL12511 a_1600_n11917.t3 a_9600_n36000.t3 3.00135390334151e-06f
CMODEL12512 a_1600_n11917.t3 a_9600_n36000.n1 7.20167810318565e-05f
CMODEL12513 a_1600_n11917.n2 a_9600_n36000.t1 0.00168390656323755f
CMODEL12514 a_1600_n11917.n2 a_9600_n36000.t2 0.00220349898178837f
CMODEL12515 a_1600_n11917.n2 a_9600_n36000.t0 0.000680388805272204f
CMODEL12516 a_1600_n11917.n2 a_9600_n36000.n0 0.0349284425719084f
CMODEL12517 a_1600_n11917.n2 a_9600_n36000.t3 0.000728068113133131f
CMODEL12518 a_1600_n11917.n2 a_9600_n36000.n1 0.0174698231426191f
CMODEL12519 a_1600_n11917.t1 a_9600_n36000.t1 2.45241615246582e-05f
CMODEL12520 a_1600_n11917.t1 a_9600_n36000.t2 3.20914272374473e-05f
CMODEL12521 a_1600_n11917.t1 a_9600_n36000.t0 9.9090800667607e-06f
CMODEL12522 a_1600_n11917.t1 a_9600_n36000.n0 0.000508692576024712f
CMODEL12523 a_1600_n11917.t1 a_9600_n36000.t3 1.06034743240746e-05f
CMODEL12524 a_1600_n11917.t1 a_9600_n36000.n1 0.000254427872608964f
CMODEL12525 a_1600_n11917.t0 a_9600_n36000.t1 3.37073857763153e-05f
CMODEL12526 a_1600_n11917.t0 a_9600_n36000.t2 4.41082610272957e-05f
CMODEL12527 a_1600_n11917.t0 a_9600_n36000.t0 1.3619596501306e-05f
CMODEL12528 a_1600_n11917.t0 a_9600_n36000.n0 0.000699175663329901f
CMODEL12529 a_1600_n11917.t0 a_9600_n36000.t3 1.45740109912205e-05f
CMODEL12530 a_1600_n11917.t0 a_9600_n36000.n1 0.000349699966119313f
CMODEL12531 a_1600_n11917.n3 a_9600_n36000.t1 0.00467244378793205f
CMODEL12532 a_1600_n11917.n3 a_9600_n36000.t2 0.0061141902727528f
CMODEL12533 a_1600_n11917.n3 a_9600_n36000.t0 0.00188791855556426f
CMODEL12534 a_1600_n11917.n3 a_9600_n36000.n0 0.0969181949166329f
CMODEL12535 a_1600_n11917.n3 a_9600_n36000.t3 0.00202021739606487f
CMODEL12536 a_1600_n11917.n3 a_9600_n36000.n1 0.0484746412901098f
CMODEL12537 a_1600_n11917.n4 a_9600_n36000.t1 0.00685053861733065f
CMODEL12538 a_1600_n11917.n4 a_9600_n36000.t2 0.00896436607442598f
CMODEL12539 a_1600_n11917.n4 a_9600_n36000.t0 0.00276798599582342f
CMODEL12540 a_1600_n11917.n4 a_9600_n36000.n0 0.142097340734884f
CMODEL12541 a_1600_n11917.n4 a_9600_n36000.t3 0.00296195693630179f
CMODEL12542 a_1600_n11917.n4 a_9600_n36000.n1 0.0710714600733849f
CMODEL12543 a_0_n11917.t2 a_3200_n23917.t1 8.22635089528279e-06f
CMODEL12544 a_0_n11917.t2 a_3200_n23917.n0 1.17463232669966e-05f
CMODEL12545 a_0_n11917.t2 a_3200_n23917.t0 1.86758294765927e-06f
CMODEL12546 a_0_n11917.t2 a_3200_n23917.t3 5.43314488486325e-06f
CMODEL12547 a_0_n11917.t2 a_3200_n23917.n1 0.000277620925070061f
CMODEL12548 a_0_n11917.t2 a_3200_n23917.t2 6.95754682269822e-06f
CMODEL12549 a_0_n11917.t1 a_3200_n23917.t1 1.28689857679531e-05f
CMODEL12550 a_0_n11917.t1 a_3200_n23917.n0 1.83754946601459e-05f
CMODEL12551 a_0_n11917.t1 a_3200_n23917.t0 2.92157466656093e-06f
CMODEL12552 a_0_n11917.t1 a_3200_n23917.t3 8.4994021150527e-06f
CMODEL12553 a_0_n11917.t1 a_3200_n23917.n1 0.000434299457814432f
CMODEL12554 a_0_n11917.t1 a_3200_n23917.t2 1.08841176581117e-05f
CMODEL12555 a_0_n11917.n0 a_3200_n23917.t1 0.00035091394114416f
CMODEL12556 a_0_n11917.n0 a_3200_n23917.n0 0.000501066468479816f
CMODEL12557 a_0_n11917.n0 a_3200_n23917.t0 7.96660513171818e-05f
CMODEL12558 a_0_n11917.n0 a_3200_n23917.t3 0.000231763306552833f
CMODEL12559 a_0_n11917.n0 a_3200_n23917.n1 0.0118425598665243f
CMODEL12560 a_0_n11917.n0 a_3200_n23917.t2 0.000296790181616017f
CMODEL12561 a_0_n11917.t6 a_3200_n23917.t1 2.19254824731542e-05f
CMODEL12562 a_0_n11917.t6 a_3200_n23917.n0 3.13071747355465e-05f
CMODEL12563 a_0_n11917.t6 a_3200_n23917.t0 4.97762102629801e-06f
CMODEL12564 a_0_n11917.t6 a_3200_n23917.t3 1.44808219906454e-05f
CMODEL12565 a_0_n11917.t6 a_3200_n23917.n1 0.000739935945389215f
CMODEL12566 a_0_n11917.t6 a_3200_n23917.t2 1.85437714557854e-05f
CMODEL12567 a_0_n11917.n1 a_3200_n23917.t1 0.00136042430527787f
CMODEL12568 a_0_n11917.n1 a_3200_n23917.n0 0.00194253611029849f
CMODEL12569 a_0_n11917.n1 a_3200_n23917.t0 0.000308849606157096f
CMODEL12570 a_0_n11917.n1 a_3200_n23917.t3 0.000898500738608477f
CMODEL12571 a_0_n11917.n1 a_3200_n23917.n1 0.0459112745039371f
CMODEL12572 a_0_n11917.n1 a_3200_n23917.t2 0.00115059713877937f
CMODEL12573 a_0_n11917.t4 a_3200_n23917.t1 1.74060687470756e-06f
CMODEL12574 a_0_n11917.t4 a_3200_n23917.n0 2.48539495717302e-06f
CMODEL12575 a_0_n11917.t4 a_3200_n23917.t0 3.95160352282856e-07f
CMODEL12576 a_0_n11917.t4 a_3200_n23917.t3 1.14959469371749e-06f
CMODEL12577 a_0_n11917.t4 a_3200_n23917.n1 5.87415850467449e-05f
CMODEL12578 a_0_n11917.t4 a_3200_n23917.t2 1.47214165610571e-06f
CMODEL12579 a_0_n11917.t5 a_3200_n23917.t1 1.75736948386347e-06f
CMODEL12580 a_0_n11917.t5 a_3200_n23917.n0 2.50933011730052e-06f
CMODEL12581 a_0_n11917.t5 a_3200_n23917.t0 3.98965874733376e-07f
CMODEL12582 a_0_n11917.t5 a_3200_n23917.t3 1.16066566374438e-06f
CMODEL12583 a_0_n11917.t5 a_3200_n23917.n1 5.93072855766262e-05f
CMODEL12584 a_0_n11917.t5 a_3200_n23917.t2 1.48631885807015e-06f
CMODEL12585 a_0_n11917.n2 a_3200_n23917.t1 0.000441955411375926f
CMODEL12586 a_0_n11917.n2 a_3200_n23917.n0 0.000631063663306284f
CMODEL12587 a_0_n11917.n2 a_3200_n23917.t0 0.000100334692796136f
CMODEL12588 a_0_n11917.n2 a_3200_n23917.t3 0.000291892214813212f
CMODEL12589 a_0_n11917.n2 a_3200_n23917.n1 0.0149150056577651f
CMODEL12590 a_0_n11917.n2 a_3200_n23917.t2 0.000373789728560704f
CMODEL12591 a_0_n11917.t0 a_3200_n23917.t1 3.48335157449186e-06f
CMODEL12592 a_0_n11917.t0 a_3200_n23917.n0 4.97384249315763e-06f
CMODEL12593 a_0_n11917.t0 a_3200_n23917.t0 7.90806043169574e-07f
CMODEL12594 a_0_n11917.t0 a_3200_n23917.t3 2.30060132737386e-06f
CMODEL12595 a_0_n11917.t0 a_3200_n23917.n1 0.000117555316903539f
CMODEL12596 a_0_n11917.t0 a_3200_n23917.t2 2.94609140650005e-06f
CMODEL12597 a_0_n11917.t3 a_3200_n23917.t1 6.25563677153246e-06f
CMODEL12598 a_0_n11917.t3 a_3200_n23917.n0 8.93236049552262e-06f
CMODEL12599 a_0_n11917.t3 a_3200_n23917.t0 1.42018261924174e-06f
CMODEL12600 a_0_n11917.t3 a_3200_n23917.t3 4.13157441974709e-06f
CMODEL12601 a_0_n11917.t3 a_3200_n23917.n1 0.000211113735545975f
CMODEL12602 a_0_n11917.t3 a_3200_n23917.t2 5.29078886832891e-06f
CMODEL12603 a_0_n11917.n3 a_3200_n23917.t1 0.000969897753308211f
CMODEL12604 a_0_n11917.n3 a_3200_n23917.n0 0.00138490719534282f
CMODEL12605 a_0_n11917.n3 a_3200_n23917.t0 0.000220190522883012f
CMODEL12606 a_0_n11917.n3 a_3200_n23917.t3 0.000640575035554171f
CMODEL12607 a_0_n11917.n3 a_3200_n23917.n1 0.0327318777091313f
CMODEL12608 a_0_n11917.n3 a_3200_n23917.t2 0.000820304059208225f
CMODEL12609 a_0_n11917.n4 a_3200_n23917.t1 0.0017666986434152f
CMODEL12610 a_0_n11917.n4 a_3200_n23917.n0 0.0025226511298976f
CMODEL12611 a_0_n11917.n4 a_3200_n23917.t0 0.000401083822231191f
CMODEL12612 a_0_n11917.n4 a_3200_n23917.t3 0.00116682716550182f
CMODEL12613 a_0_n11917.n4 a_3200_n23917.n1 0.0596221238248176f
CMODEL12614 a_0_n11917.n4 a_3200_n23917.t2 0.00149420912013457f
CMODEL12615 a_1600_n11917.t5 din 1.91540492567976e-06f
CMODEL12616 a_1600_n11917.t5 din.t0 1.07830411513009e-05f
CMODEL12617 a_1600_n11917.t5 din.t1 1.11572162582488e-05f
CMODEL12618 a_1600_n11917.t5 din.n0 0.000628103986903355f
CMODEL12619 a_1600_n11917.t5 din.t2 1.90046806506633e-05f
CMODEL12620 a_1600_n11917.t5 din.n1 0.00082795423295115f
CMODEL12621 a_1600_n11917.t5 din.t3 1.39925090945227e-05f
CMODEL12622 a_1600_n11917.t4 din 3.04458691812631e-06f
CMODEL12623 a_1600_n11917.t4 din.t0 1.71399298324438e-05f
CMODEL12624 a_1600_n11917.t4 din.t1 1.77346910865415e-05f
CMODEL12625 a_1600_n11917.t4 din.n0 0.000998387941949282f
CMODEL12626 a_1600_n11917.t4 din.t2 3.0208443821164e-05f
CMODEL12627 a_1600_n11917.t4 din.n1 0.00131605520725899f
CMODEL12628 a_1600_n11917.t4 din.t3 2.2241464230248e-05f
CMODEL12629 a_1600_n11917.n0 din 5.30028050180953e-05f
CMODEL12630 a_1600_n11917.n0 din.t0 0.000298386737959164f
CMODEL12631 a_1600_n11917.n0 din.t1 0.00030874085680385f
CMODEL12632 a_1600_n11917.n0 din.n0 0.0173808016793692f
CMODEL12633 a_1600_n11917.n0 din.t2 0.000525894743953838f
CMODEL12634 a_1600_n11917.n0 din.n1 0.0229110284643559f
CMODEL12635 a_1600_n11917.n0 din.t3 0.000387198665570785f
CMODEL12636 a_1600_n11917.t6 din 5.62071728358472e-06f
CMODEL12637 a_1600_n11917.t6 din.t0 3.16426176815916e-05f
CMODEL12638 a_1600_n11917.t6 din.t1 3.274062701764e-05f
CMODEL12639 a_1600_n11917.t6 din.n0 0.00184315853412732f
CMODEL12640 a_1600_n11917.t6 din.t2 5.5768853661208e-05f
CMODEL12641 a_1600_n11917.t6 din.n1 0.00242961506717129f
CMODEL12642 a_1600_n11917.t6 din.t3 4.10607368989555e-05f
CMODEL12643 a_1600_n11917.n1 din 0.000312255127004515f
CMODEL12644 a_1600_n11917.n1 din.t0 0.00175788411058796f
CMODEL12645 a_1600_n11917.n1 din.t1 0.00181888327268445f
CMODEL12646 a_1600_n11917.n1 din.n0 0.102395419147701f
CMODEL12647 a_1600_n11917.n1 din.t2 0.00309820074632371f
CMODEL12648 a_1600_n11917.n1 din.n1 0.134975613092535f
CMODEL12649 a_1600_n11917.n1 din.t3 0.00228110132006235f
CMODEL12650 a_1600_n11917.t2 din 3.92591022465916e-07f
CMODEL12651 a_1600_n11917.t2 din.t0 2.21014632160815e-06f
CMODEL12652 a_1600_n11917.t2 din.t1 2.28683913253733e-06f
CMODEL12653 a_1600_n11917.t2 din.n0 0.000128739350686276f
CMODEL12654 a_1600_n11917.t2 din.t2 3.89529488425757e-06f
CMODEL12655 a_1600_n11917.t2 din.n1 0.000169701661779907f
CMODEL12656 a_1600_n11917.t2 din.t3 2.86797500551105e-06f
CMODEL12657 a_1600_n11917.t3 din 3.92591022465916e-07f
CMODEL12658 a_1600_n11917.t3 din.t0 2.21014632160815e-06f
CMODEL12659 a_1600_n11917.t3 din.t1 2.28683913253733e-06f
CMODEL12660 a_1600_n11917.t3 din.n0 0.000128739350686276f
CMODEL12661 a_1600_n11917.t3 din.t2 3.89529488425757e-06f
CMODEL12662 a_1600_n11917.t3 din.n1 0.000169701661779907f
CMODEL12663 a_1600_n11917.t3 din.t3 2.86797500551105e-06f
CMODEL12664 a_1600_n11917.n2 din 9.52346887987912e-05f
CMODEL12665 a_1600_n11917.n2 din.t0 0.000536137061454122f
CMODEL12666 a_1600_n11917.n2 din.t1 0.000554741195435762f
CMODEL12667 a_1600_n11917.n2 din.n0 0.031229578103331f
CMODEL12668 a_1600_n11917.n2 din.t2 0.0009449202219442f
CMODEL12669 a_1600_n11917.n2 din.n1 0.0411662112055817f
CMODEL12670 a_1600_n11917.n2 din.t3 0.000695713074173184f
CMODEL12671 a_1600_n11917.t1 din 1.38698366158849e-06f
CMODEL12672 a_1600_n11917.t1 din.t0 7.8082193997611e-06f
CMODEL12673 a_1600_n11917.t1 din.t1 8.07916720455789e-06f
CMODEL12674 a_1600_n11917.t1 din.n0 0.000454822871098326f
CMODEL12675 a_1600_n11917.t1 din.t2 1.37616757703713e-05f
CMODEL12676 a_1600_n11917.t1 din.n1 0.000599538498753068f
CMODEL12677 a_1600_n11917.t1 din.t3 1.0132260410599e-05f
CMODEL12678 a_1600_n11917.t0 din 1.906348288385e-06f
CMODEL12679 a_1600_n11917.t0 din.t0 1.07320555391557e-05f
CMODEL12680 a_1600_n11917.t0 din.t1 1.11044614284395e-05f
CMODEL12681 a_1600_n11917.t0 din.n0 0.0006251341135797f
CMODEL12682 a_1600_n11917.t0 din.t2 1.89148205394941e-05f
CMODEL12683 a_1600_n11917.t0 din.n1 0.000824039404768364f
CMODEL12684 a_1600_n11917.t0 din.t3 1.39263481078751e-05f
CMODEL12685 a_1600_n11917.n3 din 0.000264253813001368f
CMODEL12686 a_1600_n11917.n3 din.t0 0.00148765396902729f
CMODEL12687 a_1600_n11917.n3 din.t1 0.00153927605551958f
CMODEL12688 a_1600_n11917.n3 din.n0 0.0866547179007952f
CMODEL12689 a_1600_n11917.n3 din.t2 0.00262193088233227f
CMODEL12690 a_1600_n11917.n3 din.n1 0.114226532528268f
CMODEL12691 a_1600_n11917.n3 din.t3 0.00193043978957698f
CMODEL12692 a_1600_n11917.n4 din 0.000387437716301334f
CMODEL12693 a_1600_n11917.n4 din.t0 0.00218113506049415f
CMODEL12694 a_1600_n11917.n4 din.t1 0.00225682117103355f
CMODEL12695 a_1600_n11917.n4 din.n0 0.127049466680909f
CMODEL12696 a_1600_n11917.n4 din.t2 0.00384416369176666f
CMODEL12697 a_1600_n11917.n4 din.n1 0.167474090160217f
CMODEL12698 a_1600_n11917.n4 din.t3 0.00283032882302084f
CMODEL12699 a_9600_n36000.t1 vdd 4.59075100984258e-06f
CMODEL12700 a_9600_n36000.t1 vdd.n0 0.00154057061203284f
CMODEL12701 a_9600_n36000.t1 vdd.n1 0.00014276584622401f
CMODEL12702 a_9600_n36000.t1 vdd.t7 1.17691026630929e-05f
CMODEL12703 a_9600_n36000.t1 vdd.t6 9.30286587135279e-05f
CMODEL12704 a_9600_n36000.t1 vdd.n2 0.000128023878986891f
CMODEL12705 a_9600_n36000.t1 vdd.t27 1.17691026630929e-05f
CMODEL12706 a_9600_n36000.t1 vdd.t26 9.30286587135279e-05f
CMODEL12707 a_9600_n36000.t1 vdd.n3 0.000240125355334495f
CMODEL12708 a_9600_n36000.t1 vdd.n4 0.000128023878986891f
CMODEL12709 a_9600_n36000.t1 vdd.t36 1.17691026630929e-05f
CMODEL12710 a_9600_n36000.t1 vdd.t35 9.30286587135279e-05f
CMODEL12711 a_9600_n36000.t1 vdd.n5 0.000182669952933273f
CMODEL12712 a_9600_n36000.t1 vdd.t3 1.87474702328216e-05f
CMODEL12713 a_9600_n36000.t1 vdd.n6 0.0001793668898536f
CMODEL12714 a_9600_n36000.t1 vdd.t2 0.000235072660603938f
CMODEL12715 a_9600_n36000.t1 vdd.n7 0.000240448762293993f
CMODEL12716 a_9600_n36000.t1 vdd.t25 1.87474702328216e-05f
CMODEL12717 a_9600_n36000.t1 vdd.n8 0.000108339175385444f
CMODEL12718 a_9600_n36000.t1 vdd.t24 0.000235072660603938f
CMODEL12719 a_9600_n36000.t1 vdd.n9 0.000240448762293993f
CMODEL12720 a_9600_n36000.t1 vdd.t5 1.87474702328216e-05f
CMODEL12721 a_9600_n36000.t1 vdd.n10 0.000320802455450874f
CMODEL12722 a_9600_n36000.t1 vdd.t4 0.000235202023387737f
CMODEL12723 a_9600_n36000.t1 vdd.n11 0.0007756463153817f
CMODEL12724 a_9600_n36000.t1 vdd.n12 0.00191245627475963f
CMODEL12725 a_9600_n36000.t1 vdd.n13 0.000144961779479001f
CMODEL12726 a_9600_n36000.t1 vdd.t42 1.17691026630929e-05f
CMODEL12727 a_9600_n36000.t1 vdd.t41 9.30286587135279e-05f
CMODEL12728 a_9600_n36000.t1 vdd.n14 0.000130331926654508f
CMODEL12729 a_9600_n36000.t1 vdd.t9 1.17691026630929e-05f
CMODEL12730 a_9600_n36000.t1 vdd.t8 9.30286587135279e-05f
CMODEL12731 a_9600_n36000.t1 vdd.n15 0.000250219964563627f
CMODEL12732 a_9600_n36000.t1 vdd.t15 1.98203189197964e-05f
CMODEL12733 a_9600_n36000.t1 vdd.n16 0.00015590263691882f
CMODEL12734 a_9600_n36000.t1 vdd.t14 0.000267363767486618f
CMODEL12735 a_9600_n36000.t1 vdd.n17 0.000218385939517038f
CMODEL12736 a_9600_n36000.t1 vdd.t32 0.000267363767486618f
CMODEL12737 a_9600_n36000.t1 vdd.n18 0.000215576611062198f
CMODEL12738 a_9600_n36000.t1 vdd.t34 1.98203189197964e-05f
CMODEL12739 a_9600_n36000.t1 vdd.n19 0.000217087999586252f
CMODEL12740 a_9600_n36000.t1 vdd.t33 0.000267363767486618f
CMODEL12741 a_9600_n36000.t1 vdd.n20 0.000433230572827572f
CMODEL12742 a_9600_n36000.t1 vdd.t48 0.000267874750482625f
CMODEL12743 a_9600_n36000.t1 vdd.n21 0.000769031565036767f
CMODEL12744 a_9600_n36000.t1 vdd.n22 0.00337018080400106f
CMODEL12745 a_9600_n36000.t1 vdd.t47 3.81024065379003e-06f
CMODEL12746 a_9600_n36000.t1 vdd.t45 3.77111919192275e-06f
CMODEL12747 a_9600_n36000.t1 vdd.n23 4.30618522618026e-05f
CMODEL12748 a_9600_n36000.t1 vdd.t46 0.000102769460728969f
CMODEL12749 a_9600_n36000.t1 vdd.n24 0.00011041652608862f
CMODEL12750 a_9600_n36000.t1 vdd.t44 0.000102769460728969f
CMODEL12751 a_9600_n36000.t1 vdd.n25 0.000174137399318517f
CMODEL12752 a_9600_n36000.t1 vdd.t43 0.000102992072519423f
CMODEL12753 a_9600_n36000.t1 vdd.n26 0.000931733294267433f
CMODEL12754 a_9600_n36000.t1 vdd.n27 0.000622882882016408f
CMODEL12755 a_9600_n36000.t1 vdd.n28 0.000140698197729619f
CMODEL12756 a_9600_n36000.t1 vdd.t29 1.17691026630929e-05f
CMODEL12757 a_9600_n36000.t1 vdd.t28 9.30286587135279e-05f
CMODEL12758 a_9600_n36000.t1 vdd.n29 2.10026947637212e-05f
CMODEL12759 a_9600_n36000.t1 vdd.n30 6.70032382641626e-06f
CMODEL12760 a_9600_n36000.t1 vdd.t38 3.08497898665173e-06f
CMODEL12761 a_9600_n36000.t1 vdd.t40 3.08497898665173e-06f
CMODEL12762 a_9600_n36000.t1 vdd.t37 6.23382006757233e-05f
CMODEL12763 a_9600_n36000.t1 vdd.t39 6.23382006757233e-05f
CMODEL12764 a_9600_n36000.t1 vdd.n31 2.01898652721828e-05f
CMODEL12765 a_9600_n36000.t1 vdd.n32 0.000243649413169826f
CMODEL12766 a_9600_n36000.t1 vdd.n33 0.000123457372718779f
CMODEL12767 a_9600_n36000.t1 vdd.t17 1.17691026630929e-05f
CMODEL12768 a_9600_n36000.t1 vdd.t16 9.30286587135279e-05f
CMODEL12769 a_9600_n36000.t1 vdd.n34 2.10026947637212e-05f
CMODEL12770 a_9600_n36000.t1 vdd.n35 6.70032382641626e-06f
CMODEL12771 a_9600_n36000.t1 vdd.t1 3.08497898665173e-06f
CMODEL12772 a_9600_n36000.t1 vdd.t31 3.08497898665173e-06f
CMODEL12773 a_9600_n36000.t1 vdd.t0 6.23382006757233e-05f
CMODEL12774 a_9600_n36000.t1 vdd.t30 6.23382006757233e-05f
CMODEL12775 a_9600_n36000.t1 vdd.n36 2.01898652721828e-05f
CMODEL12776 a_9600_n36000.t1 vdd.n37 0.000236291904841245f
CMODEL12777 a_9600_n36000.t1 vdd.n38 0.000136304175173239f
CMODEL12778 a_9600_n36000.t1 vdd.t19 1.17691026630929e-05f
CMODEL12779 a_9600_n36000.t1 vdd.t18 9.30286587135279e-05f
CMODEL12780 a_9600_n36000.t1 vdd.n39 0.000115021841191872f
CMODEL12781 a_9600_n36000.t1 vdd.t21 1.17692104654127e-05f
CMODEL12782 a_9600_n36000.t1 vdd.t20 9.30286587135279e-05f
CMODEL12783 a_9600_n36000.t1 vdd.n40 0.000115021841191872f
CMODEL12784 a_9600_n36000.t1 vdd.t11 1.17691026630929e-05f
CMODEL12785 a_9600_n36000.t1 vdd.t10 9.30286587135279e-05f
CMODEL12786 a_9600_n36000.t1 vdd.n41 0.000494844988727939f
CMODEL12787 a_9600_n36000.t1 vdd.n42 0.00094787453561598f
CMODEL12788 a_9600_n36000.t1 vdd.n43 0.000115021841191872f
CMODEL12789 a_9600_n36000.t1 vdd.t13 1.17691026630929e-05f
CMODEL12790 a_9600_n36000.t1 vdd.t12 9.30286587135279e-05f
CMODEL12791 a_9600_n36000.t1 vdd.n44 0.000115021841191872f
CMODEL12792 a_9600_n36000.t1 vdd.t23 1.17691026630929e-05f
CMODEL12793 a_9600_n36000.t1 vdd.t22 9.30286587135279e-05f
CMODEL12794 a_9600_n36000.t1 vdd.n45 0.000141989669521214f
CMODEL12795 a_9600_n36000.t1 vdd.n46 0.0023436871145543f
CMODEL12796 a_9600_n36000.t2 vdd 6.00729006981427e-06f
CMODEL12797 a_9600_n36000.t2 vdd.n0 0.00201593476092922f
CMODEL12798 a_9600_n36000.t2 vdd.n1 0.000186818202183336f
CMODEL12799 a_9600_n36000.t2 vdd.t7 1.54006203793324e-05f
CMODEL12800 a_9600_n36000.t2 vdd.t6 0.000121733924688954f
CMODEL12801 a_9600_n36000.t2 vdd.n2 0.000167527399174591f
CMODEL12802 a_9600_n36000.t2 vdd.t27 1.54006203793324e-05f
CMODEL12803 a_9600_n36000.t2 vdd.t26 0.000121733924688954f
CMODEL12804 a_9600_n36000.t2 vdd.n3 0.000314219320437726f
CMODEL12805 a_9600_n36000.t2 vdd.n4 0.000167527399174591f
CMODEL12806 a_9600_n36000.t2 vdd.t36 1.54006203793324e-05f
CMODEL12807 a_9600_n36000.t2 vdd.t35 0.000121733924688954f
CMODEL12808 a_9600_n36000.t2 vdd.n5 0.000239035267205032f
CMODEL12809 a_9600_n36000.t2 vdd.t3 2.45322587790771e-05f
CMODEL12810 a_9600_n36000.t2 vdd.n6 0.000234712998801464f
CMODEL12811 a_9600_n36000.t2 vdd.t2 0.000307607547589317f
CMODEL12812 a_9600_n36000.t2 vdd.n7 0.000314642519041208f
CMODEL12813 a_9600_n36000.t2 vdd.t25 2.45322587790771e-05f
CMODEL12814 a_9600_n36000.t2 vdd.n8 0.000141768710842621f
CMODEL12815 a_9600_n36000.t2 vdd.t24 0.000307607547589317f
CMODEL12816 a_9600_n36000.t2 vdd.n9 0.000314642519041208f
CMODEL12817 a_9600_n36000.t2 vdd.t5 2.45322587790771e-05f
CMODEL12818 a_9600_n36000.t2 vdd.n10 0.000419790444062475f
CMODEL12819 a_9600_n36000.t2 vdd.t4 0.00030777682703071f
CMODEL12820 a_9600_n36000.t2 vdd.n11 0.00101498260264834f
CMODEL12821 a_9600_n36000.t2 vdd.n12 0.00250257083507377f
CMODEL12822 a_9600_n36000.t2 vdd.n13 0.000189691720700982f
CMODEL12823 a_9600_n36000.t2 vdd.t42 1.54006203793324e-05f
CMODEL12824 a_9600_n36000.t2 vdd.t41 0.000121733924688954f
CMODEL12825 a_9600_n36000.t2 vdd.n14 0.000170547626541444f
CMODEL12826 a_9600_n36000.t2 vdd.t9 1.54006203793324e-05f
CMODEL12827 a_9600_n36000.t2 vdd.t8 0.000121733924688954f
CMODEL12828 a_9600_n36000.t2 vdd.n15 0.000327428759514427f
CMODEL12829 a_9600_n36000.t2 vdd.t15 2.59361496130298e-05f
CMODEL12830 a_9600_n36000.t2 vdd.n16 0.000204008529456796f
CMODEL12831 a_9600_n36000.t2 vdd.t14 0.000349862517485035f
CMODEL12832 a_9600_n36000.t2 vdd.n17 0.00028577191031163f
CMODEL12833 a_9600_n36000.t2 vdd.t32 0.000349862517485035f
CMODEL12834 a_9600_n36000.t2 vdd.n18 0.000282095725109379f
CMODEL12835 a_9600_n36000.t2 vdd.t34 2.59361496130298e-05f
CMODEL12836 a_9600_n36000.t2 vdd.n19 0.000284073473249654f
CMODEL12837 a_9600_n36000.t2 vdd.t33 0.000349862517485035f
CMODEL12838 a_9600_n36000.t2 vdd.n20 0.000566909795915127f
CMODEL12839 a_9600_n36000.t2 vdd.t48 0.000350531171278538f
CMODEL12840 a_9600_n36000.t2 vdd.n21 0.00100632678054511f
CMODEL12841 a_9600_n36000.t2 vdd.n22 0.00441009622041089f
CMODEL12842 a_9600_n36000.t2 vdd.t47 4.98594256016956e-06f
CMODEL12843 a_9600_n36000.t2 vdd.t45 4.93474963576829e-06f
CMODEL12844 a_9600_n36000.t2 vdd.n23 5.63491761861e-05f
CMODEL12845 a_9600_n36000.t2 vdd.t46 0.000134480384493445f
CMODEL12846 a_9600_n36000.t2 vdd.n24 0.000144487056538991f
CMODEL12847 a_9600_n36000.t2 vdd.t44 0.000134480384493445f
CMODEL12848 a_9600_n36000.t2 vdd.n25 0.000227869877383152f
CMODEL12849 a_9600_n36000.t2 vdd.t43 0.000134771686198843f
CMODEL12850 a_9600_n36000.t2 vdd.n26 0.00121923235530912f
CMODEL12851 a_9600_n36000.t2 vdd.n27 0.000815081920969348f
CMODEL12852 a_9600_n36000.t2 vdd.n28 0.000184112552445071f
CMODEL12853 a_9600_n36000.t2 vdd.t29 1.54006203793324e-05f
CMODEL12854 a_9600_n36000.t2 vdd.t28 0.000121733924688954f
CMODEL12855 a_9600_n36000.t2 vdd.n29 2.74833637073619e-05f
CMODEL12856 a_9600_n36000.t2 vdd.n30 8.76780045371064e-06f
CMODEL12857 a_9600_n36000.t2 vdd.t38 4.03689147861977e-06f
CMODEL12858 a_9600_n36000.t2 vdd.t40 4.03689147861977e-06f
CMODEL12859 a_9600_n36000.t2 vdd.t37 8.15735057480722e-05f
CMODEL12860 a_9600_n36000.t2 vdd.t39 8.15735057480722e-05f
CMODEL12861 a_9600_n36000.t2 vdd.n31 2.64197245506092e-05f
CMODEL12862 a_9600_n36000.t2 vdd.n32 0.000318830774553673f
CMODEL12863 a_9600_n36000.t2 vdd.n33 0.000161551834893418f
CMODEL12864 a_9600_n36000.t2 vdd.t17 1.54006203793324e-05f
CMODEL12865 a_9600_n36000.t2 vdd.t16 0.000121733924688954f
CMODEL12866 a_9600_n36000.t2 vdd.n34 2.74833637073619e-05f
CMODEL12867 a_9600_n36000.t2 vdd.n35 8.76780045371064e-06f
CMODEL12868 a_9600_n36000.t2 vdd.t1 4.03689147861977e-06f
CMODEL12869 a_9600_n36000.t2 vdd.t31 4.03689147861977e-06f
CMODEL12870 a_9600_n36000.t2 vdd.t0 8.15735057480722e-05f
CMODEL12871 a_9600_n36000.t2 vdd.t30 8.15735057480722e-05f
CMODEL12872 a_9600_n36000.t2 vdd.n36 2.64197245506092e-05f
CMODEL12873 a_9600_n36000.t2 vdd.n37 0.000309203006324446f
CMODEL12874 a_9600_n36000.t2 vdd.n38 0.000178362694085755f
CMODEL12875 a_9600_n36000.t2 vdd.t19 1.54006203793324e-05f
CMODEL12876 a_9600_n36000.t2 vdd.t18 0.000121733924688954f
CMODEL12877 a_9600_n36000.t2 vdd.n39 0.000150513404652582f
CMODEL12878 a_9600_n36000.t2 vdd.t21 1.54007614455336e-05f
CMODEL12879 a_9600_n36000.t2 vdd.t20 0.000121733924688954f
CMODEL12880 a_9600_n36000.t2 vdd.n40 0.000150513404652582f
CMODEL12881 a_9600_n36000.t2 vdd.t11 1.54006203793324e-05f
CMODEL12882 a_9600_n36000.t2 vdd.t10 0.000121733924688954f
CMODEL12883 a_9600_n36000.t2 vdd.n41 0.000647536183188606f
CMODEL12884 a_9600_n36000.t2 vdd.n42 0.00124035419760893f
CMODEL12885 a_9600_n36000.t2 vdd.n43 0.000150513404652582f
CMODEL12886 a_9600_n36000.t2 vdd.t13 1.54006203793324e-05f
CMODEL12887 a_9600_n36000.t2 vdd.t12 0.000121733924688954f
CMODEL12888 a_9600_n36000.t2 vdd.n44 0.000150513404652582f
CMODEL12889 a_9600_n36000.t2 vdd.t23 1.54006203793324e-05f
CMODEL12890 a_9600_n36000.t2 vdd.t22 0.000121733924688954f
CMODEL12891 a_9600_n36000.t2 vdd.n45 0.000185802525534978f
CMODEL12892 a_9600_n36000.t2 vdd.n46 0.00306686385295737f
CMODEL12893 a_9600_n36000.t0 vdd 1.85491028010698e-06f
CMODEL12894 a_9600_n36000.t0 vdd.n0 0.000622473372954377f
CMODEL12895 a_9600_n36000.t0 vdd.n1 5.76850792476694e-05f
CMODEL12896 a_9600_n36000.t0 vdd.t7 4.75535037090892e-06f
CMODEL12897 a_9600_n36000.t0 vdd.t6 3.75885808274764e-05f
CMODEL12898 a_9600_n36000.t0 vdd.n2 5.17285317201508e-05f
CMODEL12899 a_9600_n36000.t0 vdd.t27 4.75535037090892e-06f
CMODEL12900 a_9600_n36000.t0 vdd.t26 3.75885808274764e-05f
CMODEL12901 a_9600_n36000.t0 vdd.n3 9.70235565312375e-05f
CMODEL12902 a_9600_n36000.t0 vdd.n4 5.17285317201508e-05f
CMODEL12903 a_9600_n36000.t0 vdd.t36 4.75535037090892e-06f
CMODEL12904 a_9600_n36000.t0 vdd.t35 3.75885808274764e-05f
CMODEL12905 a_9600_n36000.t0 vdd.n5 7.38084842406223e-05f
CMODEL12906 a_9600_n36000.t0 vdd.t3 7.57498613762824e-06f
CMODEL12907 a_9600_n36000.t0 vdd.n6 7.24738691309831e-05f
CMODEL12908 a_9600_n36000.t0 vdd.t2 9.49819961464858e-05f
CMODEL12909 a_9600_n36000.t0 vdd.n7 9.71542303344006e-05f
CMODEL12910 a_9600_n36000.t0 vdd.t25 7.57498613762824e-06f
CMODEL12911 a_9600_n36000.t0 vdd.n8 4.37748529009558e-05f
CMODEL12912 a_9600_n36000.t0 vdd.t24 9.49819961464858e-05f
CMODEL12913 a_9600_n36000.t0 vdd.n9 9.71542303344006e-05f
CMODEL12914 a_9600_n36000.t0 vdd.t5 7.57498613762824e-06f
CMODEL12915 a_9600_n36000.t0 vdd.n10 0.000129621443468308f
CMODEL12916 a_9600_n36000.t0 vdd.t4 9.5034265667751e-05f
CMODEL12917 a_9600_n36000.t0 vdd.n11 0.000313402822554289f
CMODEL12918 a_9600_n36000.t0 vdd.n12 0.000772735179211643f
CMODEL12919 a_9600_n36000.t0 vdd.n13 5.8572354371147e-05f
CMODEL12920 a_9600_n36000.t0 vdd.t42 4.75535037090892e-06f
CMODEL12921 a_9600_n36000.t0 vdd.t41 3.75885808274764e-05f
CMODEL12922 a_9600_n36000.t0 vdd.n14 5.26611070953915e-05f
CMODEL12923 a_9600_n36000.t0 vdd.t9 4.75535037090892e-06f
CMODEL12924 a_9600_n36000.t0 vdd.t8 3.75885808274764e-05f
CMODEL12925 a_9600_n36000.t0 vdd.n15 0.000101102321507302f
CMODEL12926 a_9600_n36000.t0 vdd.t15 8.00847470065468e-06f
CMODEL12927 a_9600_n36000.t0 vdd.n16 6.29930491321552e-05f
CMODEL12928 a_9600_n36000.t0 vdd.t14 0.000108029339812979f
CMODEL12929 a_9600_n36000.t0 vdd.n17 8.82396634826129e-05f
CMODEL12930 a_9600_n36000.t0 vdd.t32 0.000108029339812979f
CMODEL12931 a_9600_n36000.t0 vdd.n18 8.71045437124693e-05f
CMODEL12932 a_9600_n36000.t0 vdd.t34 8.00847470065468e-06f
CMODEL12933 a_9600_n36000.t0 vdd.n19 8.77152259525849e-05f
CMODEL12934 a_9600_n36000.t0 vdd.t33 0.000108029339812979f
CMODEL12935 a_9600_n36000.t0 vdd.n20 0.00017504844882059f
CMODEL12936 a_9600_n36000.t0 vdd.t48 0.000108235804421977f
CMODEL12937 a_9600_n36000.t0 vdd.n21 0.000310730107700259f
CMODEL12938 a_9600_n36000.t0 vdd.n22 0.00136173427958907f
CMODEL12939 a_9600_n36000.t0 vdd.t47 1.53954212355312e-06f
CMODEL12940 a_9600_n36000.t0 vdd.t45 1.52373494916382e-06f
CMODEL12941 a_9600_n36000.t0 vdd.n23 1.73993040070376e-05f
CMODEL12942 a_9600_n36000.t0 vdd.t46 4.15243886628807e-05f
CMODEL12943 a_9600_n36000.t0 vdd.n24 4.46142142966069e-05f
CMODEL12944 a_9600_n36000.t0 vdd.t44 4.15243886628807e-05f
CMODEL12945 a_9600_n36000.t0 vdd.n25 7.03608737338355e-05f
CMODEL12946 a_9600_n36000.t0 vdd.t43 4.16143357973913e-05f
CMODEL12947 a_9600_n36000.t0 vdd.n26 0.000376470355754247f
CMODEL12948 a_9600_n36000.t0 vdd.n27 0.000251678180471504f
CMODEL12949 a_9600_n36000.t0 vdd.n28 5.68496380661133e-05f
CMODEL12950 a_9600_n36000.t0 vdd.t29 4.75535037090892e-06f
CMODEL12951 a_9600_n36000.t0 vdd.t28 3.75885808274764e-05f
CMODEL12952 a_9600_n36000.t0 vdd.n29 8.48621812501902e-06f
CMODEL12953 a_9600_n36000.t0 vdd.n30 2.70729114234654e-06f
CMODEL12954 a_9600_n36000.t0 vdd.t38 1.24649740837296e-06f
CMODEL12955 a_9600_n36000.t0 vdd.t40 1.24649740837296e-06f
CMODEL12956 a_9600_n36000.t0 vdd.t37 2.51879853707719e-05f
CMODEL12957 a_9600_n36000.t0 vdd.t39 2.51879853707719e-05f
CMODEL12958 a_9600_n36000.t0 vdd.n31 8.15779129973573e-06f
CMODEL12959 a_9600_n36000.t0 vdd.n32 9.84474654063716e-05f
CMODEL12960 a_9600_n36000.t0 vdd.n33 4.98834176194876e-05f
CMODEL12961 a_9600_n36000.t0 vdd.t17 4.75535037090892e-06f
CMODEL12962 a_9600_n36000.t0 vdd.t16 3.75885808274764e-05f
CMODEL12963 a_9600_n36000.t0 vdd.n34 8.48621812501902e-06f
CMODEL12964 a_9600_n36000.t0 vdd.n35 2.70729114234654e-06f
CMODEL12965 a_9600_n36000.t0 vdd.t1 1.24649740837296e-06f
CMODEL12966 a_9600_n36000.t0 vdd.t31 1.24649740837296e-06f
CMODEL12967 a_9600_n36000.t0 vdd.t0 2.51879853707719e-05f
CMODEL12968 a_9600_n36000.t0 vdd.t30 2.51879853707719e-05f
CMODEL12969 a_9600_n36000.t0 vdd.n36 8.15779129973573e-06f
CMODEL12970 a_9600_n36000.t0 vdd.n37 9.54746363844107e-05f
CMODEL12971 a_9600_n36000.t0 vdd.n38 5.50742166604704e-05f
CMODEL12972 a_9600_n36000.t0 vdd.t19 4.75535037090892e-06f
CMODEL12973 a_9600_n36000.t0 vdd.t18 3.75885808274764e-05f
CMODEL12974 a_9600_n36000.t0 vdd.n39 4.64750092536497e-05f
CMODEL12975 a_9600_n36000.t0 vdd.t21 4.75539392884331e-06f
CMODEL12976 a_9600_n36000.t0 vdd.t20 3.75885808274764e-05f
CMODEL12977 a_9600_n36000.t0 vdd.n40 4.64750092536497e-05f
CMODEL12978 a_9600_n36000.t0 vdd.t11 4.75535037090892e-06f
CMODEL12979 a_9600_n36000.t0 vdd.t10 3.75885808274764e-05f
CMODEL12980 a_9600_n36000.t0 vdd.n41 0.000199943986219883f
CMODEL12981 a_9600_n36000.t0 vdd.n42 0.000382992285270118f
CMODEL12982 a_9600_n36000.t0 vdd.n43 4.64750092536497e-05f
CMODEL12983 a_9600_n36000.t0 vdd.t13 4.75535037090892e-06f
CMODEL12984 a_9600_n36000.t0 vdd.t12 3.75885808274764e-05f
CMODEL12985 a_9600_n36000.t0 vdd.n44 4.64750092536497e-05f
CMODEL12986 a_9600_n36000.t0 vdd.t23 4.75535037090892e-06f
CMODEL12987 a_9600_n36000.t0 vdd.t22 3.75885808274764e-05f
CMODEL12988 a_9600_n36000.t0 vdd.n45 5.7371462120078e-05f
CMODEL12989 a_9600_n36000.t0 vdd.n46 0.000946975628349341f
CMODEL12990 a_9600_n36000.n0 vdd 9.52236819487924e-05f
CMODEL12991 a_9600_n36000.n0 vdd.n0 0.031955295694615f
CMODEL12992 a_9600_n36000.n0 vdd.n1 0.00296132147111404f
CMODEL12993 a_9600_n36000.n0 vdd.t7 0.000244120686661129f
CMODEL12994 a_9600_n36000.n0 vdd.t6 0.00192964754360823f
CMODEL12995 a_9600_n36000.n0 vdd.n2 0.00265553612216412f
CMODEL12996 a_9600_n36000.n0 vdd.t27 0.000244120686661129f
CMODEL12997 a_9600_n36000.n0 vdd.t26 0.00192964754360823f
CMODEL12998 a_9600_n36000.n0 vdd.n3 0.0049808017065593f
CMODEL12999 a_9600_n36000.n0 vdd.n4 0.00265553612216412f
CMODEL13000 a_9600_n36000.n0 vdd.t36 0.000244120686661129f
CMODEL13001 a_9600_n36000.n0 vdd.t35 0.00192964754360823f
CMODEL13002 a_9600_n36000.n0 vdd.n5 0.00378903265771223f
CMODEL13003 a_9600_n36000.n0 vdd.t3 0.000388869520252172f
CMODEL13004 a_9600_n36000.n0 vdd.n6 0.00372051885082502f
CMODEL13005 a_9600_n36000.n0 vdd.t2 0.00487599615405267f
CMODEL13006 a_9600_n36000.n0 vdd.n7 0.00498750997746862f
CMODEL13007 a_9600_n36000.n0 vdd.t25 0.000388869520252172f
CMODEL13008 a_9600_n36000.n0 vdd.n8 0.00224722603281674f
CMODEL13009 a_9600_n36000.n0 vdd.t24 0.00487599615405267f
CMODEL13010 a_9600_n36000.n0 vdd.n9 0.00498750997746862f
CMODEL13011 a_9600_n36000.n0 vdd.t5 0.000388869520252172f
CMODEL13012 a_9600_n36000.n0 vdd.n10 0.00665424696759872f
CMODEL13013 a_9600_n36000.n0 vdd.t4 0.00487867946241639f
CMODEL13014 a_9600_n36000.n0 vdd.n11 0.016088848618081f
CMODEL13015 a_9600_n36000.n0 vdd.n12 0.0396691364132441f
CMODEL13016 a_9600_n36000.n0 vdd.n13 0.00300687063058834f
CMODEL13017 a_9600_n36000.n0 vdd.t42 0.000244120686661129f
CMODEL13018 a_9600_n36000.n0 vdd.t41 0.00192964754360823f
CMODEL13019 a_9600_n36000.n0 vdd.n14 0.00270341081555365f
CMODEL13020 a_9600_n36000.n0 vdd.t9 0.000244120686661129f
CMODEL13021 a_9600_n36000.n0 vdd.t8 0.00192964754360823f
CMODEL13022 a_9600_n36000.n0 vdd.n15 0.00519018920254227f
CMODEL13023 a_9600_n36000.n0 vdd.t15 0.000411123090948695f
CMODEL13024 a_9600_n36000.n0 vdd.n16 0.00323381143545069f
CMODEL13025 a_9600_n36000.n0 vdd.t14 0.00554579464344541f
CMODEL13026 a_9600_n36000.n0 vdd.n17 0.00452987173603469f
CMODEL13027 a_9600_n36000.n0 vdd.t32 0.00554579464344541f
CMODEL13028 a_9600_n36000.n0 vdd.n18 0.00447159922273572f
CMODEL13029 a_9600_n36000.n0 vdd.t34 0.000411123090948695f
CMODEL13030 a_9600_n36000.n0 vdd.n19 0.00450294920878528f
CMODEL13031 a_9600_n36000.n0 vdd.t33 0.00554579464344541f
CMODEL13032 a_9600_n36000.n0 vdd.n20 0.00898628790561231f
CMODEL13033 a_9600_n36000.n0 vdd.t48 0.00555639371148214f
CMODEL13034 a_9600_n36000.n0 vdd.n21 0.0159516421170823f
CMODEL13035 a_9600_n36000.n0 vdd.n22 0.0699059967099211f
CMODEL13036 a_9600_n36000.n0 vdd.t47 7.90339409362353e-05f
CMODEL13037 a_9600_n36000.n0 vdd.t45 7.82224637652376e-05f
CMODEL13038 a_9600_n36000.n0 vdd.n23 0.000893210743756802f
CMODEL13039 a_9600_n36000.n0 vdd.t46 0.0021316961912164f
CMODEL13040 a_9600_n36000.n0 vdd.n24 0.00229031549295761f
CMODEL13041 a_9600_n36000.n0 vdd.t44 0.0021316961912164f
CMODEL13042 a_9600_n36000.n0 vdd.n25 0.00361204611022129f
CMODEL13043 a_9600_n36000.n0 vdd.t43 0.00213631371769231f
CMODEL13044 a_9600_n36000.n0 vdd.n26 0.01932648376795f
CMODEL13045 a_9600_n36000.n0 vdd.n27 0.0129201521322568f
CMODEL13046 a_9600_n36000.n0 vdd.n28 0.00291843325910044f
CMODEL13047 a_9600_n36000.n0 vdd.t29 0.000244120686661129f
CMODEL13048 a_9600_n36000.n0 vdd.t28 0.00192964754360823f
CMODEL13049 a_9600_n36000.n0 vdd.n29 0.000435648529393175f
CMODEL13050 a_9600_n36000.n0 vdd.n30 0.000138981509481268f
CMODEL13051 a_9600_n36000.n0 vdd.t38 6.39901962040205e-05f
CMODEL13052 a_9600_n36000.n0 vdd.t40 6.39901962040205e-05f
CMODEL13053 a_9600_n36000.n0 vdd.t37 0.00129305052303602f
CMODEL13054 a_9600_n36000.n0 vdd.t39 0.00129305052303602f
CMODEL13055 a_9600_n36000.n0 vdd.n31 0.000418788408507747f
CMODEL13056 a_9600_n36000.n0 vdd.n32 0.00505389949856788f
CMODEL13057 a_9600_n36000.n0 vdd.n33 0.0025608153369245f
CMODEL13058 a_9600_n36000.n0 vdd.t17 0.000244120686661129f
CMODEL13059 a_9600_n36000.n0 vdd.t16 0.00192964754360823f
CMODEL13060 a_9600_n36000.n0 vdd.n34 0.000435648529393175f
CMODEL13061 a_9600_n36000.n0 vdd.n35 0.000138981509481268f
CMODEL13062 a_9600_n36000.n0 vdd.t1 6.39901962040205e-05f
CMODEL13063 a_9600_n36000.n0 vdd.t31 6.39901962040205e-05f
CMODEL13064 a_9600_n36000.n0 vdd.t0 0.00129305052303602f
CMODEL13065 a_9600_n36000.n0 vdd.t30 0.00129305052303602f
CMODEL13066 a_9600_n36000.n0 vdd.n36 0.000418788408507747f
CMODEL13067 a_9600_n36000.n0 vdd.n37 0.00490128633538081f
CMODEL13068 a_9600_n36000.n0 vdd.n38 0.00282729021834579f
CMODEL13069 a_9600_n36000.n0 vdd.t19 0.000244120686661129f
CMODEL13070 a_9600_n36000.n0 vdd.t18 0.00192964754360823f
CMODEL13071 a_9600_n36000.n0 vdd.n39 0.00238584127070636f
CMODEL13072 a_9600_n36000.n0 vdd.t21 0.000244122922751432f
CMODEL13073 a_9600_n36000.n0 vdd.t20 0.00192964754360823f
CMODEL13074 a_9600_n36000.n0 vdd.n40 0.00238584127070636f
CMODEL13075 a_9600_n36000.n0 vdd.t11 0.000244120686661129f
CMODEL13076 a_9600_n36000.n0 vdd.t10 0.00192964754360823f
CMODEL13077 a_9600_n36000.n0 vdd.n41 0.0102643253183533f
CMODEL13078 a_9600_n36000.n0 vdd.n42 0.0196612935690343f
CMODEL13079 a_9600_n36000.n0 vdd.n43 0.00238584127070636f
CMODEL13080 a_9600_n36000.n0 vdd.t13 0.000244120686661129f
CMODEL13081 a_9600_n36000.n0 vdd.t12 0.00192964754360823f
CMODEL13082 a_9600_n36000.n0 vdd.n44 0.00238584127070636f
CMODEL13083 a_9600_n36000.n0 vdd.t23 0.000244120686661129f
CMODEL13084 a_9600_n36000.n0 vdd.t22 0.00192964754360823f
CMODEL13085 a_9600_n36000.n0 vdd.n45 0.00294522162093167f
CMODEL13086 a_9600_n36000.n0 vdd.n46 0.0486139448437337f
CMODEL13087 a_9600_n36000.t3 vdd 1.98489601416714e-06f
CMODEL13088 a_9600_n36000.t3 vdd.n0 0.000666094166468826f
CMODEL13089 a_9600_n36000.t3 vdd.n1 6.17274512430924e-05f
CMODEL13090 a_9600_n36000.t3 vdd.t7 5.08858897296152e-06f
CMODEL13091 a_9600_n36000.t3 vdd.t6 4.0222659318247e-05f
CMODEL13092 a_9600_n36000.t3 vdd.n2 5.53534893472712e-05f
CMODEL13093 a_9600_n36000.t3 vdd.t27 5.08858897296152e-06f
CMODEL13094 a_9600_n36000.t3 vdd.t26 4.0222659318247e-05f
CMODEL13095 a_9600_n36000.t3 vdd.n3 0.000103822633743809f
CMODEL13096 a_9600_n36000.t3 vdd.n4 5.53534893472712e-05f
CMODEL13097 a_9600_n36000.t3 vdd.t36 5.08858897296152e-06f
CMODEL13098 a_9600_n36000.t3 vdd.t35 4.0222659318247e-05f
CMODEL13099 a_9600_n36000.t3 vdd.n5 7.89807290153569e-05f
CMODEL13100 a_9600_n36000.t3 vdd.t3 8.10581511849858e-06f
CMODEL13101 a_9600_n36000.t3 vdd.n6 7.75525886680958e-05f
CMODEL13102 a_9600_n36000.t3 vdd.t2 0.000101638007827486f
CMODEL13103 a_9600_n36000.t3 vdd.n7 0.000103962464717758f
CMODEL13104 a_9600_n36000.t3 vdd.t25 8.10581511849858e-06f
CMODEL13105 a_9600_n36000.t3 vdd.n8 4.68424440662697e-05f
CMODEL13106 a_9600_n36000.t3 vdd.t24 0.000101638007827486f
CMODEL13107 a_9600_n36000.t3 vdd.n9 0.000103962464717758f
CMODEL13108 a_9600_n36000.t3 vdd.t5 8.10581511849858e-06f
CMODEL13109 a_9600_n36000.t3 vdd.n10 0.000138704868505013f
CMODEL13110 a_9600_n36000.t3 vdd.t4 0.000101693940217066f
CMODEL13111 a_9600_n36000.t3 vdd.n11 0.000335365014679233f
CMODEL13112 a_9600_n36000.t3 vdd.n12 0.000826885803412259f
CMODEL13113 a_9600_n36000.t3 vdd.n13 6.2676903556203e-05f
CMODEL13114 a_9600_n36000.t3 vdd.t42 5.08858897296152e-06f
CMODEL13115 a_9600_n36000.t3 vdd.t41 4.0222659318247e-05f
CMODEL13116 a_9600_n36000.t3 vdd.n14 5.63514163980173e-05f
CMODEL13117 a_9600_n36000.t3 vdd.t9 5.08858897296152e-06f
CMODEL13118 a_9600_n36000.t3 vdd.t8 4.0222659318247e-05f
CMODEL13119 a_9600_n36000.t3 vdd.n15 0.00010818722454399f
CMODEL13120 a_9600_n36000.t3 vdd.t15 8.56968106941056e-06f
CMODEL13121 a_9600_n36000.t3 vdd.n16 6.74073854048823e-05f
CMODEL13122 a_9600_n36000.t3 vdd.t14 0.000115599664473002f
CMODEL13123 a_9600_n36000.t3 vdd.n17 9.44231956749878e-05f
CMODEL13124 a_9600_n36000.t3 vdd.t32 0.000115599664473002f
CMODEL13125 a_9600_n36000.t3 vdd.n18 9.32085306146214e-05f
CMODEL13126 a_9600_n36000.t3 vdd.t34 8.56968106941056e-06f
CMODEL13127 a_9600_n36000.t3 vdd.n19 9.38620073662076e-05f
CMODEL13128 a_9600_n36000.t3 vdd.t33 0.000115599664473002f
CMODEL13129 a_9600_n36000.t3 vdd.n20 0.000187315242185239f
CMODEL13130 a_9600_n36000.t3 vdd.t48 0.000115820597411841f
CMODEL13131 a_9600_n36000.t3 vdd.n21 0.000332505005158739f
CMODEL13132 a_9600_n36000.t3 vdd.n22 0.00145715993538793f
CMODEL13133 a_9600_n36000.t3 vdd.t47 1.64742794163972e-06f
CMODEL13134 a_9600_n36000.t3 vdd.t45 1.63051305482441e-06f
CMODEL13135 a_9600_n36000.t3 vdd.n23 1.86185874018981e-05f
CMODEL13136 a_9600_n36000.t3 vdd.t46 4.44342750329279e-05f
CMODEL13137 a_9600_n36000.t3 vdd.n24 4.77406250222659e-05f
CMODEL13138 a_9600_n36000.t3 vdd.t44 4.44342750329279e-05f
CMODEL13139 a_9600_n36000.t3 vdd.n25 7.52915218193478e-05f
CMODEL13140 a_9600_n36000.t3 vdd.t43 4.45305253533291e-05f
CMODEL13141 a_9600_n36000.t3 vdd.n26 0.000402852103739266f
CMODEL13142 a_9600_n36000.t3 vdd.n27 0.000269314921928145f
CMODEL13143 a_9600_n36000.t3 vdd.n28 6.08334652163147e-05f
CMODEL13144 a_9600_n36000.t3 vdd.t29 5.08858897296152e-06f
CMODEL13145 a_9600_n36000.t3 vdd.t28 4.0222659318247e-05f
CMODEL13146 a_9600_n36000.t3 vdd.n29 9.08090311016644e-06f
CMODEL13147 a_9600_n36000.t3 vdd.n30 2.89700879620103e-06f
CMODEL13148 a_9600_n36000.t3 vdd.t38 1.33384766049517e-06f
CMODEL13149 a_9600_n36000.t3 vdd.t40 1.33384766049517e-06f
CMODEL13150 a_9600_n36000.t3 vdd.t37 2.69530727731272e-05f
CMODEL13151 a_9600_n36000.t3 vdd.t39 2.69530727731272e-05f
CMODEL13152 a_9600_n36000.t3 vdd.n31 8.72946126230909e-06f
CMODEL13153 a_9600_n36000.t3 vdd.n32 0.000105346325256602f
CMODEL13154 a_9600_n36000.t3 vdd.n33 5.33790759951177e-05f
CMODEL13155 a_9600_n36000.t3 vdd.t17 5.08858897296152e-06f
CMODEL13156 a_9600_n36000.t3 vdd.t16 4.0222659318247e-05f
CMODEL13157 a_9600_n36000.t3 vdd.n34 9.08090311016644e-06f
CMODEL13158 a_9600_n36000.t3 vdd.n35 2.89700879620103e-06f
CMODEL13159 a_9600_n36000.t3 vdd.t1 1.33384766049517e-06f
CMODEL13160 a_9600_n36000.t3 vdd.t31 1.33384766049517e-06f
CMODEL13161 a_9600_n36000.t3 vdd.t0 2.69530727731272e-05f
CMODEL13162 a_9600_n36000.t3 vdd.t30 2.69530727731272e-05f
CMODEL13163 a_9600_n36000.t3 vdd.n36 8.72946126230909e-06f
CMODEL13164 a_9600_n36000.t3 vdd.n37 0.000102165170599272f
CMODEL13165 a_9600_n36000.t3 vdd.n38 5.89336283836005e-05f
CMODEL13166 a_9600_n36000.t3 vdd.t19 5.08858897296152e-06f
CMODEL13167 a_9600_n36000.t3 vdd.t18 4.0222659318247e-05f
CMODEL13168 a_9600_n36000.t3 vdd.n39 4.97318180912932e-05f
CMODEL13169 a_9600_n36000.t3 vdd.t21 5.08863558328617e-06f
CMODEL13170 a_9600_n36000.t3 vdd.t20 4.0222659318247e-05f
CMODEL13171 a_9600_n36000.t3 vdd.n40 4.97318180912932e-05f
CMODEL13172 a_9600_n36000.t3 vdd.t11 5.08858897296152e-06f
CMODEL13173 a_9600_n36000.t3 vdd.t10 4.0222659318247e-05f
CMODEL13174 a_9600_n36000.t3 vdd.n41 0.000213955373238669f
CMODEL13175 a_9600_n36000.t3 vdd.n42 0.000409831067649038f
CMODEL13176 a_9600_n36000.t3 vdd.n43 4.97318180912932e-05f
CMODEL13177 a_9600_n36000.t3 vdd.t13 5.08858897296152e-06f
CMODEL13178 a_9600_n36000.t3 vdd.t12 4.0222659318247e-05f
CMODEL13179 a_9600_n36000.t3 vdd.n44 4.97318180912932e-05f
CMODEL13180 a_9600_n36000.t3 vdd.t23 5.08858897296152e-06f
CMODEL13181 a_9600_n36000.t3 vdd.t22 4.0222659318247e-05f
CMODEL13182 a_9600_n36000.t3 vdd.n45 6.13918569056159e-05f
CMODEL13183 a_9600_n36000.t3 vdd.n46 0.00101333642407525f
CMODEL13184 a_9600_n36000.n1 vdd 4.76271130385966e-05f
CMODEL13185 a_9600_n36000.n1 vdd.n0 0.0159827728678633f
CMODEL13186 a_9600_n36000.n1 vdd.n1 0.00148113567509621f
CMODEL13187 a_9600_n36000.n1 vdd.t7 0.00012209949563725f
CMODEL13188 a_9600_n36000.n1 vdd.t6 0.000965133250502765f
CMODEL13189 a_9600_n36000.n1 vdd.n2 0.00132819395847769f
CMODEL13190 a_9600_n36000.n1 vdd.t27 0.00012209949563725f
CMODEL13191 a_9600_n36000.n1 vdd.t26 0.000965133250502765f
CMODEL13192 a_9600_n36000.n1 vdd.n3 0.0024911996789696f
CMODEL13193 a_9600_n36000.n1 vdd.n4 0.00132819395847769f
CMODEL13194 a_9600_n36000.n1 vdd.t36 0.00012209949563725f
CMODEL13195 a_9600_n36000.n1 vdd.t35 0.000965133250502765f
CMODEL13196 a_9600_n36000.n1 vdd.n5 0.00189512401749849f
CMODEL13197 a_9600_n36000.n1 vdd.t3 0.000194497127387646f
CMODEL13198 a_9600_n36000.n1 vdd.n6 0.00186085612574572f
CMODEL13199 a_9600_n36000.n1 vdd.t2 0.00243878009390261f
CMODEL13200 a_9600_n36000.n1 vdd.n7 0.00249455489030309f
CMODEL13201 a_9600_n36000.n1 vdd.t25 0.000194497127387646f
CMODEL13202 a_9600_n36000.n1 vdd.n8 0.00112397342864557f
CMODEL13203 a_9600_n36000.n1 vdd.t24 0.00243878009390261f
CMODEL13204 a_9600_n36000.n1 vdd.n9 0.00249455489030309f
CMODEL13205 a_9600_n36000.n1 vdd.t5 0.000194497127387646f
CMODEL13206 a_9600_n36000.n1 vdd.n10 0.00332819069822349f
CMODEL13207 a_9600_n36000.n1 vdd.t4 0.00244012217843601f
CMODEL13208 a_9600_n36000.n1 vdd.n11 0.00804700465380324f
CMODEL13209 a_9600_n36000.n1 vdd.n12 0.0198409303802503f
CMODEL13210 a_9600_n36000.n1 vdd.n13 0.00150391756005065f
CMODEL13211 a_9600_n36000.n1 vdd.t42 0.00012209949563725f
CMODEL13212 a_9600_n36000.n1 vdd.t41 0.000965133250502765f
CMODEL13213 a_9600_n36000.n1 vdd.n14 0.00135213898336107f
CMODEL13214 a_9600_n36000.n1 vdd.t9 0.00012209949563725f
CMODEL13215 a_9600_n36000.n1 vdd.t8 0.000965133250502765f
CMODEL13216 a_9600_n36000.n1 vdd.n15 0.00259592700872578f
CMODEL13217 a_9600_n36000.n1 vdd.t15 0.00020562748178463f
CMODEL13218 a_9600_n36000.n1 vdd.n16 0.00161742435946282f
CMODEL13219 a_9600_n36000.n1 vdd.t14 0.0027737867615144f
CMODEL13220 a_9600_n36000.n1 vdd.n17 0.002265662373132f
CMODEL13221 a_9600_n36000.n1 vdd.t32 0.0027737867615144f
CMODEL13222 a_9600_n36000.n1 vdd.n18 0.0022365167706817f
CMODEL13223 a_9600_n36000.n1 vdd.t34 0.00020562748178463f
CMODEL13224 a_9600_n36000.n1 vdd.n19 0.00225219679164691f
CMODEL13225 a_9600_n36000.n1 vdd.t33 0.0027737867615144f
CMODEL13226 a_9600_n36000.n1 vdd.n20 0.00449458518216222f
CMODEL13227 a_9600_n36000.n1 vdd.t48 0.00277908799542132f
CMODEL13228 a_9600_n36000.n1 vdd.n21 0.00797837939799547f
CMODEL13229 a_9600_n36000.n1 vdd.n22 0.0349642099448497f
CMODEL13230 a_9600_n36000.n1 vdd.t47 3.95296460063376e-05f
CMODEL13231 a_9600_n36000.n1 vdd.t45 3.91237772753624e-05f
CMODEL13232 a_9600_n36000.n1 vdd.n23 0.000446748625862536f
CMODEL13233 a_9600_n36000.n1 vdd.t46 0.00106618997906011f
CMODEL13234 a_9600_n36000.n1 vdd.n24 0.00114552506944439f
CMODEL13235 a_9600_n36000.n1 vdd.t44 0.00106618997906011f
CMODEL13236 a_9600_n36000.n1 vdd.n25 0.00180660235848309f
CMODEL13237 a_9600_n36000.n1 vdd.t43 0.00106849948286133f
CMODEL13238 a_9600_n36000.n1 vdd.n26 0.00966634148372615f
CMODEL13239 a_9600_n36000.n1 vdd.n27 0.00646214821235089f
CMODEL13240 a_9600_n36000.n1 vdd.n28 0.00145968469063739f
CMODEL13241 a_9600_n36000.n1 vdd.t29 0.00012209949563725f
CMODEL13242 a_9600_n36000.n1 vdd.t28 0.000965133250502765f
CMODEL13243 a_9600_n36000.n1 vdd.n29 0.000217894134419891f
CMODEL13244 a_9600_n36000.n1 vdd.n30 6.95130447266126e-05f
CMODEL13245 a_9600_n36000.n1 vdd.t38 3.20053609102175e-05f
CMODEL13246 a_9600_n36000.n1 vdd.t40 3.20053609102175e-05f
CMODEL13247 a_9600_n36000.n1 vdd.t37 0.000646732642184226f
CMODEL13248 a_9600_n36000.n1 vdd.t39 0.000646732642184226f
CMODEL13249 a_9600_n36000.n1 vdd.n31 0.000209461369935038f
CMODEL13250 a_9600_n36000.n1 vdd.n32 0.00252776029846692f
CMODEL13251 a_9600_n36000.n1 vdd.n33 0.00128081837444873f
CMODEL13252 a_9600_n36000.n1 vdd.t17 0.00012209949563725f
CMODEL13253 a_9600_n36000.n1 vdd.t16 0.000965133250502765f
CMODEL13254 a_9600_n36000.n1 vdd.n34 0.000217894134419891f
CMODEL13255 a_9600_n36000.n1 vdd.n35 6.95130447266126e-05f
CMODEL13256 a_9600_n36000.n1 vdd.t1 3.20053609102175e-05f
CMODEL13257 a_9600_n36000.n1 vdd.t31 3.20053609102175e-05f
CMODEL13258 a_9600_n36000.n1 vdd.t0 0.000646732642184226f
CMODEL13259 a_9600_n36000.n1 vdd.t30 0.000646732642184226f
CMODEL13260 a_9600_n36000.n1 vdd.n36 0.000209461369935038f
CMODEL13261 a_9600_n36000.n1 vdd.n37 0.00245142924062989f
CMODEL13262 a_9600_n36000.n1 vdd.n38 0.00141409855265296f
CMODEL13263 a_9600_n36000.n1 vdd.t19 0.00012209949563725f
CMODEL13264 a_9600_n36000.n1 vdd.t18 0.000965133250502765f
CMODEL13265 a_9600_n36000.n1 vdd.n39 0.00119330327883338f
CMODEL13266 a_9600_n36000.n1 vdd.t21 0.000122100614041027f
CMODEL13267 a_9600_n36000.n1 vdd.t20 0.000965133250502765f
CMODEL13268 a_9600_n36000.n1 vdd.n40 0.00119330327883338f
CMODEL13269 a_9600_n36000.n1 vdd.t11 0.00012209949563725f
CMODEL13270 a_9600_n36000.n1 vdd.t10 0.000965133250502765f
CMODEL13271 a_9600_n36000.n1 vdd.n41 0.00513380886138209f
CMODEL13272 a_9600_n36000.n1 vdd.n42 0.00983380008138093f
CMODEL13273 a_9600_n36000.n1 vdd.n43 0.00119330327883338f
CMODEL13274 a_9600_n36000.n1 vdd.t13 0.00012209949563725f
CMODEL13275 a_9600_n36000.n1 vdd.t12 0.000965133250502765f
CMODEL13276 a_9600_n36000.n1 vdd.n44 0.00119330327883338f
CMODEL13277 a_9600_n36000.n1 vdd.t23 0.00012209949563725f
CMODEL13278 a_9600_n36000.n1 vdd.t22 0.000965133250502765f
CMODEL13279 a_9600_n36000.n1 vdd.n45 0.00147308316789582f
CMODEL13280 a_9600_n36000.n1 vdd.n46 0.0243147691723337f
CMODEL13281 a_16000_n24000.t0 din 9.43190845331264e-05f
CMODEL13282 a_16000_n24000.t0 din.t0 0.000530982538594437f
CMODEL13283 a_16000_n24000.t0 din.t1 0.000549407808922009f
CMODEL13284 a_16000_n24000.t0 din.n0 0.0309293310474842f
CMODEL13285 a_16000_n24000.t0 din.t2 0.000935835580656055f
CMODEL13286 a_16000_n24000.t0 din.n1 0.0407704314843845f
CMODEL13287 a_16000_n24000.t0 din.t3 0.00068902435742064f
CMODEL13288 a_16000_n24000.t1 din 9.43005195804911e-05f
CMODEL13289 a_16000_n24000.t1 din.t0 0.000530878024585126f
CMODEL13290 a_16000_n24000.t1 din.t1 0.000549299668241885f
CMODEL13291 a_16000_n24000.t1 din.n0 0.0309232431855337f
CMODEL13292 a_16000_n24000.t1 din.t2 0.000935651378876371f
CMODEL13293 a_16000_n24000.t1 din.n1 0.0407624065853604f
CMODEL13294 a_16000_n24000.t1 din.t3 0.000688888735826948f
CMODEL13295 a_20800_n23917.t0 din 1.07221521511038e-05f
CMODEL13296 a_20800_n23917.t0 din.t0 6.03618620406491e-05f
CMODEL13297 a_20800_n23917.t0 din.t1 6.24564386881573e-05f
CMODEL13298 a_20800_n23917.t0 din.n0 0.00351603278450514f
CMODEL13299 a_20800_n23917.t0 din.t2 0.00010638537824958f
CMODEL13300 a_20800_n23917.t0 din.n1 0.0046347647647936f
CMODEL13301 a_20800_n23917.t0 din.t3 7.83279866704591e-05f
CMODEL13302 a_20800_n23917.t1 din 1.0718097363634e-05f
CMODEL13303 a_20800_n23917.t1 din.t0 6.0339035044874e-05f
CMODEL13304 a_20800_n23917.t1 din.t1 6.24328195880524e-05f
CMODEL13305 a_20800_n23917.t1 din.n0 0.00351470312927577f
CMODEL13306 a_20800_n23917.t1 din.t2 0.000106345146578493f
CMODEL13307 a_20800_n23917.t1 din.n1 0.00463301203961039f
CMODEL13308 a_20800_n23917.t1 din.t3 7.82983654400936e-05f
CMODEL13309 a_3200_n23917.t1 we 3.26590101140509e-05f
CMODEL13310 a_3200_n23917.t1 we.t1 0.000186723062509929f
CMODEL13311 a_3200_n23917.t1 we.t3 0.00019023918118801f
CMODEL13312 a_3200_n23917.t1 we.n0 0.00650029204960994f
CMODEL13313 a_3200_n23917.t1 we.t0 0.000230577788826057f
CMODEL13314 a_3200_n23917.t1 we.n1 0.0177513789056357f
CMODEL13315 a_3200_n23917.t1 we.t2 0.000346982128987947f
CMODEL13316 a_3200_n23917.n0 we 4.66334703276192e-05f
CMODEL13317 a_3200_n23917.n0 we.t1 0.000266619973006858f
CMODEL13318 a_3200_n23917.n0 we.t3 0.000271640603315924f
CMODEL13319 a_3200_n23917.n0 we.n0 0.00928170129338756f
CMODEL13320 a_3200_n23917.n0 we.t0 0.000329239693299885f
CMODEL13321 a_3200_n23917.n0 we.n1 0.025347014455718f
CMODEL13322 a_3200_n23917.n0 we.t2 0.000495452273656389f
CMODEL13323 a_3200_n23917.t0 we 7.41439444449282e-06f
CMODEL13324 a_3200_n23917.t0 we.t1 4.2390704203759e-05f
CMODEL13325 a_3200_n23917.t0 we.t3 4.31889491812369e-05f
CMODEL13326 a_3200_n23917.t0 we.n0 0.00147572535394983f
CMODEL13327 a_3200_n23917.t0 we.t0 5.23468001793426e-05f
CMODEL13328 a_3200_n23917.t0 we.n1 0.00402999737837759f
CMODEL13329 a_3200_n23917.t0 we.t2 7.87734337483696e-05f
CMODEL13330 a_3200_n23917.t3 we 2.15698474335203e-05f
CMODEL13331 a_3200_n23917.t3 we.t1 0.000123322414139125f
CMODEL13332 a_3200_n23917.t3 we.t3 0.000125644656704943f
CMODEL13333 a_3200_n23917.t3 we.n0 0.00429315852788473f
CMODEL13334 a_3200_n23917.t3 we.t0 0.000152286542340631f
CMODEL13335 a_3200_n23917.t3 we.n1 0.0117240091904819f
CMODEL13336 a_3200_n23917.t3 we.t2 0.000229166516630217f
CMODEL13337 a_3200_n23917.n1 we 0.0011021684724067f
CMODEL13338 a_3200_n23917.n1 we.t1 0.00630148531296505f
CMODEL13339 a_3200_n23917.n1 we.t3 0.00642014644625377f
CMODEL13340 a_3200_n23917.n1 we.n0 0.219370303432241f
CMODEL13341 a_3200_n23917.n1 we.t0 0.00778148414155369f
CMODEL13342 a_3200_n23917.n1 we.n1 0.599069295217846f
CMODEL13343 a_3200_n23917.n1 we.t2 0.011709870009028f
CMODEL13344 a_3200_n23917.t2 we 2.76217967047554e-05f
CMODEL13345 a_3200_n23917.t2 we.t1 0.000157923539468198f
CMODEL13346 a_3200_n23917.t2 we.t3 0.000160897344092912f
CMODEL13347 a_3200_n23917.t2 we.n0 0.00549770935765796f
CMODEL13348 a_3200_n23917.t2 we.t0 0.000195014263608842f
CMODEL13349 a_3200_n23917.t2 we.n1 0.015013467268244f
CMODEL13350 a_3200_n23917.t2 we.t2 0.000293464798645714f
CMODEL13351 din vdd 2.03987641135245e-07f
CMODEL13352 din vdd.n0 6.84544564662932e-05f
CMODEL13353 din vdd.n1 6.34372636273983e-06f
CMODEL13354 din vdd.t7 5.22953975368221e-07f
CMODEL13355 din vdd.t6 4.13368022100573e-06f
CMODEL13356 din vdd.n2 5.68867469124959e-06f
CMODEL13357 din vdd.t27 5.22953975368221e-07f
CMODEL13358 din vdd.t26 4.13368022100573e-06f
CMODEL13359 din vdd.n3 1.06698456758878e-05f
CMODEL13360 din vdd.n4 5.68867469124959e-06f
CMODEL13361 din vdd.t36 5.22953975368221e-07f
CMODEL13362 din vdd.t35 4.13368022100573e-06f
CMODEL13363 din vdd.n5 8.11684465684461e-06f
CMODEL13364 din vdd.t3 8.33034120527839e-07f
CMODEL13365 din vdd.n6 7.97007476130924e-06f
CMODEL13366 din vdd.t2 1.04453318050085e-05f
CMODEL13367 din vdd.n7 1.06842160964689e-05f
CMODEL13368 din vdd.t25 8.33034120527839e-07f
CMODEL13369 din vdd.n8 4.81399509187761e-06f
CMODEL13370 din vdd.t24 1.04453318050085e-05f
CMODEL13371 din vdd.n9 1.06842160964689e-05f
CMODEL13372 din vdd.t5 8.33034120527839e-07f
CMODEL13373 din vdd.n10 1.42546907940587e-05f
CMODEL13374 din vdd.t4 1.04510799732409e-05f
CMODEL13375 din vdd.n11 3.446544190498e-05f
CMODEL13376 din vdd.n12 8.49790030925447e-05f
CMODEL13377 din vdd.n13 6.44130151848577e-06f
CMODEL13378 din vdd.t42 5.22953975368221e-07f
CMODEL13379 din vdd.t41 4.13368022100573e-06f
CMODEL13380 din vdd.n14 5.79123159279699e-06f
CMODEL13381 din vdd.t9 5.22953975368221e-07f
CMODEL13382 din vdd.t8 4.13368022100573e-06f
CMODEL13383 din vdd.n15 1.11183944036271e-05f
CMODEL13384 din vdd.t15 8.80705595735671e-07f
CMODEL13385 din vdd.n16 6.92745284674569e-06f
CMODEL13386 din vdd.t14 1.18801703986332e-05f
CMODEL13387 din vdd.n17 9.70386600442364e-06f
CMODEL13388 din vdd.t32 1.18801703986332e-05f
CMODEL13389 din vdd.n18 9.57903495097548e-06f
CMODEL13390 din vdd.t34 8.80705595735671e-07f
CMODEL13391 din vdd.n19 9.64619271649133e-06f
CMODEL13392 din vdd.t33 1.18801703986332e-05f
CMODEL13393 din vdd.n20 1.92503759034838e-05f
CMODEL13394 din vdd.t48 1.19028756631514e-05f
CMODEL13395 din vdd.n21 3.41715189026937e-05f
CMODEL13396 din vdd.n22 0.00014975223681997f
CMODEL13397 din vdd.t47 1.69306068104725e-07f
CMODEL13398 din vdd.t45 1.67567726228427e-07f
CMODEL13399 din vdd.n23 1.91343108065901e-06f
CMODEL13400 din vdd.t46 4.56650770862924e-06f
CMODEL13401 din vdd.n24 4.90630109341046e-06f
CMODEL13402 din vdd.t44 4.56650770862924e-06f
CMODEL13403 din vdd.n25 7.73770506051223e-06f
CMODEL13404 din vdd.t43 4.57639934812926e-06f
CMODEL13405 din vdd.n26 4.14010858914569e-05f
CMODEL13406 din vdd.n27 2.76774779406752e-05f
CMODEL13407 din vdd.n28 6.25185147382442e-06f
CMODEL13408 din vdd.t29 5.22953975368221e-07f
CMODEL13409 din vdd.t28 4.13368022100573e-06f
CMODEL13410 din vdd.n29 9.33243853380314e-07f
CMODEL13411 din vdd.n30 2.97725415571994e-07f
CMODEL13412 din vdd.t38 1.37079441923483e-07f
CMODEL13413 din vdd.t40 1.37079441923483e-07f
CMODEL13414 din vdd.t37 2.76996562897721e-06f
CMODEL13415 din vdd.t39 2.76996562897721e-06f
CMODEL13416 din vdd.n31 8.97126196319718e-07f
CMODEL13417 din vdd.n32 1.08264353588203e-05f
CMODEL13418 din vdd.n33 5.48576435264391e-06f
CMODEL13419 din vdd.t17 5.22953975368221e-07f
CMODEL13420 din vdd.t16 4.13368022100573e-06f
CMODEL13421 din vdd.n34 9.33243853380314e-07f
CMODEL13422 din vdd.n35 2.97725415571994e-07f
CMODEL13423 din vdd.t1 1.37079441923483e-07f
CMODEL13424 din vdd.t31 1.37079441923483e-07f
CMODEL13425 din vdd.t0 2.76996562897721e-06f
CMODEL13426 din vdd.t30 2.76996562897721e-06f
CMODEL13427 din vdd.n36 8.97126196319718e-07f
CMODEL13428 din vdd.n37 1.04995082905994e-05f
CMODEL13429 din vdd.n38 6.05660535952868e-06f
CMODEL13430 din vdd.t19 5.22953975368221e-07f
CMODEL13431 din vdd.t18 4.13368022100573e-06f
CMODEL13432 din vdd.n39 5.11093588248588e-06f
CMODEL13433 din vdd.t21 5.22958765508415e-07f
CMODEL13434 din vdd.t20 4.13368022100573e-06f
CMODEL13435 din vdd.n40 5.11093588248588e-06f
CMODEL13436 din vdd.t11 5.22953975368221e-07f
CMODEL13437 din vdd.t10 4.13368022100573e-06f
CMODEL13438 din vdd.n41 2.19881805312004e-05f
CMODEL13439 din vdd.n42 4.21183135826615e-05f
CMODEL13440 din vdd.n43 5.11093588248588e-06f
CMODEL13441 din vdd.t13 5.22953975368221e-07f
CMODEL13442 din vdd.t12 4.13368022100573e-06f
CMODEL13443 din vdd.n44 5.11093588248588e-06f
CMODEL13444 din vdd.t23 5.22953975368221e-07f
CMODEL13445 din vdd.t22 4.13368022100573e-06f
CMODEL13446 din vdd.n45 6.3092373533451e-06f
CMODEL13447 din vdd.n46 0.000104140521895435f
CMODEL13448 din.t0 vdd 1.14837708686456e-06f
CMODEL13449 din.t0 vdd.n0 0.000385373980806702f
CMODEL13450 din.t0 vdd.n1 3.57128988784132e-05f
CMODEL13451 din.t0 vdd.t7 2.94404288149706e-06f
CMODEL13452 din.t0 vdd.t6 2.32711336030445e-05f
CMODEL13453 din.t0 vdd.n2 3.20251934563334e-05f
CMODEL13454 din.t0 vdd.t27 2.94404288149706e-06f
CMODEL13455 din.t0 vdd.t26 2.32711336030445e-05f
CMODEL13456 din.t0 vdd.n3 6.0067395389148e-05f
CMODEL13457 din.t0 vdd.n4 3.20251934563334e-05f
CMODEL13458 din.t0 vdd.t36 2.94404288149706e-06f
CMODEL13459 din.t0 vdd.t35 2.32711336030445e-05f
CMODEL13460 din.t0 vdd.n5 4.5694917445412e-05f
CMODEL13461 din.t0 vdd.t3 4.68968262619538e-06f
CMODEL13462 din.t0 vdd.n6 4.4868655696728e-05f
CMODEL13463 din.t0 vdd.t2 5.88034630079203e-05f
CMODEL13464 din.t0 vdd.n7 6.01482956909121e-05f
CMODEL13465 din.t0 vdd.t25 4.68968262619538e-06f
CMODEL13466 din.t0 vdd.n8 2.71010617556257e-05f
CMODEL13467 din.t0 vdd.t24 5.88034630079203e-05f
CMODEL13468 din.t0 vdd.n9 6.01482956909121e-05f
CMODEL13469 din.t0 vdd.t5 4.68968262619538e-06f
CMODEL13470 din.t0 vdd.n10 8.02487846672183e-05f
CMODEL13471 din.t0 vdd.t4 5.8835823128626e-05f
CMODEL13472 din.t0 vdd.n11 0.000194028047738927f
CMODEL13473 din.t0 vdd.n12 0.000478401237805231f
CMODEL13474 din.t0 vdd.n13 3.62622119273914e-05f
CMODEL13475 din.t0 vdd.t42 2.94404288149706e-06f
CMODEL13476 din.t0 vdd.t41 2.32711336030445e-05f
CMODEL13477 din.t0 vdd.n14 3.26025519432564e-05f
CMODEL13478 din.t0 vdd.t9 2.94404288149706e-06f
CMODEL13479 din.t0 vdd.t8 2.32711336030445e-05f
CMODEL13480 din.t0 vdd.n15 6.25925634748778e-05f
CMODEL13481 din.t0 vdd.t15 4.95805589391413e-06f
CMODEL13482 din.t0 vdd.n16 3.89990691360706e-05f
CMODEL13483 din.t0 vdd.t14 6.68810884713923e-05f
CMODEL13484 din.t0 vdd.n17 5.46292771045657e-05f
CMODEL13485 din.t0 vdd.t32 6.68810884713923e-05f
CMODEL13486 din.t0 vdd.n18 5.39265231499083e-05f
CMODEL13487 din.t0 vdd.t34 4.95805589391413e-06f
CMODEL13488 din.t0 vdd.n19 5.43045972268192e-05f
CMODEL13489 din.t0 vdd.t33 6.68810884713923e-05f
CMODEL13490 din.t0 vdd.n20 0.000108372695904815f
CMODEL13491 din.t0 vdd.t48 6.70089109481796e-05f
CMODEL13492 din.t0 vdd.n21 0.000192373366900179f
CMODEL13493 din.t0 vdd.n22 0.000843051257976699f
CMODEL13494 din.t0 vdd.t47 9.53132298587099e-07f
CMODEL13495 din.t0 vdd.t45 9.43346058750369e-07f
CMODEL13496 din.t0 vdd.n23 1.07719291134233e-05f
CMODEL13497 din.t0 vdd.t46 2.57077967586445e-05f
CMODEL13498 din.t0 vdd.n24 2.76207113606237e-05f
CMODEL13499 din.t0 vdd.t44 2.57077967586445e-05f
CMODEL13500 din.t0 vdd.n25 4.35604978172027e-05f
CMODEL13501 din.t0 vdd.t43 2.57634831330254e-05f
CMODEL13502 din.t0 vdd.n26 0.000233073230047003f
CMODEL13503 din.t0 vdd.n27 0.000155814250865313f
CMODEL13504 din.t0 vdd.n28 3.51956762824681e-05f
CMODEL13505 din.t0 vdd.t29 2.94404288149706e-06f
CMODEL13506 din.t0 vdd.t28 2.32711336030445e-05f
CMODEL13507 din.t0 vdd.n29 5.25382739716365e-06f
CMODEL13508 din.t0 vdd.n30 1.676087058595e-06f
CMODEL13509 din.t0 vdd.t38 7.71707978527672e-07f
CMODEL13510 din.t0 vdd.t40 7.71707978527672e-07f
CMODEL13511 din.t0 vdd.t37 1.55939106997703e-05f
CMODEL13512 din.t0 vdd.t39 1.55939106997703e-05f
CMODEL13513 din.t0 vdd.n31 5.05049797206323e-06f
CMODEL13514 din.t0 vdd.n32 6.0948939010704e-05f
CMODEL13515 din.t0 vdd.n33 3.08828811954244e-05f
CMODEL13516 din.t0 vdd.t17 2.94404288149706e-06f
CMODEL13517 din.t0 vdd.t16 2.32711336030445e-05f
CMODEL13518 din.t0 vdd.n34 5.25382739716365e-06f
CMODEL13519 din.t0 vdd.n35 1.676087058595e-06f
CMODEL13520 din.t0 vdd.t1 7.71707978527672e-07f
CMODEL13521 din.t0 vdd.t31 7.71707978527672e-07f
CMODEL13522 din.t0 vdd.t0 1.55939106997703e-05f
CMODEL13523 din.t0 vdd.t30 1.55939106997703e-05f
CMODEL13524 din.t0 vdd.n36 5.05049797206323e-06f
CMODEL13525 din.t0 vdd.n37 5.91084571455709e-05f
CMODEL13526 din.t0 vdd.n38 3.40965108491667e-05f
CMODEL13527 din.t0 vdd.t19 2.94404288149706e-06f
CMODEL13528 din.t0 vdd.t18 2.32711336030445e-05f
CMODEL13529 din.t0 vdd.n39 2.87727316577443e-05f
CMODEL13530 din.t0 vdd.t21 2.94406984826432e-06f
CMODEL13531 din.t0 vdd.t20 2.32711336030445e-05f
CMODEL13532 din.t0 vdd.n40 2.87727316577443e-05f
CMODEL13533 din.t0 vdd.t11 2.94404288149706e-06f
CMODEL13534 din.t0 vdd.t10 2.32711336030445e-05f
CMODEL13535 din.t0 vdd.n41 0.000123785551729237f
CMODEL13536 din.t0 vdd.n42 0.000237110964108049f
CMODEL13537 din.t0 vdd.n43 2.87727316577443e-05f
CMODEL13538 din.t0 vdd.t13 2.94404288149706e-06f
CMODEL13539 din.t0 vdd.t12 2.32711336030445e-05f
CMODEL13540 din.t0 vdd.n44 2.87727316577443e-05f
CMODEL13541 din.t0 vdd.t23 2.94404288149706e-06f
CMODEL13542 din.t0 vdd.t22 2.32711336030445e-05f
CMODEL13543 din.t0 vdd.n45 3.55187381541794e-05f
CMODEL13544 din.t0 vdd.n46 0.000586273700177471f
CMODEL13545 din.t1 vdd 1.18822615293645e-06f
CMODEL13546 din.t1 vdd.n0 0.000398746585850122f
CMODEL13547 din.t1 vdd.n1 3.69521483229578e-05f
CMODEL13548 din.t1 vdd.t7 3.0462021466419e-06f
CMODEL13549 din.t1 vdd.t6 2.40786496629891e-05f
CMODEL13550 din.t1 vdd.n2 3.31364782987459e-05f
CMODEL13551 din.t1 vdd.t27 3.0462021466419e-06f
CMODEL13552 din.t1 vdd.t26 2.40786496629891e-05f
CMODEL13553 din.t1 vdd.n3 6.21517539461128e-05f
CMODEL13554 din.t1 vdd.n4 3.31364782987459e-05f
CMODEL13555 din.t1 vdd.t36 3.0462021466419e-06f
CMODEL13556 din.t1 vdd.t35 2.40786496629891e-05f
CMODEL13557 din.t1 vdd.n5 4.72805462473618e-05f
CMODEL13558 din.t1 vdd.t3 4.85241616987631e-06f
CMODEL13559 din.t1 vdd.n6 4.64256129417542e-05f
CMODEL13560 din.t1 vdd.t2 6.08439626917449e-05f
CMODEL13561 din.t1 vdd.n7 6.22354615151997e-05f
CMODEL13562 din.t1 vdd.t25 4.85241616987631e-06f
CMODEL13563 din.t1 vdd.n8 2.80414775936557e-05f
CMODEL13564 din.t1 vdd.t24 6.08439626917449e-05f
CMODEL13565 din.t1 vdd.n9 6.22354615151997e-05f
CMODEL13566 din.t1 vdd.t5 4.85241616987631e-06f
CMODEL13567 din.t1 vdd.n10 8.30334441305344e-05f
CMODEL13568 din.t1 vdd.t4 6.08774457193796e-05f
CMODEL13569 din.t1 vdd.n11 0.000200760885395292f
CMODEL13570 din.t1 vdd.n12 0.000495001919543165f
CMODEL13571 din.t1 vdd.n13 3.75205227170579e-05f
CMODEL13572 din.t1 vdd.t42 3.0462021466419e-06f
CMODEL13573 din.t1 vdd.t41 2.40786496629891e-05f
CMODEL13574 din.t1 vdd.n14 3.37338713167962e-05f
CMODEL13575 din.t1 vdd.t9 3.0462021466419e-06f
CMODEL13576 din.t1 vdd.t8 2.40786496629891e-05f
CMODEL13577 din.t1 vdd.n15 6.47645462025456e-05f
CMODEL13578 din.t1 vdd.t15 5.13010207906063e-06f
CMODEL13579 din.t1 vdd.n16 4.03523497792682e-05f
CMODEL13580 din.t1 vdd.t14 6.9201884439843e-05f
CMODEL13581 din.t1 vdd.n17 5.65249311520904e-05f
CMODEL13582 din.t1 vdd.t32 6.9201884439843e-05f
CMODEL13583 din.t1 vdd.n18 5.57977914019554e-05f
CMODEL13584 din.t1 vdd.t34 5.13010207906063e-06f
CMODEL13585 din.t1 vdd.n19 5.61889847748216e-05f
CMODEL13586 din.t1 vdd.t33 6.9201884439843e-05f
CMODEL13587 din.t1 vdd.n20 0.000112133264422679f
CMODEL13588 din.t1 vdd.t48 6.93341423990003e-05f
CMODEL13589 din.t1 vdd.n21 0.000199048786582234f
CMODEL13590 din.t1 vdd.n22 0.000872305416445523f
CMODEL13591 din.t1 vdd.t47 9.86206305702087e-07f
CMODEL13592 din.t1 vdd.t45 9.76080480094874e-07f
CMODEL13593 din.t1 vdd.n23 1.11457186289687e-05f
CMODEL13594 din.t1 vdd.t46 2.65998658388409e-05f
CMODEL13595 din.t1 vdd.n24 2.8579159212424e-05f
CMODEL13596 din.t1 vdd.t44 2.65998658388409e-05f
CMODEL13597 din.t1 vdd.n25 4.50720615496187e-05f
CMODEL13598 din.t1 vdd.t43 2.66574845488957e-05f
CMODEL13599 din.t1 vdd.n26 0.00024116094848894f
CMODEL13600 din.t1 vdd.n27 0.000161221057086627f
CMODEL13601 din.t1 vdd.n28 3.64169779312621e-05f
CMODEL13602 din.t1 vdd.t29 3.0462021466419e-06f
CMODEL13603 din.t1 vdd.t28 2.40786496629891e-05f
CMODEL13604 din.t1 vdd.n29 5.43613695164239e-06f
CMODEL13605 din.t1 vdd.n30 1.73424783583809e-06f
CMODEL13606 din.t1 vdd.t38 7.98486501520076e-07f
CMODEL13607 din.t1 vdd.t40 7.98486501520076e-07f
CMODEL13608 din.t1 vdd.t37 1.61350245768252e-05f
CMODEL13609 din.t1 vdd.t39 1.61350245768252e-05f
CMODEL13610 din.t1 vdd.n31 5.22575192800395e-06f
CMODEL13611 din.t1 vdd.n32 6.30638874239298e-05f
CMODEL13612 din.t1 vdd.n33 3.19545274232387e-05f
CMODEL13613 din.t1 vdd.t17 3.0462021466419e-06f
CMODEL13614 din.t1 vdd.t16 2.40786496629891e-05f
CMODEL13615 din.t1 vdd.n34 5.43613695164239e-06f
CMODEL13616 din.t1 vdd.n35 1.73424783583809e-06f
CMODEL13617 din.t1 vdd.t1 7.98486501520076e-07f
CMODEL13618 din.t1 vdd.t31 7.98486501520076e-07f
CMODEL13619 din.t1 vdd.t0 1.61350245768252e-05f
CMODEL13620 din.t1 vdd.t30 1.61350245768252e-05f
CMODEL13621 din.t1 vdd.n36 5.22575192800395e-06f
CMODEL13622 din.t1 vdd.n37 6.11595402272025e-05f
CMODEL13623 din.t1 vdd.n38 3.52796710926012e-05f
CMODEL13624 din.t1 vdd.t19 3.0462021466419e-06f
CMODEL13625 din.t1 vdd.t18 2.40786496629891e-05f
CMODEL13626 din.t1 vdd.n39 2.97711549962217e-05f
CMODEL13627 din.t1 vdd.t21 3.04623004916493e-06f
CMODEL13628 din.t1 vdd.t20 2.40786496629891e-05f
CMODEL13629 din.t1 vdd.n40 2.97711549962217e-05f
CMODEL13630 din.t1 vdd.t11 3.0462021466419e-06f
CMODEL13631 din.t1 vdd.t10 2.40786496629891e-05f
CMODEL13632 din.t1 vdd.n41 0.000128080951459888f
CMODEL13633 din.t1 vdd.n42 0.000245338793262068f
CMODEL13634 din.t1 vdd.n43 2.97711549962217e-05f
CMODEL13635 din.t1 vdd.t13 3.0462021466419e-06f
CMODEL13636 din.t1 vdd.t12 2.40786496629891e-05f
CMODEL13637 din.t1 vdd.n44 2.97711549962217e-05f
CMODEL13638 din.t1 vdd.t23 3.0462021466419e-06f
CMODEL13639 din.t1 vdd.t22 2.40786496629891e-05f
CMODEL13640 din.t1 vdd.n45 3.67512501571492e-05f
CMODEL13641 din.t1 vdd.n46 0.000606617592163657f
CMODEL13642 din.n0 vdd 6.68920962655392e-05f
CMODEL13643 din.n0 vdd.n0 0.0224477427468878f
CMODEL13644 din.n0 vdd.n1 0.00208024933362158f
CMODEL13645 din.n0 vdd.t7 0.000171488269917217f
CMODEL13646 din.n0 vdd.t6 0.00135552592174514f
CMODEL13647 din.n0 vdd.n2 0.00186544328348849f
CMODEL13648 din.n0 vdd.t27 0.000171488269917217f
CMODEL13649 din.n0 vdd.t26 0.00135552592174514f
CMODEL13650 din.n0 vdd.n3 0.0034988803248954f
CMODEL13651 din.n0 vdd.n4 0.00186544328348849f
CMODEL13652 din.n0 vdd.t36 0.000171488269917217f
CMODEL13653 din.n0 vdd.t35 0.00135552592174514f
CMODEL13654 din.n0 vdd.n5 0.00266169436117012f
CMODEL13655 din.n0 vdd.t3 0.000273170464017876f
CMODEL13656 din.n0 vdd.n6 0.00261356523959003f
CMODEL13657 din.n0 vdd.t2 0.00342525722018068f
CMODEL13658 din.n0 vdd.n7 0.00350359270625115f
CMODEL13659 din.n0 vdd.t25 0.000273170464017876f
CMODEL13660 din.n0 vdd.n8 0.00157861633830164f
CMODEL13661 din.n0 vdd.t24 0.00342525722018068f
CMODEL13662 din.n0 vdd.n9 0.00350359270625115f
CMODEL13663 din.n0 vdd.t5 0.000273170464017876f
CMODEL13664 din.n0 vdd.n10 0.00467443097790161f
CMODEL13665 din.n0 vdd.t4 0.00342714217272298f
CMODEL13666 din.n0 vdd.n11 0.0113019869483844f
CMODEL13667 din.n0 vdd.n12 0.0278665100678685f
CMODEL13668 din.n0 vdd.n13 0.00211224640302714f
CMODEL13669 din.n0 vdd.t42 0.000171488269917217f
CMODEL13670 din.n0 vdd.t41 0.00135552592174514f
CMODEL13671 din.n0 vdd.n14 0.00189907397843072f
CMODEL13672 din.n0 vdd.t9 0.000171488269917217f
CMODEL13673 din.n0 vdd.t8 0.00135552592174514f
CMODEL13674 din.n0 vdd.n15 0.00364596945494631f
CMODEL13675 din.n0 vdd.t15 0.000288803003768695f
CMODEL13676 din.n0 vdd.n16 0.00227166626429228f
CMODEL13677 din.n0 vdd.t14 0.00389577279061479f
CMODEL13678 din.n0 vdd.n17 0.00318211405016166f
CMODEL13679 din.n0 vdd.t32 0.00389577279061479f
CMODEL13680 din.n0 vdd.n18 0.00314117916411802f
CMODEL13681 din.n0 vdd.t34 0.000288803003768695f
CMODEL13682 din.n0 vdd.n19 0.00316320169298724f
CMODEL13683 din.n0 vdd.t33 0.00389577279061479f
CMODEL13684 din.n0 vdd.n20 0.00631262752447783f
CMODEL13685 din.n0 vdd.t48 0.00390321835315688f
CMODEL13686 din.n0 vdd.n21 0.0112056030417214f
CMODEL13687 din.n0 vdd.n22 0.0491070977907908f
CMODEL13688 din.n0 vdd.t47 5.55192351015643e-05f
CMODEL13689 din.n0 vdd.t45 5.49491940368966e-05f
CMODEL13690 din.n0 vdd.n23 0.000627456719106119f
CMODEL13691 din.n0 vdd.t46 0.00149745970659286f
CMODEL13692 din.n0 vdd.n24 0.00160888553454343f
CMODEL13693 din.n0 vdd.t44 0.00149745970659286f
CMODEL13694 din.n0 vdd.n25 0.0025373660330675f
CMODEL13695 din.n0 vdd.t43 0.0015007033957594f
CMODEL13696 din.n0 vdd.n26 0.0135763392700495f
CMODEL13697 din.n0 vdd.n27 0.00907606219911866f
CMODEL13698 din.n0 vdd.n28 0.00205012150882046f
CMODEL13699 din.n0 vdd.t29 0.000171488269917217f
CMODEL13700 din.n0 vdd.t28 0.00135552592174514f
CMODEL13701 din.n0 vdd.n29 0.000306031470005329f
CMODEL13702 din.n0 vdd.n30 9.76308027697393e-05f
CMODEL13703 din.n0 vdd.t38 4.49514057525305e-05f
CMODEL13704 din.n0 vdd.t40 4.49514057525305e-05f
CMODEL13705 din.n0 vdd.t37 0.000908333497434437f
CMODEL13706 din.n0 vdd.t39 0.000908333497434437f
CMODEL13707 din.n0 vdd.n31 0.000294187684864536f
CMODEL13708 din.n0 vdd.n32 0.00355022957373526f
CMODEL13709 din.n0 vdd.n33 0.00179890445874526f
CMODEL13710 din.n0 vdd.t17 0.000171488269917217f
CMODEL13711 din.n0 vdd.t16 0.00135552592174514f
CMODEL13712 din.n0 vdd.n34 0.000306031470005329f
CMODEL13713 din.n0 vdd.n35 9.76308027697393e-05f
CMODEL13714 din.n0 vdd.t1 4.49514057525305e-05f
CMODEL13715 din.n0 vdd.t31 4.49514057525305e-05f
CMODEL13716 din.n0 vdd.t0 0.000908333497434437f
CMODEL13717 din.n0 vdd.t30 0.000908333497434437f
CMODEL13718 din.n0 vdd.n36 0.000294187684864536f
CMODEL13719 din.n0 vdd.n37 0.00344302289789187f
CMODEL13720 din.n0 vdd.n38 0.00198609595413363f
CMODEL13721 din.n0 vdd.t19 0.000171488269917217f
CMODEL13722 din.n0 vdd.t18 0.00135552592174514f
CMODEL13723 din.n0 vdd.n39 0.00167598984504936f
CMODEL13724 din.n0 vdd.t21 0.000171489840711003f
CMODEL13725 din.n0 vdd.t20 0.00135552592174514f
CMODEL13726 din.n0 vdd.n40 0.00167598984504936f
CMODEL13727 din.n0 vdd.t11 0.000171488269917217f
CMODEL13728 din.n0 vdd.t10 0.00135552592174514f
CMODEL13729 din.n0 vdd.n41 0.00721041471243809f
CMODEL13730 din.n0 vdd.n42 0.0138115342235151f
CMODEL13731 din.n0 vdd.n43 0.00167598984504936f
CMODEL13732 din.n0 vdd.t13 0.000171488269917217f
CMODEL13733 din.n0 vdd.t12 0.00135552592174514f
CMODEL13734 din.n0 vdd.n44 0.00167598984504936f
CMODEL13735 din.n0 vdd.t23 0.000171488269917217f
CMODEL13736 din.n0 vdd.t22 0.00135552592174514f
CMODEL13737 din.n0 vdd.n45 0.00206893961836777f
CMODEL13738 din.n0 vdd.n46 0.0341499993676299f
CMODEL13739 din.t2 vdd 2.02396888745686e-06f
CMODEL13740 din.t2 vdd.n0 0.000679206295658315f
CMODEL13741 din.t2 vdd.n1 6.2942562192837e-05f
CMODEL13742 din.t2 vdd.t7 5.1887583474501e-06f
CMODEL13743 din.t2 vdd.t6 4.10144463235613e-05f
CMODEL13744 din.t2 vdd.n2 5.64431282301008e-05f
CMODEL13745 din.t2 vdd.t27 5.1887583474501e-06f
CMODEL13746 din.t2 vdd.t26 4.10144463235613e-05f
CMODEL13747 din.t2 vdd.n3 0.000105866392501912f
CMODEL13748 din.t2 vdd.n4 5.64431282301008e-05f
CMODEL13749 din.t2 vdd.t36 5.1887583474501e-06f
CMODEL13750 din.t2 vdd.t35 4.10144463235613e-05f
CMODEL13751 din.t2 vdd.n5 8.05354724352242e-05f
CMODEL13752 din.t2 vdd.t3 8.26537888646147e-06f
CMODEL13753 din.t2 vdd.n6 7.90792190047435e-05f
CMODEL13754 din.t2 vdd.t2 0.000103638762009528f
CMODEL13755 din.t2 vdd.n7 0.000106008976062337f
CMODEL13756 din.t2 vdd.t25 8.26537888646147e-06f
CMODEL13757 din.t2 vdd.n8 4.77645421855258e-05f
CMODEL13758 din.t2 vdd.t24 0.000103638762009528f
CMODEL13759 din.t2 vdd.n9 0.000106008976062337f
CMODEL13760 din.t2 vdd.t5 8.26537888646147e-06f
CMODEL13761 din.t2 vdd.n10 0.000141435287485696f
CMODEL13762 din.t2 vdd.t4 0.000103695795433698f
CMODEL13763 din.t2 vdd.n11 0.00034196670798248f
CMODEL13764 din.t2 vdd.n12 0.000843163131791779f
CMODEL13765 din.t2 vdd.n13 6.39107045681273e-05f
CMODEL13766 din.t2 vdd.t42 5.1887583474501e-06f
CMODEL13767 din.t2 vdd.t41 4.10144463235613e-05f
CMODEL13768 din.t2 vdd.n14 5.74606995730052e-05f
CMODEL13769 din.t2 vdd.t9 5.1887583474501e-06f
CMODEL13770 din.t2 vdd.t8 4.10144463235613e-05f
CMODEL13771 din.t2 vdd.n15 0.000110316900701331f
CMODEL13772 din.t2 vdd.t15 8.73837608424685e-06f
CMODEL13773 din.t2 vdd.n16 6.87343064173273e-05f
CMODEL13774 din.t2 vdd.t14 0.000117875255239495f
CMODEL13775 din.t2 vdd.n17 9.6281925570099e-05f
CMODEL13776 din.t2 vdd.t32 0.000117875255239495f
CMODEL13777 din.t2 vdd.n18 9.50433497085348e-05f
CMODEL13778 din.t2 vdd.t34 8.73837608424685e-06f
CMODEL13779 din.t2 vdd.n19 9.57096902142574e-05f
CMODEL13780 din.t2 vdd.t33 0.000117875255239495f
CMODEL13781 din.t2 vdd.n20 0.000191002561153537f
CMODEL13782 din.t2 vdd.t48 0.000118100537264968f
CMODEL13783 din.t2 vdd.n21 0.000339050398893241f
CMODEL13784 din.t2 vdd.n22 0.00148584427205439f
CMODEL13785 din.t2 vdd.t47 1.67985772272558e-06f
CMODEL13786 din.t2 vdd.t45 1.66260986469942e-06f
CMODEL13787 din.t2 vdd.n23 1.89850961263833e-05f
CMODEL13788 din.t2 vdd.t46 4.53089681078751e-05f
CMODEL13789 din.t2 vdd.n24 4.86804039219933e-05f
CMODEL13790 din.t2 vdd.t44 4.53089681078751e-05f
CMODEL13791 din.t2 vdd.n25 7.67736428326606e-05f
CMODEL13792 din.t2 vdd.t43 4.54071131253014e-05f
CMODEL13793 din.t2 vdd.n26 0.00041078228702925f
CMODEL13794 din.t2 vdd.n27 0.000274616412658351f
CMODEL13795 din.t2 vdd.n28 6.20309779631823e-05f
CMODEL13796 din.t2 vdd.t29 5.1887583474501e-06f
CMODEL13797 din.t2 vdd.t28 4.10144463235613e-05f
CMODEL13798 din.t2 vdd.n29 9.25966158116305e-06f
CMODEL13799 din.t2 vdd.n30 2.95403669932808e-06f
CMODEL13800 din.t2 vdd.t38 1.36010458290035e-06f
CMODEL13801 din.t2 vdd.t40 1.36010458290035e-06f
CMODEL13802 din.t2 vdd.t37 2.74836466619942e-05f
CMODEL13803 din.t2 vdd.t39 2.74836466619942e-05f
CMODEL13804 din.t2 vdd.n31 8.9013015659599e-06f
CMODEL13805 din.t2 vdd.n32 0.000107420078032017f
CMODEL13806 din.t2 vdd.n33 5.44298483568905e-05f
CMODEL13807 din.t2 vdd.t17 5.1887583474501e-06f
CMODEL13808 din.t2 vdd.t16 4.10144463235613e-05f
CMODEL13809 din.t2 vdd.n34 9.25966158116305e-06f
CMODEL13810 din.t2 vdd.n35 2.95403669932808e-06f
CMODEL13811 din.t2 vdd.t1 1.36010458290035e-06f
CMODEL13812 din.t2 vdd.t31 1.36010458290035e-06f
CMODEL13813 din.t2 vdd.t0 2.74836466619942e-05f
CMODEL13814 din.t2 vdd.t30 2.74836466619942e-05f
CMODEL13815 din.t2 vdd.n36 8.9013015659599e-06f
CMODEL13816 din.t2 vdd.n37 0.000104176302032333f
CMODEL13817 din.t2 vdd.n38 6.00937426555324e-05f
CMODEL13818 din.t2 vdd.t19 5.1887583474501e-06f
CMODEL13819 din.t2 vdd.t18 4.10144463235613e-05f
CMODEL13820 din.t2 vdd.n39 5.07107938224546e-05f
CMODEL13821 din.t2 vdd.t21 5.18880587530358e-06f
CMODEL13822 din.t2 vdd.t20 4.10144463235613e-05f
CMODEL13823 din.t2 vdd.n40 5.07107938224546e-05f
CMODEL13824 din.t2 vdd.t11 5.1887583474501e-06f
CMODEL13825 din.t2 vdd.t10 4.10144463235613e-05f
CMODEL13826 din.t2 vdd.n41 0.000218167105807299f
CMODEL13827 din.t2 vdd.n42 0.000417898632530094f
CMODEL13828 din.t2 vdd.n43 5.07107938224546e-05f
CMODEL13829 din.t2 vdd.t13 5.1887583474501e-06f
CMODEL13830 din.t2 vdd.t12 4.10144463235613e-05f
CMODEL13831 din.t2 vdd.n44 5.07107938224546e-05f
CMODEL13832 din.t2 vdd.t23 5.1887583474501e-06f
CMODEL13833 din.t2 vdd.t22 4.10144463235613e-05f
CMODEL13834 din.t2 vdd.n45 6.26003616478155e-05f
CMODEL13835 din.t2 vdd.n46 0.00103328405126335f
CMODEL13836 din.n1 vdd 8.81758361813276e-05f
CMODEL13837 din.n1 vdd.n0 0.0295901698047077f
CMODEL13838 din.n1 vdd.n1 0.00274214346235444f
CMODEL13839 din.n1 vdd.t7 0.000226052440264603f
CMODEL13840 din.n1 vdd.t6 0.00178682741741072f
CMODEL13841 din.n1 vdd.n2 0.00245899038232381f
CMODEL13842 din.n1 vdd.t27 0.000226052440264603f
CMODEL13843 din.n1 vdd.t26 0.00178682741741072f
CMODEL13844 din.n1 vdd.n3 0.00461215473232202f
CMODEL13845 din.n1 vdd.n4 0.00245899038232381f
CMODEL13846 din.n1 vdd.t36 0.000226052440264603f
CMODEL13847 din.n1 vdd.t35 0.00178682741741072f
CMODEL13848 din.n1 vdd.n5 0.00350859277938654f
CMODEL13849 din.n1 vdd.t3 0.000360087894228939f
CMODEL13850 din.n1 vdd.n6 0.00344514992474567f
CMODEL13851 din.n1 vdd.t2 0.0045151062141426f
CMODEL13852 din.n1 vdd.n7 0.00461836650007407f
CMODEL13853 din.n1 vdd.t25 0.000360087894228939f
CMODEL13854 din.n1 vdd.n8 0.00208090078514945f
CMODEL13855 din.n1 vdd.t24 0.0045151062141426f
CMODEL13856 din.n1 vdd.n9 0.00461836650007407f
CMODEL13857 din.n1 vdd.t5 0.000360087894228939f
CMODEL13858 din.n1 vdd.n10 0.00616174231574671f
CMODEL13859 din.n1 vdd.t4 0.00451759092124342f
CMODEL13860 din.n1 vdd.n11 0.0148980553057902f
CMODEL13861 din.n1 vdd.n12 0.0367330815427822f
CMODEL13862 din.n1 vdd.n13 0.00278432136539081f
CMODEL13863 din.n1 vdd.t42 0.000226052440264603f
CMODEL13864 din.n1 vdd.t41 0.00178682741741072f
CMODEL13865 din.n1 vdd.n14 0.00250332169818089f
CMODEL13866 din.n1 vdd.t9 0.000226052440264603f
CMODEL13867 din.n1 vdd.t8 0.00178682741741072f
CMODEL13868 din.n1 vdd.n15 0.0048060447097558f
CMODEL13869 din.n1 vdd.t15 0.000380694398451717f
CMODEL13870 din.n1 vdd.n16 0.00299446546844243f
CMODEL13871 din.n1 vdd.t14 0.0051353305182916f
CMODEL13872 din.n1 vdd.n17 0.00419459970402968f
CMODEL13873 din.n1 vdd.t32 0.0051353305182916f
CMODEL13874 din.n1 vdd.n18 0.00414064014815693f
CMODEL13875 din.n1 vdd.t34 0.000380694398451717f
CMODEL13876 din.n1 vdd.n19 0.00416966980945148f
CMODEL13877 din.n1 vdd.t33 0.0051353305182916f
CMODEL13878 din.n1 vdd.n20 0.00832118055117449f
CMODEL13879 din.n1 vdd.t48 0.00514514511133983f
CMODEL13880 din.n1 vdd.n21 0.0147710039493685f
CMODEL13881 din.n1 vdd.n22 0.0647320035083415f
CMODEL13882 din.n1 vdd.t47 7.31843558885467e-05f
CMODEL13883 din.n1 vdd.t45 7.24329390494745e-05f
CMODEL13884 din.n1 vdd.n23 0.000827101017363049f
CMODEL13885 din.n1 vdd.t46 0.00197392172092376f
CMODEL13886 din.n1 vdd.n24 0.00212080104001007f
CMODEL13887 din.n1 vdd.t44 0.00197392172092376f
CMODEL13888 din.n1 vdd.n25 0.00334470564019513f
CMODEL13889 din.n1 vdd.t43 0.00197819748772642f
CMODEL13890 din.n1 vdd.n26 0.0178960614818513f
CMODEL13891 din.n1 vdd.n27 0.0119638853963276f
CMODEL13892 din.n1 vdd.n28 0.00270242956052638f
CMODEL13893 din.n1 vdd.t29 0.000226052440264603f
CMODEL13894 din.n1 vdd.t28 0.00178682741741072f
CMODEL13895 din.n1 vdd.n29 0.000403404621353187f
CMODEL13896 din.n1 vdd.n30 0.00012869499016898f
CMODEL13897 din.n1 vdd.t38 5.92540525867397e-05f
CMODEL13898 din.n1 vdd.t40 5.92540525867397e-05f
CMODEL13899 din.n1 vdd.t37 0.00119734722245583f
CMODEL13900 din.n1 vdd.t39 0.00119734722245583f
CMODEL13901 din.n1 vdd.n31 0.000387792378403052f
CMODEL13902 din.n1 vdd.n32 0.00467984229492679f
CMODEL13903 din.n1 vdd.n33 0.00237128022166496f
CMODEL13904 din.n1 vdd.t17 0.000226052440264603f
CMODEL13905 din.n1 vdd.t16 0.00178682741741072f
CMODEL13906 din.n1 vdd.n34 0.000403404621353187f
CMODEL13907 din.n1 vdd.n35 0.00012869499016898f
CMODEL13908 din.n1 vdd.t1 5.92540525867397e-05f
CMODEL13909 din.n1 vdd.t31 5.92540525867397e-05f
CMODEL13910 din.n1 vdd.t0 0.00119734722245583f
CMODEL13911 din.n1 vdd.t30 0.00119734722245583f
CMODEL13912 din.n1 vdd.n36 0.000387792378403052f
CMODEL13913 din.n1 vdd.n37 0.0045385245785678f
CMODEL13914 din.n1 vdd.n38 0.00261803234266862f
CMODEL13915 din.n1 vdd.t19 0.000226052440264603f
CMODEL13916 din.n1 vdd.t18 0.00178682741741072f
CMODEL13917 din.n1 vdd.n39 0.00220925661279916f
CMODEL13918 din.n1 vdd.t21 0.000226054510853853f
CMODEL13919 din.n1 vdd.t20 0.00178682741741072f
CMODEL13920 din.n1 vdd.n40 0.00220925661279916f
CMODEL13921 din.n1 vdd.t11 0.000226052440264603f
CMODEL13922 din.n1 vdd.t10 0.00178682741741072f
CMODEL13923 din.n1 vdd.n41 0.00950462583740124f
CMODEL13924 din.n1 vdd.n42 0.0182060908103558f
CMODEL13925 din.n1 vdd.n43 0.00220925661279916f
CMODEL13926 din.n1 vdd.t13 0.000226052440264603f
CMODEL13927 din.n1 vdd.t12 0.00178682741741072f
CMODEL13928 din.n1 vdd.n44 0.00220925661279916f
CMODEL13929 din.n1 vdd.t23 0.000226052440264603f
CMODEL13930 din.n1 vdd.t22 0.00178682741741072f
CMODEL13931 din.n1 vdd.n45 0.00272723521974954f
CMODEL13932 din.n1 vdd.n46 0.0450158526633565f
CMODEL13933 din.t3 vdd 1.49018042372539e-06f
CMODEL13934 din.t3 vdd.n0 0.000500076820218725f
CMODEL13935 din.t3 vdd.n1 4.63424979406372e-05f
CMODEL13936 din.t3 vdd.t7 3.82030878079722e-06f
CMODEL13937 din.t3 vdd.t6 3.01975615238351e-05f
CMODEL13938 din.t3 vdd.n2 4.15571826541284e-05f
CMODEL13939 din.t3 vdd.t27 3.82030878079722e-06f
CMODEL13940 din.t3 vdd.t26 3.01975615238351e-05f
CMODEL13941 din.t3 vdd.n3 7.79458748671794e-05f
CMODEL13942 din.t3 vdd.n4 4.15571826541284e-05f
CMODEL13943 din.t3 vdd.t36 3.82030878079722e-06f
CMODEL13944 din.t3 vdd.t35 3.01975615238351e-05f
CMODEL13945 din.t3 vdd.n5 5.92955678232995e-05f
CMODEL13946 din.t3 vdd.t3 6.0855213178471e-06f
CMODEL13947 din.t3 vdd.n6 5.82233772538031e-05f
CMODEL13948 din.t3 vdd.t2 7.63057452329661e-05f
CMODEL13949 din.t3 vdd.n7 7.80508543615818e-05f
CMODEL13950 din.t3 vdd.t25 6.0855213178471e-06f
CMODEL13951 din.t3 vdd.n8 3.51674307615032e-05f
CMODEL13952 din.t3 vdd.t24 7.63057452329661e-05f
CMODEL13953 din.t3 vdd.n9 7.80508543615818e-05f
CMODEL13954 din.t3 vdd.t5 6.0855213178471e-06f
CMODEL13955 din.t3 vdd.n10 0.000104134059540798f
CMODEL13956 din.t3 vdd.t4 7.6347737030727e-05f
CMODEL13957 din.t3 vdd.n11 0.000251778620194906f
CMODEL13958 din.t3 vdd.n12 0.000620792740832028f
CMODEL13959 din.t3 vdd.n13 4.70553087076294e-05f
CMODEL13960 din.t3 vdd.t42 3.82030878079722e-06f
CMODEL13961 din.t3 vdd.t41 3.01975615238351e-05f
CMODEL13962 din.t3 vdd.n14 4.23063863125134e-05f
CMODEL13963 din.t3 vdd.t9 3.82030878079722e-06f
CMODEL13964 din.t3 vdd.t8 3.01975615238351e-05f
CMODEL13965 din.t3 vdd.n15 8.12226348191258e-05f
CMODEL13966 din.t3 vdd.t15 6.43377329394461e-06f
CMODEL13967 din.t3 vdd.n16 5.06067650032621e-05f
CMODEL13968 din.t3 vdd.t14 8.67875978173963e-05f
CMODEL13969 din.t3 vdd.n17 7.0889153253451e-05f
CMODEL13970 din.t3 vdd.t32 8.67875978173963e-05f
CMODEL13971 din.t3 vdd.n18 6.99772313787423e-05f
CMODEL13972 din.t3 vdd.t34 6.43377329394461e-06f
CMODEL13973 din.t3 vdd.n19 7.04678355492494e-05f
CMODEL13974 din.t3 vdd.t33 8.67875978173963e-05f
CMODEL13975 din.t3 vdd.n20 0.000140628781043196f
CMODEL13976 din.t3 vdd.t48 8.69534654185521e-05f
CMODEL13977 din.t3 vdd.n21 0.000249631439602729f
CMODEL13978 din.t3 vdd.n22 0.00109397731390134f
CMODEL13979 din.t3 vdd.t47 1.23682291193467e-06f
CMODEL13980 din.t3 vdd.t45 1.22412389242846e-06f
CMODEL13981 din.t3 vdd.n23 1.39780896660073e-05f
CMODEL13982 din.t3 vdd.t46 3.33594739089053e-05f
CMODEL13983 din.t3 vdd.n24 3.58417490472145e-05f
CMODEL13984 din.t3 vdd.t44 3.33594739089053e-05f
CMODEL13985 din.t3 vdd.n25 5.65258588293166e-05f
CMODEL13986 din.t3 vdd.t43 3.3431734794219e-05f
CMODEL13987 din.t3 vdd.n26 0.000302445223509977f
CMODEL13988 din.t3 vdd.n27 0.000202190856150643f
CMODEL13989 din.t3 vdd.n28 4.56713290397579e-05f
CMODEL13990 din.t3 vdd.t29 3.82030878079722e-06f
CMODEL13991 din.t3 vdd.t28 3.01975615238351e-05f
CMODEL13992 din.t3 vdd.n29 6.81757832547973e-06f
CMODEL13993 din.t3 vdd.n30 2.17495816639567e-06f
CMODEL13994 din.t3 vdd.t38 1.00139939710436e-06f
CMODEL13995 din.t3 vdd.t40 1.00139939710436e-06f
CMODEL13996 din.t3 vdd.t37 2.02352874503671e-05f
CMODEL13997 din.t3 vdd.t39 2.02352874503671e-05f
CMODEL13998 din.t3 vdd.n31 6.55372986288174e-06f
CMODEL13999 din.t3 vdd.n32 7.90898014245174e-05f
CMODEL14000 din.t3 vdd.n33 4.00748721931667e-05f
CMODEL14001 din.t3 vdd.t17 3.82030878079722e-06f
CMODEL14002 din.t3 vdd.t16 3.01975615238351e-05f
CMODEL14003 din.t3 vdd.n34 6.81757832547973e-06f
CMODEL14004 din.t3 vdd.n35 2.17495816639567e-06f
CMODEL14005 din.t3 vdd.t1 1.00139939710436e-06f
CMODEL14006 din.t3 vdd.t31 1.00139939710436e-06f
CMODEL14007 din.t3 vdd.t0 2.02352874503671e-05f
CMODEL14008 din.t3 vdd.t30 2.02352874503671e-05f
CMODEL14009 din.t3 vdd.n36 6.55372986288174e-06f
CMODEL14010 din.t3 vdd.n37 7.67015179268631e-05f
CMODEL14011 din.t3 vdd.n38 4.42450076424775e-05f
CMODEL14012 din.t3 vdd.t19 3.82030878079722e-06f
CMODEL14013 din.t3 vdd.t18 3.01975615238351e-05f
CMODEL14014 din.t3 vdd.n39 3.73366570475045e-05f
CMODEL14015 din.t3 vdd.t21 3.82034377396202e-06f
CMODEL14016 din.t3 vdd.t20 3.01975615238351e-05f
CMODEL14017 din.t3 vdd.n40 3.73366570475045e-05f
CMODEL14018 din.t3 vdd.t11 3.82030878079722e-06f
CMODEL14019 din.t3 vdd.t10 3.01975615238351e-05f
CMODEL14020 din.t3 vdd.n41 0.00016062912438509f
CMODEL14021 din.t3 vdd.n42 0.0003076847500756f
CMODEL14022 din.t3 vdd.n43 3.73366570475045e-05f
CMODEL14023 din.t3 vdd.t13 3.82030878079722e-06f
CMODEL14024 din.t3 vdd.t12 3.01975615238351e-05f
CMODEL14025 din.t3 vdd.n44 3.73366570475045e-05f
CMODEL14026 din.t3 vdd.t23 3.82030878079722e-06f
CMODEL14027 din.t3 vdd.t22 3.01975615238351e-05f
CMODEL14028 din.t3 vdd.n45 4.60905471540714e-05f
CMODEL14029 din.t3 vdd.n46 0.000760772398668169f
CMODEL14030 a_3200_n23917.t1 a_6400_n24000.t0 0.0188898375732846f
CMODEL14031 a_3200_n23917.t1 a_6400_n24000.t1 0.0188857291588212f
CMODEL14032 a_3200_n23917.n0 a_6400_n24000.t0 0.0269726080763337f
CMODEL14033 a_3200_n23917.n0 a_6400_n24000.t1 0.0269667417128615f
CMODEL14034 a_3200_n23917.t0 a_6400_n24000.t0 0.00428845535341184f
CMODEL14035 a_3200_n23917.t0 a_6400_n24000.t1 0.00428752264279794f
CMODEL14036 a_3200_n23917.t3 a_6400_n24000.t0 0.0124759113358561f
CMODEL14037 a_3200_n23917.t3 a_6400_n24000.t1 0.0124731979078355f
CMODEL14038 a_3200_n23917.n1 a_6400_n24000.t0 0.637489726401731f
CMODEL14039 a_3200_n23917.n1 a_6400_n24000.t1 0.637351076611756f
CMODEL14040 a_3200_n23917.t2 a_6400_n24000.t0 0.0159763339860272f
CMODEL14041 a_3200_n23917.t2 a_6400_n24000.t1 0.0159728592392823f
CMODEL14042 a_0_n11917.t2 a_20000_6483.t1 1.63922197062566e-05f
CMODEL14043 a_0_n11917.t2 a_20000_6483.t0 7.76107357374867e-06f
CMODEL14044 a_0_n11917.t2 a_20000_6483.n0 2.10662298943843e-05f
CMODEL14045 a_0_n11917.t2 a_20000_6483.t2 7.03633561643835e-06f
CMODEL14046 a_0_n11917.t2 a_20000_6483.t3 7.41243521537204e-06f
CMODEL14047 a_0_n11917.t2 a_20000_6483.t4 7.25042624746793e-06f
CMODEL14048 a_0_n11917.t2 a_20000_6483.n1 0.000184780800216127f
CMODEL14049 a_0_n11917.t1 a_20000_6483.t1 2.56433556980826e-05f
CMODEL14050 a_0_n11917.t1 a_20000_6483.t0 1.21411238878566e-05f
CMODEL14051 a_0_n11917.t1 a_20000_6483.n0 3.29551967994359e-05f
CMODEL14052 a_0_n11917.t1 a_20000_6483.t2 1.10073718054515e-05f
CMODEL14053 a_0_n11917.t1 a_20000_6483.t3 1.15957274989566e-05f
CMODEL14054 a_0_n11917.t1 a_20000_6483.t4 1.13422869238124e-05f
CMODEL14055 a_0_n11917.t1 a_20000_6483.n1 0.000289063950522205f
CMODEL14056 a_0_n11917.n0 a_20000_6483.t1 0.000699247879703499f
CMODEL14057 a_0_n11917.n0 a_20000_6483.t0 0.000331066465549828f
CMODEL14058 a_0_n11917.n0 a_20000_6483.n0 0.000898628547625697f
CMODEL14059 a_0_n11917.n0 a_20000_6483.t2 0.000300151099048459f
CMODEL14060 a_0_n11917.n0 a_20000_6483.t3 0.000316194493526105f
CMODEL14061 a_0_n11917.n0 a_20000_6483.t4 0.000309283627924623f
CMODEL14062 a_0_n11917.n0 a_20000_6483.n1 0.00788225054790636f
CMODEL14063 a_0_n11917.t6 a_20000_6483.t1 4.3689763595146e-05f
CMODEL14064 a_0_n11917.t6 a_20000_6483.t0 2.06853907376677e-05f
CMODEL14065 a_0_n11917.t6 a_20000_6483.n0 5.61472833099813e-05f
CMODEL14066 a_0_n11917.t6 a_20000_6483.t2 1.8753765211002e-05f
CMODEL14067 a_0_n11917.t6 a_20000_6483.t3 1.97561738451037e-05f
CMODEL14068 a_0_n11917.t6 a_20000_6483.t4 1.93243754898557e-05f
CMODEL14069 a_0_n11917.t6 a_20000_6483.n1 0.000492491537023699f
CMODEL14070 a_0_n11917.n1 a_20000_6483.t1 0.00271084644816622f
CMODEL14071 a_0_n11917.n1 a_20000_6483.t0 0.00128347954751504f
CMODEL14072 a_0_n11917.n1 a_20000_6483.n0 0.00348380606829275f
CMODEL14073 a_0_n11917.n1 a_20000_6483.t2 0.00116362675438318f
CMODEL14074 a_0_n11917.n1 a_20000_6483.t3 0.00122582383813365f
CMODEL14075 a_0_n11917.n1 a_20000_6483.t4 0.00119903177195323f
CMODEL14076 a_0_n11917.n1 a_20000_6483.n1 0.0305579344915692f
CMODEL14077 a_0_n11917.t4 a_20000_6483.t1 3.4684163945387e-06f
CMODEL14078 a_0_n11917.t4 a_20000_6483.t0 1.64215922582691e-06f
CMODEL14079 a_0_n11917.t4 a_20000_6483.n0 4.45738639709153e-06f
CMODEL14080 a_0_n11917.t4 a_20000_6483.t2 1.48881251269567e-06f
CMODEL14081 a_0_n11917.t4 a_20000_6483.t3 1.5683911200043e-06f
CMODEL14082 a_0_n11917.t4 a_20000_6483.t4 1.5341117746557e-06f
CMODEL14083 a_0_n11917.t4 a_20000_6483.n1 3.90976187697739e-05f
CMODEL14084 a_0_n11917.t5 a_20000_6483.t1 3.50181837016939e-06f
CMODEL14085 a_0_n11917.t5 a_20000_6483.t0 1.65797375217074e-06f
CMODEL14086 a_0_n11917.t5 a_20000_6483.n0 4.5003124748389e-06f
CMODEL14087 a_0_n11917.t5 a_20000_6483.t2 1.50315026041997e-06f
CMODEL14088 a_0_n11917.t5 a_20000_6483.t3 1.58349523554599e-06f
CMODEL14089 a_0_n11917.t5 a_20000_6483.t4 1.54888576897556e-06f
CMODEL14090 a_0_n11917.t5 a_20000_6483.n1 3.9474141528524e-05f
CMODEL14091 a_0_n11917.n2 a_20000_6483.t1 0.000880661461669167f
CMODEL14092 a_0_n11917.n2 a_20000_6483.t0 0.000416958686502396f
CMODEL14093 a_0_n11917.n2 a_20000_6483.n0 0.00113176965310965f
CMODEL14094 a_0_n11917.n2 a_20000_6483.t2 0.000378022605834295f
CMODEL14095 a_0_n11917.n2 a_20000_6483.t3 0.00039822831491247f
CMODEL14096 a_0_n11917.n2 a_20000_6483.t4 0.000389524487301893f
CMODEL14097 a_0_n11917.n2 a_20000_6483.n1 0.00992722965667803f
CMODEL14098 a_0_n11917.t0 a_20000_6483.t1 6.9410927214335e-06f
CMODEL14099 a_0_n11917.t0 a_20000_6483.t0 3.28633536266571e-06f
CMODEL14100 a_0_n11917.t0 a_20000_6483.n0 8.92024738615146e-06f
CMODEL14101 a_0_n11917.t0 a_20000_6483.t2 2.97945359493823e-06f
CMODEL14102 a_0_n11917.t0 a_20000_6483.t3 3.13870854853651e-06f
CMODEL14103 a_0_n11917.t0 a_20000_6483.t4 3.07010775571667e-06f
CMODEL14104 a_0_n11917.t0 a_20000_6483.n1 7.82432574980239e-05f
CMODEL14105 a_0_n11917.t3 a_20000_6483.t1 1.24652806167433e-05f
CMODEL14106 a_0_n11917.t3 a_20000_6483.t0 5.90182182264449e-06f
CMODEL14107 a_0_n11917.t3 a_20000_6483.n0 1.60195795246753e-05f
CMODEL14108 a_0_n11917.t3 a_20000_6483.t2 5.35070292762197e-06f
CMODEL14109 a_0_n11917.t3 a_20000_6483.t3 5.6367036721559e-06f
CMODEL14110 a_0_n11917.t3 a_20000_6483.t4 5.51350575975951e-06f
CMODEL14111 a_0_n11917.t3 a_20000_6483.n1 0.000140514498253172f
CMODEL14112 a_0_n11917.n3 a_20000_6483.t1 0.00193266458812858f
CMODEL14113 a_0_n11917.n3 a_20000_6483.t0 0.000915040935921541f
CMODEL14114 a_0_n11917.n3 a_20000_6483.n0 0.00248373662943966f
CMODEL14115 a_0_n11917.n3 a_20000_6483.t2 0.000829593363178741f
CMODEL14116 a_0_n11917.n3 a_20000_6483.t3 0.000873936008012319f
CMODEL14117 a_0_n11917.n3 a_20000_6483.t4 0.00085483493440311f
CMODEL14118 a_0_n11917.n3 a_20000_6483.n1 0.0217859030407861f
CMODEL14119 a_0_n11917.n4 a_20000_6483.t1 0.00352040809907756f
CMODEL14120 a_0_n11917.n4 a_20000_6483.t0 0.00166677526022503f
CMODEL14121 a_0_n11917.n4 a_20000_6483.n0 0.0045242028026817f
CMODEL14122 a_0_n11917.n4 a_20000_6483.t2 0.0015111298735511f
CMODEL14123 a_0_n11917.n4 a_20000_6483.t3 0.00159190136745932f
CMODEL14124 a_0_n11917.n4 a_20000_6483.t4 0.00155710817331276f
CMODEL14125 a_0_n11917.n4 a_20000_6483.n1 0.0396836936846692f
CMODEL14126 a_0_n11917.t2 a_n104_n35959.t0 1.36337289259034e-05f
CMODEL14127 a_0_n11917.t2 a_n104_n35959.t3 1.18978293383146e-05f
CMODEL14128 a_0_n11917.t2 a_n104_n35959.t4 4.77028731338619e-06f
CMODEL14129 a_0_n11917.t2 a_n104_n35959.t2 6.52914130922713e-06f
CMODEL14130 a_0_n11917.t2 a_n104_n35959.n0 0.000487395664662468f
CMODEL14131 a_0_n11917.t2 a_n104_n35959.t1 1.20829185303822e-05f
CMODEL14132 a_0_n11917.t2 a_n104_n35959.n1 0.000227687022429463f
CMODEL14133 a_0_n11917.t1 a_n104_n35959.t0 2.13280792109404e-05f
CMODEL14134 a_0_n11917.t1 a_n104_n35959.t3 1.8612504909328e-05f
CMODEL14135 a_0_n11917.t1 a_n104_n35959.t4 7.46245331939537e-06f
CMODEL14136 a_0_n11917.t1 a_n104_n35959.t2 1.02139366111382e-05f
CMODEL14137 a_0_n11917.t1 a_n104_n35959.n0 0.000762462962223024f
CMODEL14138 a_0_n11917.t1 a_n104_n35959.t1 1.89020512961573e-05f
CMODEL14139 a_0_n11917.t1 a_n104_n35959.n1 0.000356184788187503f
CMODEL14140 a_0_n11917.n0 a_n104_n35959.t0 0.000581578103193159f
CMODEL14141 a_0_n11917.n0 a_n104_n35959.t3 0.000507529308841266f
CMODEL14142 a_0_n11917.n0 a_n104_n35959.t4 0.000203487590407823f
CMODEL14143 a_0_n11917.n0 a_n104_n35959.t2 0.000278515557903304f
CMODEL14144 a_0_n11917.n0 a_n104_n35959.n0 0.0207909844547671f
CMODEL14145 a_0_n11917.n0 a_n104_n35959.t1 0.000515424714553761f
CMODEL14146 a_0_n11917.n0 a_n104_n35959.n1 0.00971251426120392f
CMODEL14147 a_0_n11917.t6 a_n104_n35959.t0 3.63376287267352e-05f
CMODEL14148 a_0_n11917.t6 a_n104_n35959.t3 3.17109799893638e-05f
CMODEL14149 a_0_n11917.t6 a_n104_n35959.t4 1.27141246724029e-05f
CMODEL14150 a_0_n11917.t6 a_n104_n35959.t2 1.74019532065299e-05f
CMODEL14151 a_0_n11917.t6 a_n104_n35959.n0 0.0012990431892683f
CMODEL14152 a_0_n11917.t6 a_n104_n35959.t1 3.22042934752952e-05f
CMODEL14153 a_0_n11917.t6 a_n104_n35959.n1 0.00060684839282804f
CMODEL14154 a_0_n11917.n1 a_n104_n35959.t0 0.00225466387690862f
CMODEL14155 a_0_n11917.n1 a_n104_n35959.t3 0.0019675912707751f
CMODEL14156 a_0_n11917.n1 a_n104_n35959.t4 0.000788881350540319f
CMODEL14157 a_0_n11917.n1 a_n104_n35959.t2 0.00107975001829302f
CMODEL14158 a_0_n11917.n1 a_n104_n35959.n0 0.0806025559734029f
CMODEL14159 a_0_n11917.n1 a_n104_n35959.t1 0.00199820020525142f
CMODEL14160 a_0_n11917.n1 a_n104_n35959.n1 0.0376535067920588f
CMODEL14161 a_0_n11917.t4 a_n104_n35959.t0 2.88474958075698e-06f
CMODEL14162 a_0_n11917.t4 a_n104_n35959.t3 2.51745200320145e-06f
CMODEL14163 a_0_n11917.t4 a_n104_n35959.t4 1.00934120094142e-06f
CMODEL14164 a_0_n11917.t4 a_n104_n35959.t2 1.38149568301234e-06f
CMODEL14165 a_0_n11917.t4 a_n104_n35959.n0 0.000103127651058579f
CMODEL14166 a_0_n11917.t4 a_n104_n35959.t1 2.55661487435147e-06f
CMODEL14167 a_0_n11917.t4 a_n104_n35959.n1 4.817611132412e-05f
CMODEL14168 a_0_n11917.t5 a_n104_n35959.t0 2.91253065552897e-06f
CMODEL14169 a_0_n11917.t5 a_n104_n35959.t3 2.54169588308703e-06f
CMODEL14170 a_0_n11917.t5 a_n104_n35959.t4 1.01906148431051e-06f
CMODEL14171 a_0_n11917.t5 a_n104_n35959.t2 1.39479993483474e-06f
CMODEL14172 a_0_n11917.t5 a_n104_n35959.n0 0.000104120803810634f
CMODEL14173 a_0_n11917.t5 a_n104_n35959.t1 2.5812359053974e-06f
CMODEL14174 a_0_n11917.t5 a_n104_n35959.n1 4.86400629127941e-05f
CMODEL14175 a_0_n11917.n2 a_n104_n35959.t0 0.000732463318515954f
CMODEL14176 a_0_n11917.n2 a_n104_n35959.t3 0.000639203229552323f
CMODEL14177 a_0_n11917.n2 a_n104_n35959.t4 0.000256280618077924f
CMODEL14178 a_0_n11917.n2 a_n104_n35959.t2 0.000350773917862622f
CMODEL14179 a_0_n11917.n2 a_n104_n35959.n0 0.0261850186335067f
CMODEL14180 a_0_n11917.n2 a_n104_n35959.t1 0.000649147027362887f
CMODEL14181 a_0_n11917.n2 a_n104_n35959.n1 0.0122323388515406f
CMODEL14182 a_0_n11917.t0 a_n104_n35959.t0 5.77304223036165e-06f
CMODEL14183 a_0_n11917.t0 a_n104_n35959.t3 5.03799595789415e-06f
CMODEL14184 a_0_n11917.t0 a_n104_n35959.t4 2.01992208153809e-06f
CMODEL14185 a_0_n11917.t0 a_n104_n35959.t2 2.76468812831918e-06f
CMODEL14186 a_0_n11917.t0 a_n104_n35959.n0 0.000206381964192174f
CMODEL14187 a_0_n11917.t0 a_n104_n35959.t1 5.11636980029608e-06f
CMODEL14188 a_0_n11917.t0 a_n104_n35959.n1 9.64113928723641e-05f
CMODEL14189 a_0_n11917.t3 a_n104_n35959.t0 1.03676170744058e-05f
CMODEL14190 a_0_n11917.t3 a_n104_n35959.t3 9.04757159737229e-06f
CMODEL14191 a_0_n11917.t3 a_n104_n35959.t4 3.62751177384193e-06f
CMODEL14192 a_0_n11917.t3 a_n104_n35959.t2 4.96501267456921e-06f
CMODEL14193 a_0_n11917.t3 a_n104_n35959.n0 0.000370634596184853f
CMODEL14194 a_0_n11917.t3 a_n104_n35959.t1 9.18832060876867e-06f
CMODEL14195 a_0_n11917.t3 a_n104_n35959.n1 0.000173142056306792f
CMODEL14196 a_0_n11917.n3 a_n104_n35959.t0 0.00160743484234663f
CMODEL14197 a_0_n11917.n3 a_n104_n35959.t3 0.00140276996342243f
CMODEL14198 a_0_n11917.n3 a_n104_n35959.t4 0.000562423242915762f
CMODEL14199 a_0_n11917.n3 a_n104_n35959.t2 0.00076979447721863f
CMODEL14200 a_0_n11917.n3 a_n104_n35959.n0 0.0574645995710398f
CMODEL14201 a_0_n11917.n3 a_n104_n35959.t1 0.00142459222627422f
CMODEL14202 a_0_n11917.n3 a_n104_n35959.n1 0.026844603922549f
CMODEL14203 a_0_n11917.n4 a_n104_n35959.t0 0.00292799209572937f
CMODEL14204 a_0_n11917.n4 a_n104_n35959.t3 0.0025551887123657f
CMODEL14205 a_0_n11917.n4 a_n104_n35959.t4 0.0010244712670952f
CMODEL14206 a_0_n11917.n4 a_n104_n35959.t2 0.0014022043601729f
CMODEL14207 a_0_n11917.n4 a_n104_n35959.n0 0.104673538793416f
CMODEL14208 a_0_n11917.n4 a_n104_n35959.t1 0.00259493863656648f
CMODEL14209 a_0_n11917.n4 a_n104_n35959.n1 0.0488982732161404f
CMODEL14210 a_0_n23917.t1 vdd 4.16696802076323e-06f
CMODEL14211 a_0_n23917.t1 vdd.n0 0.0013983569268525f
CMODEL14212 a_0_n23917.t1 vdd.n1 0.000129586796233815f
CMODEL14213 a_0_n23917.t1 vdd.t7 1.0682669202717e-05f
CMODEL14214 a_0_n23917.t1 vdd.t6 8.44409651149999e-05f
CMODEL14215 a_0_n23917.t1 vdd.n2 0.000116205694556005f
CMODEL14216 a_0_n23917.t1 vdd.t27 1.0682669202717e-05f
CMODEL14217 a_0_n23917.t1 vdd.t26 8.44409651149999e-05f
CMODEL14218 a_0_n23917.t1 vdd.n3 0.000217958820791625f
CMODEL14219 a_0_n23917.t1 vdd.n4 0.000116205694556005f
CMODEL14220 a_0_n23917.t1 vdd.t36 1.0682669202717e-05f
CMODEL14221 a_0_n23917.t1 vdd.t35 8.44409651149999e-05f
CMODEL14222 a_0_n23917.t1 vdd.n5 0.000165807261294569f
CMODEL14223 a_0_n23917.t1 vdd.t3 1.70168473007768e-05f
CMODEL14224 a_0_n23917.t1 vdd.n6 0.00016280911171206f
CMODEL14225 a_0_n23917.t1 vdd.t2 0.000213372552158068f
CMODEL14226 a_0_n23917.t1 vdd.n7 0.00021825237329644f
CMODEL14227 a_0_n23917.t1 vdd.t25 1.70168473007768e-05f
CMODEL14228 a_0_n23917.t1 vdd.n8 9.83381320962744e-05f
CMODEL14229 a_0_n23917.t1 vdd.t24 0.000213372552158068f
CMODEL14230 a_0_n23917.t1 vdd.n9 0.00021825237329644f
CMODEL14231 a_0_n23917.t1 vdd.t5 1.70168473007768e-05f
CMODEL14232 a_0_n23917.t1 vdd.n10 0.000291188428642736f
CMODEL14233 a_0_n23917.t1 vdd.t4 0.000213489973159994f
CMODEL14234 a_0_n23917.t1 vdd.n11 0.000704044585447732f
CMODEL14235 a_0_n23917.t1 vdd.n12 0.00173591295213909f
CMODEL14236 a_0_n23917.t1 vdd.n13 0.000131580017741507f
CMODEL14237 a_0_n23917.t1 vdd.t42 1.0682669202717e-05f
CMODEL14238 a_0_n23917.t1 vdd.t41 8.44409651149999e-05f
CMODEL14239 a_0_n23917.t1 vdd.n14 0.000118300680932033f
CMODEL14240 a_0_n23917.t1 vdd.t9 1.0682669202717e-05f
CMODEL14241 a_0_n23917.t1 vdd.t8 8.44409651149999e-05f
CMODEL14242 a_0_n23917.t1 vdd.n15 0.000227121572975246f
CMODEL14243 a_0_n23917.t1 vdd.t15 1.79906588100826e-05f
CMODEL14244 a_0_n23917.t1 vdd.n16 0.000141510898979394f
CMODEL14245 a_0_n23917.t1 vdd.t14 0.000242682791255481f
CMODEL14246 a_0_n23917.t1 vdd.n17 0.000198226221417971f
CMODEL14247 a_0_n23917.t1 vdd.t32 0.000242682791255481f
CMODEL14248 a_0_n23917.t1 vdd.n18 0.000195676228659479f
CMODEL14249 a_0_n23917.t1 vdd.t34 1.79906588100826e-05f
CMODEL14250 a_0_n23917.t1 vdd.n19 0.000197048097365314f
CMODEL14251 a_0_n23917.t1 vdd.t33 0.000242682791255481f
CMODEL14252 a_0_n23917.t1 vdd.n20 0.00039323804290822f
CMODEL14253 a_0_n23917.t1 vdd.t48 0.000243146604213088f
CMODEL14254 a_0_n23917.t1 vdd.n21 0.000698040458215919f
CMODEL14255 a_0_n23917.t1 vdd.n22 0.00305907151234153f
CMODEL14256 a_0_n23917.t1 vdd.t47 3.45850840564309e-06f
CMODEL14257 a_0_n23917.t1 vdd.t45 3.42299833764398e-06f
CMODEL14258 a_0_n23917.t1 vdd.n23 3.90867117177665e-05f
CMODEL14259 a_0_n23917.t1 vdd.t46 9.32825708583531e-05f
CMODEL14260 a_0_n23917.t1 vdd.n24 0.000100223717685535f
CMODEL14261 a_0_n23917.t1 vdd.t44 9.32825708583531e-05f
CMODEL14262 a_0_n23917.t1 vdd.n25 0.000158062367709204f
CMODEL14263 a_0_n23917.t1 vdd.t43 9.34846328325007e-05f
CMODEL14264 a_0_n23917.t1 vdd.n26 0.00084572280935487f
CMODEL14265 a_0_n23917.t1 vdd.n27 0.000565383102781741f
CMODEL14266 a_0_n23917.t1 vdd.n28 0.000127710017219698f
CMODEL14267 a_0_n23917.t1 vdd.t29 1.0682669202717e-05f
CMODEL14268 a_0_n23917.t1 vdd.t28 8.44409651149999e-05f
CMODEL14269 a_0_n23917.t1 vdd.n29 1.90638867676857e-05f
CMODEL14270 a_0_n23917.t1 vdd.n30 6.08180122458697e-06f
CMODEL14271 a_0_n23917.t1 vdd.t38 2.80019734342881e-06f
CMODEL14272 a_0_n23917.t1 vdd.t40 2.80019734342881e-06f
CMODEL14273 a_0_n23917.t1 vdd.t37 5.65836152147505e-05f
CMODEL14274 a_0_n23917.t1 vdd.t39 5.65836152147505e-05f
CMODEL14275 a_0_n23917.t1 vdd.n31 1.8326091472251e-05f
CMODEL14276 a_0_n23917.t1 vdd.n32 0.000221157564585757f
CMODEL14277 a_0_n23917.t1 vdd.n33 0.000112060733188019f
CMODEL14278 a_0_n23917.t1 vdd.t17 1.0682669202717e-05f
CMODEL14279 a_0_n23917.t1 vdd.t16 8.44409651149999e-05f
CMODEL14280 a_0_n23917.t1 vdd.n34 1.90638867676857e-05f
CMODEL14281 a_0_n23917.t1 vdd.n35 6.08180122458697e-06f
CMODEL14282 a_0_n23917.t1 vdd.t1 2.80019734342881e-06f
CMODEL14283 a_0_n23917.t1 vdd.t31 2.80019734342881e-06f
CMODEL14284 a_0_n23917.t1 vdd.t0 5.65836152147505e-05f
CMODEL14285 a_0_n23917.t1 vdd.t30 5.65836152147505e-05f
CMODEL14286 a_0_n23917.t1 vdd.n36 1.8326091472251e-05f
CMODEL14287 a_0_n23917.t1 vdd.n37 0.00021447924510122f
CMODEL14288 a_0_n23917.t1 vdd.n38 0.000123721617187614f
CMODEL14289 a_0_n23917.t1 vdd.t19 1.0682669202717e-05f
CMODEL14290 a_0_n23917.t1 vdd.t18 8.44409651149999e-05f
CMODEL14291 a_0_n23917.t1 vdd.n39 0.000104403905354098f
CMODEL14292 a_0_n23917.t1 vdd.t21 1.0682767053552e-05f
CMODEL14293 a_0_n23917.t1 vdd.t20 8.44409651149999e-05f
CMODEL14294 a_0_n23917.t1 vdd.n40 0.000104403905354098f
CMODEL14295 a_0_n23917.t1 vdd.t11 1.0682669202717e-05f
CMODEL14296 a_0_n23917.t1 vdd.t10 8.44409651149999e-05f
CMODEL14297 a_0_n23917.t1 vdd.n41 0.000449164687617195f
CMODEL14298 a_0_n23917.t1 vdd.n42 0.000860374014870179f
CMODEL14299 a_0_n23917.t1 vdd.n43 0.000104403905354098f
CMODEL14300 a_0_n23917.t1 vdd.t13 1.0682669202717e-05f
CMODEL14301 a_0_n23917.t1 vdd.t12 8.44409651149999e-05f
CMODEL14302 a_0_n23917.t1 vdd.n44 0.000104403905354098f
CMODEL14303 a_0_n23917.t1 vdd.t23 1.0682669202717e-05f
CMODEL14304 a_0_n23917.t1 vdd.t22 8.44409651149999e-05f
CMODEL14305 a_0_n23917.t1 vdd.n45 0.000128882270222259f
CMODEL14306 a_0_n23917.t1 vdd.n46 0.00212733586205921f
CMODEL14307 a_0_n23917.n0 vdd 1.39480300810197e-05f
CMODEL14308 a_0_n23917.n0 vdd.n0 0.00468069934363655f
CMODEL14309 a_0_n23917.n0 vdd.n1 0.000433763955702533f
CMODEL14310 a_0_n23917.n0 vdd.t7 3.5757939740029e-05f
CMODEL14311 a_0_n23917.n0 vdd.t6 0.000282647986647766f
CMODEL14312 a_0_n23917.n0 vdd.n2 0.00038897359307213f
CMODEL14313 a_0_n23917.n0 vdd.t27 3.5757939740029e-05f
CMODEL14314 a_0_n23917.n0 vdd.t26 0.000282647986647766f
CMODEL14315 a_0_n23917.n0 vdd.n3 0.000729570319156981f
CMODEL14316 a_0_n23917.n0 vdd.n4 0.00038897359307213f
CMODEL14317 a_0_n23917.n0 vdd.t36 3.5757939740029e-05f
CMODEL14318 a_0_n23917.n0 vdd.t35 0.000282647986647766f
CMODEL14319 a_0_n23917.n0 vdd.n5 0.000555004179697194f
CMODEL14320 a_0_n23917.n0 vdd.t3 5.69602398800939e-05f
CMODEL14321 a_0_n23917.n0 vdd.n6 0.000544968518190828f
CMODEL14322 a_0_n23917.n0 vdd.t2 0.00071421877037097f
CMODEL14323 a_0_n23917.n0 vdd.n7 0.000730552923090372f
CMODEL14324 a_0_n23917.n0 vdd.t25 5.69602398800939e-05f
CMODEL14325 a_0_n23917.n0 vdd.n8 0.00032916576699307f
CMODEL14326 a_0_n23917.n0 vdd.t24 0.00071421877037097f
CMODEL14327 a_0_n23917.n0 vdd.n9 0.000730552923090372f
CMODEL14328 a_0_n23917.n0 vdd.t5 5.69602398800939e-05f
CMODEL14329 a_0_n23917.n0 vdd.n10 0.00097469069638068f
CMODEL14330 a_0_n23917.n0 vdd.t4 0.000714611811944327f
CMODEL14331 a_0_n23917.n0 vdd.n11 0.00235663796968745f
CMODEL14332 a_0_n23917.n0 vdd.n12 0.00581059560664277f
CMODEL14333 a_0_n23917.n0 vdd.n13 0.000440435836410258f
CMODEL14334 a_0_n23917.n0 vdd.t42 3.5757939740029e-05f
CMODEL14335 a_0_n23917.n0 vdd.t41 0.000282647986647766f
CMODEL14336 a_0_n23917.n0 vdd.n14 0.000395986109810097f
CMODEL14337 a_0_n23917.n0 vdd.t9 3.5757939740029e-05f
CMODEL14338 a_0_n23917.n0 vdd.t8 0.000282647986647766f
CMODEL14339 a_0_n23917.n0 vdd.n15 0.000760240663264556f
CMODEL14340 a_0_n23917.n0 vdd.t15 6.0219864661796e-05f
CMODEL14341 a_0_n23917.n0 vdd.n16 0.000473677327476872f
CMODEL14342 a_0_n23917.n0 vdd.t14 0.000812328497773609f
CMODEL14343 a_0_n23917.n0 vdd.n17 0.000663519682754443f
CMODEL14344 a_0_n23917.n0 vdd.t32 0.000812328497773609f
CMODEL14345 a_0_n23917.n0 vdd.n18 0.000654984129919721f
CMODEL14346 a_0_n23917.n0 vdd.t34 6.0219864661796e-05f
CMODEL14347 a_0_n23917.n0 vdd.n19 0.000659576165635101f
CMODEL14348 a_0_n23917.n0 vdd.t33 0.000812328497773609f
CMODEL14349 a_0_n23917.n0 vdd.n20 0.00131627985243826f
CMODEL14350 a_0_n23917.n0 vdd.t48 0.000813881011988367f
CMODEL14351 a_0_n23917.n0 vdd.n21 0.00233654044390316f
CMODEL14352 a_0_n23917.n0 vdd.n22 0.010239584576009f
CMODEL14353 a_0_n23917.n0 vdd.t47 1.1576613748174e-05f
CMODEL14354 a_0_n23917.n0 vdd.t45 1.14577514256982e-05f
CMODEL14355 a_0_n23917.n0 vdd.n23 0.00013083436880029f
CMODEL14356 a_0_n23917.n0 vdd.t46 0.000312243362052211f
CMODEL14357 a_0_n23917.n0 vdd.n24 0.000335477359591884f
CMODEL14358 a_0_n23917.n0 vdd.t44 0.000312243362052211f
CMODEL14359 a_0_n23917.n0 vdd.n25 0.000529079812587897f
CMODEL14360 a_0_n23917.n0 vdd.t43 0.000312919721093029f
CMODEL14361 a_0_n23917.n0 vdd.n26 0.00283087538140636f
CMODEL14362 a_0_n23917.n0 vdd.n27 0.00189249845105736f
CMODEL14363 a_0_n23917.n0 vdd.n28 0.000427481841221721f
CMODEL14364 a_0_n23917.n0 vdd.t29 3.5757939740029e-05f
CMODEL14365 a_0_n23917.n0 vdd.t28 0.000282647986647766f
CMODEL14366 a_0_n23917.n0 vdd.n29 6.38122646422732e-05f
CMODEL14367 a_0_n23917.n0 vdd.n30 2.03575227850642e-05f
CMODEL14368 a_0_n23917.n0 vdd.t38 9.373058920616e-06f
CMODEL14369 a_0_n23917.n0 vdd.t40 9.373058920616e-06f
CMODEL14370 a_0_n23917.n0 vdd.t37 0.000189401493646123f
CMODEL14371 a_0_n23917.n0 vdd.t39 0.000189401493646123f
CMODEL14372 a_0_n23917.n0 vdd.n31 6.13426534230174e-05f
CMODEL14373 a_0_n23917.n0 vdd.n32 0.000740277426684497f
CMODEL14374 a_0_n23917.n0 vdd.n33 0.000375099225532651f
CMODEL14375 a_0_n23917.n0 vdd.t17 3.5757939740029e-05f
CMODEL14376 a_0_n23917.n0 vdd.t16 0.000282647986647766f
CMODEL14377 a_0_n23917.n0 vdd.n34 6.38122646422732e-05f
CMODEL14378 a_0_n23917.n0 vdd.n35 2.03575227850642e-05f
CMODEL14379 a_0_n23917.n0 vdd.t1 9.373058920616e-06f
CMODEL14380 a_0_n23917.n0 vdd.t31 9.373058920616e-06f
CMODEL14381 a_0_n23917.n0 vdd.t0 0.000189401493646123f
CMODEL14382 a_0_n23917.n0 vdd.t30 0.000189401493646123f
CMODEL14383 a_0_n23917.n0 vdd.n36 6.13426534230174e-05f
CMODEL14384 a_0_n23917.n0 vdd.n37 0.000717923187199854f
CMODEL14385 a_0_n23917.n0 vdd.n38 0.000414131529113383f
CMODEL14386 a_0_n23917.n0 vdd.t19 3.5757939740029e-05f
CMODEL14387 a_0_n23917.n0 vdd.t18 0.000282647986647766f
CMODEL14388 a_0_n23917.n0 vdd.n39 0.000349469639603371f
CMODEL14389 a_0_n23917.n0 vdd.t21 3.57582672746735e-05f
CMODEL14390 a_0_n23917.n0 vdd.t20 0.000282647986647766f
CMODEL14391 a_0_n23917.n0 vdd.n40 0.000349469639603371f
CMODEL14392 a_0_n23917.n0 vdd.t11 3.5757939740029e-05f
CMODEL14393 a_0_n23917.n0 vdd.t10 0.000282647986647766f
CMODEL14394 a_0_n23917.n0 vdd.n41 0.00150348227848145f
CMODEL14395 a_0_n23917.n0 vdd.n42 0.0028799171437219f
CMODEL14396 a_0_n23917.n0 vdd.n43 0.000349469639603371f
CMODEL14397 a_0_n23917.n0 vdd.t13 3.5757939740029e-05f
CMODEL14398 a_0_n23917.n0 vdd.t12 0.000282647986647766f
CMODEL14399 a_0_n23917.n0 vdd.n44 0.000349469639603371f
CMODEL14400 a_0_n23917.n0 vdd.t23 3.5757939740029e-05f
CMODEL14401 a_0_n23917.n0 vdd.t22 0.000282647986647766f
CMODEL14402 a_0_n23917.n0 vdd.n45 0.000431405706262395f
CMODEL14403 a_0_n23917.n0 vdd.n46 0.00712079969142623f
CMODEL14404 a_0_n23917.t0 vdd 9.46003304899638e-07f
CMODEL14405 a_0_n23917.t0 vdd.n0 0.000317461105446514f
CMODEL14406 a_0_n23917.t0 vdd.n1 2.94193612472435e-05f
CMODEL14407 a_0_n23917.t0 vdd.t7 2.42522628457055e-06f
CMODEL14408 a_0_n23917.t0 vdd.t6 1.91701572149511e-05f
CMODEL14409 a_0_n23917.t0 vdd.n2 2.63815250201999e-05f
CMODEL14410 a_0_n23917.t0 vdd.t27 2.42522628457055e-06f
CMODEL14411 a_0_n23917.t0 vdd.t26 1.91701572149511e-05f
CMODEL14412 a_0_n23917.t0 vdd.n3 4.94819647699478e-05f
CMODEL14413 a_0_n23917.t0 vdd.n4 2.63815250201999e-05f
CMODEL14414 a_0_n23917.t0 vdd.t36 2.42522628457055e-06f
CMODEL14415 a_0_n23917.t0 vdd.t35 1.91701572149511e-05f
CMODEL14416 a_0_n23917.t0 vdd.n5 3.76422896406799e-05f
CMODEL14417 a_0_n23917.t0 vdd.t3 3.86323909981887e-06f
CMODEL14418 a_0_n23917.t0 vdd.n6 3.6961636609626e-05f
CMODEL14419 a_0_n23917.t0 vdd.t2 4.84407700060609e-05f
CMODEL14420 a_0_n23917.t0 vdd.n7 4.95486083434844e-05f
CMODEL14421 a_0_n23917.t0 vdd.t25 3.86323909981887e-06f
CMODEL14422 a_0_n23917.t0 vdd.n8 2.2325152844272e-05f
CMODEL14423 a_0_n23917.t0 vdd.t24 4.84407700060609e-05f
CMODEL14424 a_0_n23917.t0 vdd.n9 4.95486083434844e-05f
CMODEL14425 a_0_n23917.t0 vdd.t5 3.86323909981887e-06f
CMODEL14426 a_0_n23917.t0 vdd.n10 6.61068706243889e-05f
CMODEL14427 a_0_n23917.t0 vdd.t4 4.84674274354755e-05f
CMODEL14428 a_0_n23917.t0 vdd.n11 0.000159835281027249f
CMODEL14429 a_0_n23917.t0 vdd.n12 0.000394094550656255f
CMODEL14430 a_0_n23917.t0 vdd.n13 2.9871871111557e-05f
CMODEL14431 a_0_n23917.t0 vdd.t42 2.42522628457055e-06f
CMODEL14432 a_0_n23917.t0 vdd.t41 1.91701572149511e-05f
CMODEL14433 a_0_n23917.t0 vdd.n14 2.68571379900062e-05f
CMODEL14434 a_0_n23917.t0 vdd.t9 2.42522628457055e-06f
CMODEL14435 a_0_n23917.t0 vdd.t8 1.91701572149511e-05f
CMODEL14436 a_0_n23917.t0 vdd.n15 5.15621328452703e-05f
CMODEL14437 a_0_n23917.t0 vdd.t15 4.08431804776429e-06f
CMODEL14438 a_0_n23917.t0 vdd.n16 3.21264232043003e-05f
CMODEL14439 a_0_n23917.t0 vdd.t14 5.50949086784457e-05f
CMODEL14440 a_0_n23917.t0 vdd.n17 4.50021837568173e-05f
CMODEL14441 a_0_n23917.t0 vdd.t32 5.50949086784457e-05f
CMODEL14442 a_0_n23917.t0 vdd.n18 4.44232732480293e-05f
CMODEL14443 a_0_n23917.t0 vdd.t34 4.08431804776429e-06f
CMODEL14444 a_0_n23917.t0 vdd.n19 4.47347208816904e-05f
CMODEL14445 a_0_n23917.t0 vdd.t33 5.50949086784457e-05f
CMODEL14446 a_0_n23917.t0 vdd.n20 8.92746203834087e-05f
CMODEL14447 a_0_n23917.t0 vdd.t48 5.52002055246335e-05f
CMODEL14448 a_0_n23917.t0 vdd.n21 0.00015847219780318f
CMODEL14449 a_0_n23917.t0 vdd.n22 0.000694483794015142f
CMODEL14450 a_0_n23917.t0 vdd.t47 7.85165704526399e-07f
CMODEL14451 a_0_n23917.t0 vdd.t45 7.77104053580921e-07f
CMODEL14452 a_0_n23917.t0 vdd.n23 8.87363624544781e-06f
CMODEL14453 a_0_n23917.t0 vdd.t46 2.11774172208246e-05f
CMODEL14454 a_0_n23917.t0 vdd.n24 2.27532267316221e-05f
CMODEL14455 a_0_n23917.t0 vdd.t44 2.11774172208246e-05f
CMODEL14456 a_0_n23917.t0 vdd.n25 3.58840100255391e-05f
CMODEL14457 a_0_n23917.t0 vdd.t43 2.12232902139423e-05f
CMODEL14458 a_0_n23917.t0 vdd.n26 0.000191999691068465f
CMODEL14459 a_0_n23917.t0 vdd.n27 0.000128355744776744f
CMODEL14460 a_0_n23917.t0 vdd.n28 2.89932866670994e-05f
CMODEL14461 a_0_n23917.t0 vdd.t29 2.42522628457055e-06f
CMODEL14462 a_0_n23917.t0 vdd.t28 1.91701572149511e-05f
CMODEL14463 a_0_n23917.t0 vdd.n29 4.32796695261412e-06f
CMODEL14464 a_0_n23917.t0 vdd.n30 1.38071711362645e-06f
CMODEL14465 a_0_n23917.t0 vdd.t38 6.35713047965663e-07f
CMODEL14466 a_0_n23917.t0 vdd.t40 6.35713047965663e-07f
CMODEL14467 a_0_n23917.t0 vdd.t37 1.28458598025235e-05f
CMODEL14468 a_0_n23917.t0 vdd.t39 1.28458598025235e-05f
CMODEL14469 a_0_n23917.t0 vdd.n31 4.16046943779212e-06f
CMODEL14470 a_0_n23917.t0 vdd.n32 5.02081575762516e-05f
CMODEL14471 a_0_n23917.t0 vdd.n33 2.54405177618631e-05f
CMODEL14472 a_0_n23917.t0 vdd.t17 2.42522628457055e-06f
CMODEL14473 a_0_n23917.t0 vdd.t16 1.91701572149511e-05f
CMODEL14474 a_0_n23917.t0 vdd.n34 4.32796695261412e-06f
CMODEL14475 a_0_n23917.t0 vdd.n35 1.38071711362645e-06f
CMODEL14476 a_0_n23917.t0 vdd.t1 6.35713047965663e-07f
CMODEL14477 a_0_n23917.t0 vdd.t31 6.35713047965663e-07f
CMODEL14478 a_0_n23917.t0 vdd.t0 1.28458598025235e-05f
CMODEL14479 a_0_n23917.t0 vdd.t30 1.28458598025235e-05f
CMODEL14480 a_0_n23917.t0 vdd.n36 4.16046943779212e-06f
CMODEL14481 a_0_n23917.t0 vdd.n37 4.86920162782939e-05f
CMODEL14482 a_0_n23917.t0 vdd.n38 2.80878226479821e-05f
CMODEL14483 a_0_n23917.t0 vdd.t19 2.42522628457055e-06f
CMODEL14484 a_0_n23917.t0 vdd.t18 1.91701572149511e-05f
CMODEL14485 a_0_n23917.t0 vdd.n39 2.37022312187834e-05f
CMODEL14486 a_0_n23917.t0 vdd.t21 2.42524849909506e-06f
CMODEL14487 a_0_n23917.t0 vdd.t20 1.91701572149511e-05f
CMODEL14488 a_0_n23917.t0 vdd.n40 2.37022312187834e-05f
CMODEL14489 a_0_n23917.t0 vdd.t11 2.42522628457055e-06f
CMODEL14490 a_0_n23917.t0 vdd.t10 1.91701572149511e-05f
CMODEL14491 a_0_n23917.t0 vdd.n41 0.000101971331868357f
CMODEL14492 a_0_n23917.t0 vdd.n42 0.000195325871823677f
CMODEL14493 a_0_n23917.t0 vdd.n43 2.37022312187834e-05f
CMODEL14494 a_0_n23917.t0 vdd.t13 2.42522628457055e-06f
CMODEL14495 a_0_n23917.t0 vdd.t12 1.91701572149511e-05f
CMODEL14496 a_0_n23917.t0 vdd.n44 2.37022312187834e-05f
CMODEL14497 a_0_n23917.t0 vdd.t23 2.42522628457055e-06f
CMODEL14498 a_0_n23917.t0 vdd.t22 1.91701572149511e-05f
CMODEL14499 a_0_n23917.t0 vdd.n45 2.92594166707556e-05f
CMODEL14500 a_0_n23917.t0 vdd.n46 0.000482957091609962f
CMODEL14501 a_0_n23917.t3 vdd 2.73662845657666e-06f
CMODEL14502 a_0_n23917.t3 vdd.n0 0.000918361585547931f
CMODEL14503 a_0_n23917.t3 vdd.n1 8.51052641640151e-05f
CMODEL14504 a_0_n23917.t3 vdd.t7 7.01577175219018e-06f
CMODEL14505 a_0_n23917.t3 vdd.t6 5.54560406710728e-05f
CMODEL14506 a_0_n23917.t3 vdd.n2 7.63173148806575e-05f
CMODEL14507 a_0_n23917.t3 vdd.t27 7.01577175219018e-06f
CMODEL14508 a_0_n23917.t3 vdd.t26 5.54560406710728e-05f
CMODEL14509 a_0_n23917.t3 vdd.n3 0.000143143001906456f
CMODEL14510 a_0_n23917.t3 vdd.n4 7.63173148806575e-05f
CMODEL14511 a_0_n23917.t3 vdd.t36 7.01577175219018e-06f
CMODEL14512 a_0_n23917.t3 vdd.t35 5.54560406710728e-05f
CMODEL14513 a_0_n23917.t3 vdd.n5 0.000108892813024912f
CMODEL14514 a_0_n23917.t3 vdd.t3 1.11757009731013e-05f
CMODEL14515 a_0_n23917.t3 vdd.n6 0.000106923798282374f
CMODEL14516 a_0_n23917.t3 vdd.t2 0.000140131000568899f
CMODEL14517 a_0_n23917.t3 vdd.n7 0.000143335790556183f
CMODEL14518 a_0_n23917.t3 vdd.t25 1.11757009731013e-05f
CMODEL14519 a_0_n23917.t3 vdd.n8 6.45829124006493e-05f
CMODEL14520 a_0_n23917.t3 vdd.t24 0.000140131000568899f
CMODEL14521 a_0_n23917.t3 vdd.n9 0.000143335790556183f
CMODEL14522 a_0_n23917.t3 vdd.t5 1.11757009731013e-05f
CMODEL14523 a_0_n23917.t3 vdd.n10 0.000191236058467182f
CMODEL14524 a_0_n23917.t3 vdd.t4 0.000140208116028789f
CMODEL14525 a_0_n23917.t3 vdd.n11 0.000462376585957595f
CMODEL14526 a_0_n23917.t3 vdd.n12 0.00114004925386822f
CMODEL14527 a_0_n23917.t3 vdd.n13 8.64142990956568e-05f
CMODEL14528 a_0_n23917.t3 vdd.t42 7.01577175219018e-06f
CMODEL14529 a_0_n23917.t3 vdd.t41 5.54560406710728e-05f
CMODEL14530 a_0_n23917.t3 vdd.n14 7.76931832108709e-05f
CMODEL14531 a_0_n23917.t3 vdd.t9 7.01577175219018e-06f
CMODEL14532 a_0_n23917.t3 vdd.t8 5.54560406710728e-05f
CMODEL14533 a_0_n23917.t3 vdd.n15 0.000149160578293247f
CMODEL14534 a_0_n23917.t3 vdd.t15 1.18152451871267e-05f
CMODEL14535 a_0_n23917.t3 vdd.n16 9.29363391158979e-05f
CMODEL14536 a_0_n23917.t3 vdd.t14 0.000159380304615239f
CMODEL14537 a_0_n23917.t3 vdd.n17 0.000130183748871854f
CMODEL14538 a_0_n23917.t3 vdd.t32 0.000159380304615239f
CMODEL14539 a_0_n23917.t3 vdd.n18 0.000128509058134564f
CMODEL14540 a_0_n23917.t3 vdd.t34 1.18152451871267e-05f
CMODEL14541 a_0_n23917.t3 vdd.n19 0.000129410023757619f
CMODEL14542 a_0_n23917.t3 vdd.t33 0.000159380304615239f
CMODEL14543 a_0_n23917.t3 vdd.n20 0.000258256462029204f
CMODEL14544 a_0_n23917.t3 vdd.t48 0.000159684910681806f
CMODEL14545 a_0_n23917.t3 vdd.n21 0.00045843341544186f
CMODEL14546 a_0_n23917.t3 vdd.n22 0.00200902481364459f
CMODEL14547 a_0_n23917.t3 vdd.t47 2.27135232932718e-06f
CMODEL14548 a_0_n23917.t3 vdd.t45 2.24803132899862e-06f
CMODEL14549 a_0_n23917.t3 vdd.n23 2.56699372368248e-05f
CMODEL14550 a_0_n23917.t3 vdd.t46 6.12627062750628e-05f
CMODEL14551 a_0_n23917.t3 vdd.n24 6.58212581607247e-05f
CMODEL14552 a_0_n23917.t3 vdd.t44 6.12627062750628e-05f
CMODEL14553 a_0_n23917.t3 vdd.n25 0.0001038064058163f
CMODEL14554 a_0_n23917.t3 vdd.t43 6.13954091289578e-05f
CMODEL14555 a_0_n23917.t3 vdd.n26 0.000555422814603837f
CMODEL14556 a_0_n23917.t3 vdd.n27 0.000371311582001707f
CMODEL14557 a_0_n23917.t3 vdd.n28 8.38727020634316e-05f
CMODEL14558 a_0_n23917.t3 vdd.t29 7.01577175219018e-06f
CMODEL14559 a_0_n23917.t3 vdd.t28 5.54560406710728e-05f
CMODEL14560 a_0_n23917.t3 vdd.n29 1.25200804905261e-05f
CMODEL14561 a_0_n23917.t3 vdd.n30 3.99418239245306e-06f
CMODEL14562 a_0_n23917.t3 vdd.t38 1.83901092973928e-06f
CMODEL14563 a_0_n23917.t3 vdd.t40 1.83901092973928e-06f
CMODEL14564 a_0_n23917.t3 vdd.t37 3.71609119151118e-05f
CMODEL14565 a_0_n23917.t3 vdd.t39 3.71609119151118e-05f
CMODEL14566 a_0_n23917.t3 vdd.n31 1.20355383508806e-05f
CMODEL14567 a_0_n23917.t3 vdd.n32 0.000145243755559641f
CMODEL14568 a_0_n23917.t3 vdd.n33 7.3595139146522e-05f
CMODEL14569 a_0_n23917.t3 vdd.t17 7.01577175219018e-06f
CMODEL14570 a_0_n23917.t3 vdd.t16 5.54560406710728e-05f
CMODEL14571 a_0_n23917.t3 vdd.n34 1.25200804905261e-05f
CMODEL14572 a_0_n23917.t3 vdd.n35 3.99418239245306e-06f
CMODEL14573 a_0_n23917.t3 vdd.t1 1.83901092973928e-06f
CMODEL14574 a_0_n23917.t3 vdd.t31 1.83901092973928e-06f
CMODEL14575 a_0_n23917.t3 vdd.t0 3.71609119151118e-05f
CMODEL14576 a_0_n23917.t3 vdd.t30 3.71609119151118e-05f
CMODEL14577 a_0_n23917.t3 vdd.n36 1.20355383508806e-05f
CMODEL14578 a_0_n23917.t3 vdd.n37 0.000140857813778367f
CMODEL14579 a_0_n23917.t3 vdd.n38 8.12533469424835e-05f
CMODEL14580 a_0_n23917.t3 vdd.t19 7.01577175219018e-06f
CMODEL14581 a_0_n23917.t3 vdd.t18 5.54560406710728e-05f
CMODEL14582 a_0_n23917.t3 vdd.n39 6.85665685328274e-05f
CMODEL14583 a_0_n23917.t3 vdd.t21 7.01583601507343e-06f
CMODEL14584 a_0_n23917.t3 vdd.t20 5.54560406710728e-05f
CMODEL14585 a_0_n23917.t3 vdd.n40 6.85665685328274e-05f
CMODEL14586 a_0_n23917.t3 vdd.t11 7.01577175219018e-06f
CMODEL14587 a_0_n23917.t3 vdd.t10 5.54560406710728e-05f
CMODEL14588 a_0_n23917.t3 vdd.n41 0.000294985912946228f
CMODEL14589 a_0_n23917.t3 vdd.n42 0.000565044896111677f
CMODEL14590 a_0_n23917.t3 vdd.n43 6.85665685328274e-05f
CMODEL14591 a_0_n23917.t3 vdd.t13 7.01577175219018e-06f
CMODEL14592 a_0_n23917.t3 vdd.t12 5.54560406710728e-05f
CMODEL14593 a_0_n23917.t3 vdd.n44 6.85665685328274e-05f
CMODEL14594 a_0_n23917.t3 vdd.t23 7.01577175219018e-06f
CMODEL14595 a_0_n23917.t3 vdd.t22 5.54560406710728e-05f
CMODEL14596 a_0_n23917.t3 vdd.n45 8.4642571404672e-05f
CMODEL14597 a_0_n23917.t3 vdd.n46 0.00139711363941328f
CMODEL14598 a_0_n23917.n1 vdd 0.000114753621448305f
CMODEL14599 a_0_n23917.n1 vdd.n0 0.0385091799682819f
CMODEL14600 a_0_n23917.n1 vdd.n1 0.00356867489397964f
CMODEL14601 a_0_n23917.n1 vdd.t7 0.000294188717465012f
CMODEL14602 a_0_n23917.n1 vdd.t6 0.00232540938573399f
CMODEL14603 a_0_n23917.n1 vdd.n2 0.00320017437541424f
CMODEL14604 a_0_n23917.n1 vdd.t27 0.000294188717465012f
CMODEL14605 a_0_n23917.n1 vdd.t26 0.00232540938573399f
CMODEL14606 a_0_n23917.n1 vdd.n3 0.00600234124375637f
CMODEL14607 a_0_n23917.n1 vdd.n4 0.00320017437541424f
CMODEL14608 a_0_n23917.n1 vdd.t36 0.000294188717465012f
CMODEL14609 a_0_n23917.n1 vdd.t35 0.00232540938573399f
CMODEL14610 a_0_n23917.n1 vdd.n5 0.00456614584061341f
CMODEL14611 a_0_n23917.n1 vdd.t3 0.000468624871529319f
CMODEL14612 a_0_n23917.n1 vdd.n6 0.00448358016683758f
CMODEL14613 a_0_n23917.n1 vdd.t2 0.00587604055413912f
CMODEL14614 a_0_n23917.n1 vdd.n7 0.00601042535019657f
CMODEL14615 a_0_n23917.n1 vdd.t25 0.000468624871529319f
CMODEL14616 a_0_n23917.n1 vdd.n8 0.00270812176342124f
CMODEL14617 a_0_n23917.n1 vdd.t24 0.00587604055413912f
CMODEL14618 a_0_n23917.n1 vdd.n9 0.00601042535019657f
CMODEL14619 a_0_n23917.n1 vdd.t5 0.000468624871529319f
CMODEL14620 a_0_n23917.n1 vdd.n10 0.00801900243632657f
CMODEL14621 a_0_n23917.n1 vdd.t4 0.00587927419671519f
CMODEL14622 a_0_n23917.n1 vdd.n11 0.0193885975218979f
CMODEL14623 a_0_n23917.n1 vdd.n12 0.0478050939638582f
CMODEL14624 a_0_n23917.n1 vdd.n13 0.00362356597670854f
CMODEL14625 a_0_n23917.n1 vdd.t42 0.000294188717465012f
CMODEL14626 a_0_n23917.n1 vdd.t41 0.00232540938573399f
CMODEL14627 a_0_n23917.n1 vdd.n14 0.00325786794837574f
CMODEL14628 a_0_n23917.n1 vdd.t9 0.000294188717465012f
CMODEL14629 a_0_n23917.n1 vdd.t8 0.00232540938573399f
CMODEL14630 a_0_n23917.n1 vdd.n15 0.00625467315277622f
CMODEL14631 a_0_n23917.n1 vdd.t15 0.000495442547293581f
CMODEL14632 a_0_n23917.n1 vdd.n16 0.00389705129758022f
CMODEL14633 a_0_n23917.n1 vdd.t14 0.00668321163517078f
CMODEL14634 a_0_n23917.n1 vdd.n17 0.0054589276088467f
CMODEL14635 a_0_n23917.n1 vdd.t32 0.00668321163517078f
CMODEL14636 a_0_n23917.n1 vdd.n18 0.0053887036709029f
CMODEL14637 a_0_n23917.n1 vdd.t34 0.000495442547293581f
CMODEL14638 a_0_n23917.n1 vdd.n19 0.00542648339500006f
CMODEL14639 a_0_n23917.n1 vdd.t33 0.00668321163517078f
CMODEL14640 a_0_n23917.n1 vdd.n20 0.0108293342521733f
CMODEL14641 a_0_n23917.n1 vdd.t48 0.00669598452334628f
CMODEL14642 a_0_n23917.n1 vdd.n21 0.0192232505981745f
CMODEL14643 a_0_n23917.n1 vdd.n22 0.0842433953323777f
CMODEL14644 a_0_n23917.n1 vdd.t47 9.52434389655464e-05f
CMODEL14645 a_0_n23917.n1 vdd.t45 9.42655315564979e-05f
CMODEL14646 a_0_n23917.n1 vdd.n23 0.0010764041619158f
CMODEL14647 a_0_n23917.n1 vdd.t46 0.00256889728230826f
CMODEL14648 a_0_n23917.n1 vdd.n24 0.00276004867378874f
CMODEL14649 a_0_n23917.n1 vdd.t44 0.00256889728230826f
CMODEL14650 a_0_n23917.n1 vdd.n25 0.00435286016569969f
CMODEL14651 a_0_n23917.n1 vdd.t43 0.00257446184224126f
CMODEL14652 a_0_n23917.n1 vdd.n26 0.023290256760149f
CMODEL14653 a_0_n23917.n1 vdd.n27 0.0155700159508304f
CMODEL14654 a_0_n23917.n1 vdd.n28 0.00351699050680534f
CMODEL14655 a_0_n23917.n1 vdd.t29 0.000294188717465012f
CMODEL14656 a_0_n23917.n1 vdd.t28 0.00232540938573399f
CMODEL14657 a_0_n23917.n1 vdd.n29 0.000524998040438921f
CMODEL14658 a_0_n23917.n1 vdd.n30 0.00016748597828746f
CMODEL14659 a_0_n23917.n1 vdd.t38 7.71142913329874e-05f
CMODEL14660 a_0_n23917.n1 vdd.t40 7.71142913329874e-05f
CMODEL14661 a_0_n23917.n1 vdd.t37 0.00155824924217698f
CMODEL14662 a_0_n23917.n1 vdd.t39 0.00155824924217698f
CMODEL14663 a_0_n23917.n1 vdd.n31 0.000504679986252573f
CMODEL14664 a_0_n23917.n1 vdd.n32 0.006090431056933f
CMODEL14665 a_0_n23917.n1 vdd.n33 0.00308602679247873f
CMODEL14666 a_0_n23917.n1 vdd.t17 0.000294188717465012f
CMODEL14667 a_0_n23917.n1 vdd.t16 0.00232540938573399f
CMODEL14668 a_0_n23917.n1 vdd.n34 0.000524998040438921f
CMODEL14669 a_0_n23917.n1 vdd.n35 0.00016748597828746f
CMODEL14670 a_0_n23917.n1 vdd.t1 7.71142913329874e-05f
CMODEL14671 a_0_n23917.n1 vdd.t31 7.71142913329874e-05f
CMODEL14672 a_0_n23917.n1 vdd.t0 0.00155824924217698f
CMODEL14673 a_0_n23917.n1 vdd.t30 0.00155824924217698f
CMODEL14674 a_0_n23917.n1 vdd.n36 0.000504679986252573f
CMODEL14675 a_0_n23917.n1 vdd.n37 0.00590651763541864f
CMODEL14676 a_0_n23917.n1 vdd.n38 0.00340715444730461f
CMODEL14677 a_0_n23917.n1 vdd.t19 0.000294188717465012f
CMODEL14678 a_0_n23917.n1 vdd.t18 0.00232540938573399f
CMODEL14679 a_0_n23917.n1 vdd.n39 0.00287516634949707f
CMODEL14680 a_0_n23917.n1 vdd.t21 0.000294191412167158f
CMODEL14681 a_0_n23917.n1 vdd.t20 0.00232540938573399f
CMODEL14682 a_0_n23917.n1 vdd.n40 0.00287516634949707f
CMODEL14683 a_0_n23917.n1 vdd.t11 0.000294188717465012f
CMODEL14684 a_0_n23917.n1 vdd.t10 0.00232540938573399f
CMODEL14685 a_0_n23917.n1 vdd.n41 0.0123694912641371f
CMODEL14686 a_0_n23917.n1 vdd.n42 0.023693734512579f
CMODEL14687 a_0_n23917.n1 vdd.n43 0.00287516634949707f
CMODEL14688 a_0_n23917.n1 vdd.t13 0.000294188717465012f
CMODEL14689 a_0_n23917.n1 vdd.t12 0.00232540938573399f
CMODEL14690 a_0_n23917.n1 vdd.n44 0.00287516634949707f
CMODEL14691 a_0_n23917.n1 vdd.t23 0.000294188717465012f
CMODEL14692 a_0_n23917.n1 vdd.t22 0.00232540938573399f
CMODEL14693 a_0_n23917.n1 vdd.n45 0.00354927303852318f
CMODEL14694 a_0_n23917.n1 vdd.n46 0.0585844414912097f
CMODEL14695 a_0_n23917.t2 vdd 2.04142923717942e-06f
CMODEL14696 a_0_n23917.t2 vdd.n0 0.000685065664114744f
CMODEL14697 a_0_n23917.t2 vdd.n1 6.34855543085418e-05f
CMODEL14698 a_0_n23917.t2 vdd.t7 5.2335206636763e-06f
CMODEL14699 a_0_n23917.t2 vdd.t6 4.13682692409611e-05f
CMODEL14700 a_0_n23917.t2 vdd.n2 5.69300511094199e-05f
CMODEL14701 a_0_n23917.t2 vdd.t27 5.2335206636763e-06f
CMODEL14702 a_0_n23917.t2 vdd.t26 4.13682692409611e-05f
CMODEL14703 a_0_n23917.t2 vdd.n3 0.000106779679385127f
CMODEL14704 a_0_n23917.t2 vdd.n4 5.69300511094199e-05f
CMODEL14705 a_0_n23917.t2 vdd.t36 5.2335206636763e-06f
CMODEL14706 a_0_n23917.t2 vdd.t35 4.13682692409611e-05f
CMODEL14707 a_0_n23917.t2 vdd.n5 8.12302348510425e-05f
CMODEL14708 a_0_n23917.t2 vdd.t3 8.33668255463614e-06f
CMODEL14709 a_0_n23917.t2 vdd.n6 7.97614186315098e-05f
CMODEL14710 a_0_n23917.t2 vdd.t2 0.00010453283159761f
CMODEL14711 a_0_n23917.t2 vdd.n7 0.000106923492983645f
CMODEL14712 a_0_n23917.t2 vdd.t25 8.33668255463614e-06f
CMODEL14713 a_0_n23917.t2 vdd.n8 4.8176596746278e-05f
CMODEL14714 a_0_n23917.t2 vdd.t24 0.00010453283159761f
CMODEL14715 a_0_n23917.t2 vdd.n9 0.000106923492983645f
CMODEL14716 a_0_n23917.t2 vdd.t5 8.33668255463614e-06f
CMODEL14717 a_0_n23917.t2 vdd.n10 0.00014265541967148f
CMODEL14718 a_0_n23917.t2 vdd.t4 0.000104590357037018f
CMODEL14719 a_0_n23917.t2 vdd.n11 0.000344916782142142f
CMODEL14720 a_0_n23917.t2 vdd.n12 0.000850436921050838f
CMODEL14721 a_0_n23917.t2 vdd.n13 6.44620486424805e-05f
CMODEL14722 a_0_n23917.t2 vdd.t42 5.2335206636763e-06f
CMODEL14723 a_0_n23917.t2 vdd.t41 4.13682692409611e-05f
CMODEL14724 a_0_n23917.t2 vdd.n14 5.79564008241783e-05f
CMODEL14725 a_0_n23917.t2 vdd.t9 5.2335206636763e-06f
CMODEL14726 a_0_n23917.t2 vdd.t8 4.13682692409611e-05f
CMODEL14727 a_0_n23917.t2 vdd.n15 0.000111268581173542f
CMODEL14728 a_0_n23917.t2 vdd.t15 8.81376019878723e-06f
CMODEL14729 a_0_n23917.t2 vdd.n16 6.93272626803517e-05f
CMODEL14730 a_0_n23917.t2 vdd.t14 0.000118892140030992f
CMODEL14731 a_0_n23917.t2 vdd.n17 9.71125292927322e-05f
CMODEL14732 a_0_n23917.t2 vdd.t32 0.000118892140030992f
CMODEL14733 a_0_n23917.t2 vdd.n18 9.58632685002707e-05f
CMODEL14734 a_0_n23917.t2 vdd.t34 8.81376019878723e-06f
CMODEL14735 a_0_n23917.t2 vdd.n19 9.65353573840125e-05f
CMODEL14736 a_0_n23917.t2 vdd.t33 0.000118892140030992f
CMODEL14737 a_0_n23917.t2 vdd.n20 0.00019265029968169f
CMODEL14738 a_0_n23917.t2 vdd.t48 0.000119119365516651f
CMODEL14739 a_0_n23917.t2 vdd.n21 0.000341975314673783f
CMODEL14740 a_0_n23917.t2 vdd.n22 0.00149866233501183f
CMODEL14741 a_0_n23917.t2 vdd.t47 1.69434949851557e-06f
CMODEL14742 a_0_n23917.t2 vdd.t45 1.67695284688148e-06f
CMODEL14743 a_0_n23917.t2 vdd.n23 1.91488765184325e-05f
CMODEL14744 a_0_n23917.t2 vdd.t46 4.56998389525974e-05f
CMODEL14745 a_0_n23917.t2 vdd.n24 4.91003594274267e-05f
CMODEL14746 a_0_n23917.t2 vdd.t44 4.56998389525974e-05f
CMODEL14747 a_0_n23917.t2 vdd.n25 7.74359527434703e-05f
CMODEL14748 a_0_n23917.t2 vdd.t43 4.57988306462441e-05f
CMODEL14749 a_0_n23917.t2 vdd.n26 0.000414326018573649f
CMODEL14750 a_0_n23917.t2 vdd.n27 0.000276985470124741f
CMODEL14751 a_0_n23917.t2 vdd.n28 6.25661060353487e-05f
CMODEL14752 a_0_n23917.t2 vdd.t29 5.2335206636763e-06f
CMODEL14753 a_0_n23917.t2 vdd.t28 4.13682692409611e-05f
CMODEL14754 a_0_n23917.t2 vdd.n29 9.33954271496981e-06f
CMODEL14755 a_0_n23917.t2 vdd.n30 2.97952054652711e-06f
CMODEL14756 a_0_n23917.t2 vdd.t38 1.37183791626524e-06f
CMODEL14757 a_0_n23917.t2 vdd.t40 1.37183791626524e-06f
CMODEL14758 a_0_n23917.t2 vdd.t37 2.7720742244512e-05f
CMODEL14759 a_0_n23917.t2 vdd.t39 2.7720742244512e-05f
CMODEL14760 a_0_n23917.t2 vdd.n31 8.97809120402737e-06f
CMODEL14761 a_0_n23917.t2 vdd.n32 0.000108346768230313f
CMODEL14762 a_0_n23917.t2 vdd.n33 5.48994030983428e-05f
CMODEL14763 a_0_n23917.t2 vdd.t17 5.2335206636763e-06f
CMODEL14764 a_0_n23917.t2 vdd.t16 4.13682692409611e-05f
CMODEL14765 a_0_n23917.t2 vdd.n34 9.33954271496981e-06f
CMODEL14766 a_0_n23917.t2 vdd.n35 2.97952054652711e-06f
CMODEL14767 a_0_n23917.t2 vdd.t1 1.37183791626524e-06f
CMODEL14768 a_0_n23917.t2 vdd.t31 1.37183791626524e-06f
CMODEL14769 a_0_n23917.t2 vdd.t0 2.7720742244512e-05f
CMODEL14770 a_0_n23917.t2 vdd.t30 2.7720742244512e-05f
CMODEL14771 a_0_n23917.t2 vdd.n36 8.97809120402737e-06f
CMODEL14772 a_0_n23917.t2 vdd.n37 0.000105075008864024f
CMODEL14773 a_0_n23917.t2 vdd.n38 6.06121586101479e-05f
CMODEL14774 a_0_n23917.t2 vdd.t19 5.2335206636763e-06f
CMODEL14775 a_0_n23917.t2 vdd.t18 4.13682692409611e-05f
CMODEL14776 a_0_n23917.t2 vdd.n39 5.1148265070326e-05f
CMODEL14777 a_0_n23917.t2 vdd.t21 5.23356860154248e-06f
CMODEL14778 a_0_n23917.t2 vdd.t20 4.13682692409611e-05f
CMODEL14779 a_0_n23917.t2 vdd.n40 5.1148265070326e-05f
CMODEL14780 a_0_n23917.t2 vdd.t11 5.2335206636763e-06f
CMODEL14781 a_0_n23917.t2 vdd.t10 4.13682692409611e-05f
CMODEL14782 a_0_n23917.t2 vdd.n41 0.000220049187092718f
CMODEL14783 a_0_n23917.t2 vdd.n42 0.000421503755275693f
CMODEL14784 a_0_n23917.t2 vdd.n43 5.1148265070326e-05f
CMODEL14785 a_0_n23917.t2 vdd.t13 5.2335206636763e-06f
CMODEL14786 a_0_n23917.t2 vdd.t12 4.13682692409611e-05f
CMODEL14787 a_0_n23917.t2 vdd.n44 5.1148265070326e-05f
CMODEL14788 a_0_n23917.t2 vdd.t23 5.2335206636763e-06f
CMODEL14789 a_0_n23917.t2 vdd.t22 4.13682692409611e-05f
CMODEL14790 a_0_n23917.t2 vdd.n45 6.31404016720981e-05f
CMODEL14791 a_0_n23917.t2 vdd.n46 0.00104219797331502f
CMODEL14792 a_9600_83.t0 en 6.51476913894145e-07f
CMODEL14793 a_9600_83.t0 en.t3 4.93980879857672e-06f
CMODEL14794 a_9600_83.t0 en.t1 4.44634385400296e-06f
CMODEL14795 a_9600_83.t0 en.n0 0.000177686754055062f
CMODEL14796 a_9600_83.t0 en.t0 6.08077252446077e-06f
CMODEL14797 a_9600_83.t0 en.t2 4.44634385400296e-06f
CMODEL14798 a_9600_83.t1 en 6.51476913894145e-07f
CMODEL14799 a_9600_83.t1 en.t3 4.93980879857672e-06f
CMODEL14800 a_9600_83.t1 en.t1 4.44634385400296e-06f
CMODEL14801 a_9600_83.t1 en.n0 0.000177686754055062f
CMODEL14802 a_9600_83.t1 en.t0 6.08077252446077e-06f
CMODEL14803 a_9600_83.t1 en.t2 4.44634385400296e-06f
CMODEL14804 a_0_n35917.t1 a_n104_n35959.t0 0.00116365036748777f
CMODEL14805 a_0_n35917.t1 a_n104_n35959.t3 0.00101548986026353f
CMODEL14806 a_0_n35917.t1 a_n104_n35959.t4 0.000407148082187373f
CMODEL14807 a_0_n35917.t1 a_n104_n35959.t2 0.000557267767692417f
CMODEL14808 a_0_n35917.t1 a_n104_n35959.n0 0.0415996348012211f
CMODEL14809 a_0_n35917.t1 a_n104_n35959.t1 0.00103128738033584f
CMODEL14810 a_0_n35917.t1 a_n104_n35959.n1 0.0194332811486997f
CMODEL14811 a_0_n35917.n0 a_n104_n35959.t0 0.0144940904518923f
CMODEL14812 a_0_n35917.n0 a_n104_n35959.t3 0.0126486462762999f
CMODEL14813 a_0_n35917.n0 a_n104_n35959.t4 0.00507131806547578f
CMODEL14814 a_0_n35917.n0 a_n104_n35959.t2 0.00694116519577594f
CMODEL14815 a_0_n35917.n0 a_n104_n35959.n0 0.518152949048007f
CMODEL14816 a_0_n35917.n0 a_n104_n35959.t1 0.0128454155905553f
CMODEL14817 a_0_n35917.n0 a_n104_n35959.n1 0.242055296518666f
CMODEL14818 a_0_n35917.t0 a_n104_n35959.t0 0.000264176740013326f
CMODEL14819 a_0_n35917.t0 a_n104_n35959.t3 0.00023054072623221f
CMODEL14820 a_0_n35917.t0 a_n104_n35959.t4 9.2432448835254e-05f
CMODEL14821 a_0_n35917.t0 a_n104_n35959.t2 0.00012651324340774f
CMODEL14822 a_0_n35917.t0 a_n104_n35959.n0 0.00944412188968521f
CMODEL14823 a_0_n35917.t0 a_n104_n35959.t1 0.000234127144858973f
CMODEL14824 a_0_n35917.t0 a_n104_n35959.n1 0.00441182420859749f
CMODEL14825 a_0_n35917.t2 a_n104_n35959.t0 0.0018529599015319f
CMODEL14826 a_0_n35917.t2 a_n104_n35959.t3 0.00161703381363847f
CMODEL14827 a_0_n35917.t2 a_n104_n35959.t4 0.000648329679908553f
CMODEL14828 a_0_n35917.t2 a_n104_n35959.t2 0.000887375501096204f
CMODEL14829 a_0_n35917.t2 a_n104_n35959.n0 0.0662419377492645f
CMODEL14830 a_0_n35917.t2 a_n104_n35959.t1 0.00164218928306082f
CMODEL14831 a_0_n35917.t2 a_n104_n35959.n1 0.0309449399319807f
CMODEL14832 a_0_n35917.t3 a_n104_n35959.t0 0.000444255560580278f
CMODEL14833 a_0_n35917.t3 a_n104_n35959.t3 0.000387691208407328f
CMODEL14834 a_0_n35917.t3 a_n104_n35959.t4 0.000155439988286032f
CMODEL14835 a_0_n35917.t3 a_n104_n35959.t2 0.000212752310699645f
CMODEL14836 a_0_n35917.t3 a_n104_n35959.n0 0.0158818057338392f
CMODEL14837 a_0_n35917.t3 a_n104_n35959.t1 0.000393722346566682f
CMODEL14838 a_0_n35917.t3 a_n104_n35959.n1 0.00741919003494876f
CMODEL14839 a_0_n11917.t2 a_1600_n11917.t5 0.000103034974940638f
CMODEL14840 a_0_n11917.t2 a_1600_n11917.t4 0.000163776824737156f
CMODEL14841 a_0_n11917.t2 a_1600_n11917.n0 0.00285116875998681f
CMODEL14842 a_0_n11917.t2 a_1600_n11917.t6 0.000302354064510425f
CMODEL14843 a_0_n11917.t2 a_1600_n11917.n1 0.0167970744747762f
CMODEL14844 a_0_n11917.t2 a_1600_n11917.t2 2.11185664291532e-05f
CMODEL14845 a_0_n11917.t2 a_1600_n11917.t3 2.11185664291532e-05f
CMODEL14846 a_0_n11917.t2 a_1600_n11917.n2 0.00512293961569539f
CMODEL14847 a_0_n11917.t2 a_1600_n11917.t1 7.46097208474746e-05f
CMODEL14848 a_0_n11917.t2 a_1600_n11917.t0 0.000102547793152495f
CMODEL14849 a_0_n11917.t2 a_1600_n11917.n3 0.0142149498706658f
CMODEL14850 a_0_n11917.t2 a_1600_n11917.n4 0.020841355712813f
CMODEL14851 a_0_n11917.t1 a_1600_n11917.t5 0.000161183937202681f
CMODEL14852 a_0_n11917.t1 a_1600_n11917.t4 0.000256206142126953f
CMODEL14853 a_0_n11917.t1 a_1600_n11917.n0 0.00446025834071127f
CMODEL14854 a_0_n11917.t1 a_1600_n11917.t6 0.000472991026349074f
CMODEL14855 a_0_n11917.t1 a_1600_n11917.n1 0.0262766948688142f
CMODEL14856 a_0_n11917.t1 a_1600_n11917.t2 3.30370700540122e-05f
CMODEL14857 a_0_n11917.t1 a_1600_n11917.t3 3.30370700540122e-05f
CMODEL14858 a_0_n11917.t1 a_1600_n11917.n2 0.00801412896722791f
CMODEL14859 a_0_n11917.t1 a_1600_n11917.t1 0.00011671656703675f
CMODEL14860 a_0_n11917.t1 a_1600_n11917.t0 0.000160421808820627f
CMODEL14861 a_0_n11917.t1 a_1600_n11917.n3 0.0222373188192912f
CMODEL14862 a_0_n11917.t1 a_1600_n11917.n4 0.0326034123108991f
CMODEL14863 a_0_n11917.n0 a_1600_n11917.t5 0.00439519412584773f
CMODEL14864 a_0_n11917.n0 a_1600_n11917.t4 0.00698627760573008f
CMODEL14865 a_0_n11917.n0 a_1600_n11917.n0 0.121623169151197f
CMODEL14866 a_0_n11917.n0 a_1600_n11917.t6 0.0128976088850221f
CMODEL14867 a_0_n11917.n0 a_1600_n11917.n1 0.716517892157463f
CMODEL14868 a_0_n11917.n0 a_1600_n11917.t2 0.000900861083037248f
CMODEL14869 a_0_n11917.n0 a_1600_n11917.t3 0.000900861083037248f
CMODEL14870 a_0_n11917.n0 a_1600_n11917.n2 0.218530786453332f
CMODEL14871 a_0_n11917.n0 a_1600_n11917.t1 0.003182649454604f
CMODEL14872 a_0_n11917.n0 a_1600_n11917.t0 0.00437441226478839f
CMODEL14873 a_0_n11917.n0 a_1600_n11917.n3 0.606371421032183f
CMODEL14874 a_0_n11917.n0 a_1600_n11917.n4 0.88903602156873f
CMODEL14875 a_0_n11917.t6 a_1600_n11917.t5 0.000274616481346337f
CMODEL14876 a_0_n11917.t6 a_1600_n11917.t4 0.000436510178813607f
CMODEL14877 a_0_n11917.t6 a_1600_n11917.n0 0.00759914711527105f
CMODEL14878 a_0_n11917.t6 a_1600_n11917.t6 0.000805856548851042f
CMODEL14879 a_0_n11917.t6 a_1600_n11917.n1 0.0447688126467053f
CMODEL14880 a_0_n11917.t6 a_1600_n11917.t2 5.62867745364542e-05f
CMODEL14881 a_0_n11917.t6 a_1600_n11917.t3 5.62867745364542e-05f
CMODEL14882 a_0_n11917.t6 a_1600_n11917.n2 0.0136540398269864f
CMODEL14883 a_0_n11917.t6 a_1600_n11917.t1 0.000198855379206627f
CMODEL14884 a_0_n11917.t6 a_1600_n11917.t0 0.00027331800819668f
CMODEL14885 a_0_n11917.t6 a_1600_n11917.n3 0.0378867420334292f
CMODEL14886 a_0_n11917.t6 a_1600_n11917.n4 0.0555479319098928f
CMODEL14887 a_0_n11917.n1 a_1600_n11917.t5 0.0170393028436604f
CMODEL14888 a_0_n11917.n1 a_1600_n11917.t4 0.0270844236830967f
CMODEL14889 a_0_n11917.n1 a_1600_n11917.n0 0.47150909667119f
CMODEL14890 a_0_n11917.n1 a_1600_n11917.t6 0.0500014919610836f
CMODEL14891 a_0_n11917.n1 a_1600_n11917.n1 2.77779888846602f
CMODEL14892 a_0_n11917.n1 a_1600_n11917.t2 0.00349246116881787f
CMODEL14893 a_0_n11917.n1 a_1600_n11917.t3 0.00349246116881787f
CMODEL14894 a_0_n11917.n1 a_1600_n11917.n2 0.84720086176476f
CMODEL14895 a_0_n11917.n1 a_1600_n11917.t1 0.0123385057290839f
CMODEL14896 a_0_n11917.n1 a_1600_n11917.t0 0.016958735657296f
CMODEL14897 a_0_n11917.n1 a_1600_n11917.n3 2.35078269192837f
CMODEL14898 a_0_n11917.n1 a_1600_n11917.n4 3.44661773216008f
CMODEL14899 a_0_n11917.t4 a_1600_n11917.t5 2.18010862896496e-05f
CMODEL14900 a_0_n11917.t4 a_1600_n11917.t4 3.46534047336512e-05f
CMODEL14901 a_0_n11917.t4 a_1600_n11917.n0 0.000603276471883815f
CMODEL14902 a_0_n11917.t4 a_1600_n11917.t6 6.39748498431305e-05f
CMODEL14903 a_0_n11917.t4 a_1600_n11917.n1 0.00355407928472096f
CMODEL14904 a_0_n11917.t4 a_1600_n11917.t2 4.46846024178605e-06f
CMODEL14905 a_0_n11917.t4 a_1600_n11917.t3 4.46846024178605e-06f
CMODEL14906 a_0_n11917.t4 a_1600_n11917.n2 0.00108395861388606f
CMODEL14907 a_0_n11917.t4 a_1600_n11917.t1 1.57866099659808e-05f
CMODEL14908 a_0_n11917.t4 a_1600_n11917.t0 2.16980038925491e-05f
CMODEL14909 a_0_n11917.t4 a_1600_n11917.n3 0.00300772964628731f
CMODEL14910 a_0_n11917.t4 a_1600_n11917.n4 0.00440980545246982f
CMODEL14911 a_0_n11917.t5 a_1600_n11917.t5 2.20110378266438e-05f
CMODEL14912 a_0_n11917.t5 a_1600_n11917.t4 3.49871282687655e-05f
CMODEL14913 a_0_n11917.t5 a_1600_n11917.n0 0.000609086220114783f
CMODEL14914 a_0_n11917.t5 a_1600_n11917.t6 6.45909484115728e-05f
CMODEL14915 a_0_n11917.t5 a_1600_n11917.n1 0.00358830622178789f
CMODEL14916 a_0_n11917.t5 a_1600_n11917.t2 4.51149296425209e-06f
CMODEL14917 a_0_n11917.t5 a_1600_n11917.t3 4.51149296425209e-06f
CMODEL14918 a_0_n11917.t5 a_1600_n11917.n2 0.00109439748716054f
CMODEL14919 a_0_n11917.t5 a_1600_n11917.t1 1.59386401438467e-05f
CMODEL14920 a_0_n11917.t5 a_1600_n11917.t0 2.19069627126016e-05f
CMODEL14921 a_0_n11917.t5 a_1600_n11917.n3 0.00303669505900626f
CMODEL14922 a_0_n11917.t5 a_1600_n11917.n4 0.00445227331027703f
CMODEL14923 a_0_n11917.n2 a_1600_n11917.t5 0.00553548776555472f
CMODEL14924 a_0_n11917.n2 a_1600_n11917.t4 0.00879880458199984f
CMODEL14925 a_0_n11917.n2 a_1600_n11917.n0 0.153177208006618f
CMODEL14926 a_0_n11917.n2 a_1600_n11917.t6 0.0162437776679953f
CMODEL14927 a_0_n11917.n2 a_1600_n11917.n1 0.902412023740519f
CMODEL14928 a_0_n11917.n2 a_1600_n11917.t2 0.0011345813997818f
CMODEL14929 a_0_n11917.n2 a_1600_n11917.t3 0.0011345813997818f
CMODEL14930 a_0_n11917.n2 a_1600_n11917.n2 0.275226636224208f
CMODEL14931 a_0_n11917.n2 a_1600_n11917.t1 0.00400835927004973f
CMODEL14932 a_0_n11917.n2 a_1600_n11917.t0 0.00550931423729964f
CMODEL14933 a_0_n11917.n2 a_1600_n11917.n3 0.763689039982569f
CMODEL14934 a_0_n11917.n2 a_1600_n11917.n4 1.11968843232424f
CMODEL14935 a_0_n11917.t0 a_1600_n11917.t5 4.36289488201881e-05f
CMODEL14936 a_0_n11917.t0 a_1600_n11917.t4 6.93493710121926e-05f
CMODEL14937 a_0_n11917.t0 a_1600_n11917.n0 0.00120729389199008f
CMODEL14938 a_0_n11917.t0 a_1600_n11917.t6 0.00012802827402735f
CMODEL14939 a_0_n11917.t0 a_1600_n11917.n1 0.0071125237135362f
CMODEL14940 a_0_n11917.t0 a_1600_n11917.t2 8.94240867651108e-06f
CMODEL14941 a_0_n11917.t0 a_1600_n11917.t3 8.94240867651108e-06f
CMODEL14942 a_0_n11917.t0 a_1600_n11917.n2 0.00216924855303608f
CMODEL14943 a_0_n11917.t0 a_1600_n11917.t1 3.1592609152556e-05f
CMODEL14944 a_0_n11917.t0 a_1600_n11917.t0 4.34226574194934e-05f
CMODEL14945 a_0_n11917.t0 a_1600_n11917.n3 0.00601915340636637f
CMODEL14946 a_0_n11917.t0 a_1600_n11917.n4 0.00882502705767165f
CMODEL14947 a_0_n11917.t3 a_1600_n11917.t5 7.8351797315403e-05f
CMODEL14948 a_0_n11917.t3 a_1600_n11917.t4 0.000124542259404236f
CMODEL14949 a_0_n11917.t3 a_1600_n11917.n0 0.00216813947810634f
CMODEL14950 a_0_n11917.t3 a_1600_n11917.t6 0.000229921775529694f
CMODEL14951 a_0_n11917.t3 a_1600_n11917.n1 0.0127731479092185f
CMODEL14952 a_0_n11917.t3 a_1600_n11917.t2 1.60593782587145e-05f
CMODEL14953 a_0_n11917.t3 a_1600_n11917.t3 1.60593782587145e-05f
CMODEL14954 a_0_n11917.t3 a_1600_n11917.n2 0.0038956822832176f
CMODEL14955 a_0_n11917.t3 a_1600_n11917.t1 5.67361299303279e-05f
CMODEL14956 a_0_n11917.t3 a_1600_n11917.t0 7.79813253592311e-05f
CMODEL14957 a_0_n11917.t3 a_1600_n11917.n3 0.0108096000582006f
CMODEL14958 a_0_n11917.t3 a_1600_n11917.n4 0.0158485764618213f
CMODEL14959 a_0_n11917.n3 a_1600_n11917.t5 0.0121479611044062f
CMODEL14960 a_0_n11917.n3 a_1600_n11917.t4 0.0193095062900377f
CMODEL14961 a_0_n11917.n3 a_1600_n11917.n0 0.336156603312349f
CMODEL14962 a_0_n11917.n3 a_1600_n11917.t6 0.0356479478696229f
CMODEL14963 a_0_n11917.n3 a_1600_n11917.n1 1.98039750584649f
CMODEL14964 a_0_n11917.n3 a_1600_n11917.t2 0.00248990717676185f
CMODEL14965 a_0_n11917.n3 a_1600_n11917.t3 0.00248990717676185f
CMODEL14966 a_0_n11917.n3 a_1600_n11917.n2 0.604001420173529f
CMODEL14967 a_0_n11917.n3 a_1600_n11917.t1 0.008796585697118f
CMODEL14968 a_0_n11917.n3 a_1600_n11917.t0 0.0120905217211623f
CMODEL14969 a_0_n11917.n3 a_1600_n11917.n3 1.67596156770476f
CMODEL14970 a_0_n11917.n3 a_1600_n11917.n4 2.45722366320963f
CMODEL14971 a_0_n11917.n4 a_1600_n11917.t5 0.0221278854706194f
CMODEL14972 a_0_n11917.n4 a_1600_n11917.t4 0.0351728606971896f
CMODEL14973 a_0_n11917.n4 a_1600_n11917.n0 0.61231961103251f
CMODEL14974 a_0_n11917.n4 a_1600_n11917.t6 0.0649338354759395f
CMODEL14975 a_0_n11917.n4 a_1600_n11917.n1 3.60735507951014f
CMODEL14976 a_0_n11917.n4 a_1600_n11917.t2 0.00453544264476408f
CMODEL14977 a_0_n11917.n4 a_1600_n11917.t3 0.00453544264476408f
CMODEL14978 a_0_n11917.n4 a_1600_n11917.n2 1.10020719813167f
CMODEL14979 a_0_n11917.n4 a_1600_n11917.t1 0.0160232518992601f
CMODEL14980 a_0_n11917.n4 a_1600_n11917.t0 0.0220232578641428f
CMODEL14981 a_0_n11917.n4 a_1600_n11917.n3 3.05281563750473f
CMODEL14982 a_0_n11917.n4 a_1600_n11917.n4 4.47590861774134f
CMODEL14983 a_0_n11917.t2 a_12800_83.t1 9.95241909042432e-06f
CMODEL14984 a_0_n11917.t2 a_12800_83.n0 0.000138596077501886f
CMODEL14985 a_0_n11917.t2 a_12800_83.t0 2.25944506344767e-06f
CMODEL14986 a_0_n11917.t2 a_12800_83.t2 2.22834293358625e-06f
CMODEL14987 a_0_n11917.t2 a_12800_83.t3 2.22834293358625e-06f
CMODEL14988 a_0_n11917.t2 a_12800_83.n1 0.000936384081013537f
CMODEL14989 a_0_n11917.t1 a_12800_83.t1 1.55691802187551e-05f
CMODEL14990 a_0_n11917.t1 a_12800_83.n0 0.000216814353237552f
CMODEL14991 a_0_n11917.t1 a_12800_83.t0 3.53458863293242e-06f
CMODEL14992 a_0_n11917.t1 a_12800_83.t2 3.48593366165357e-06f
CMODEL14993 a_0_n11917.t1 a_12800_83.t3 3.48593366165357e-06f
CMODEL14994 a_0_n11917.t1 a_12800_83.n1 0.00146484310787314f
CMODEL14995 a_0_n11917.n0 a_12800_83.t1 0.000424543354811407f
CMODEL14996 a_0_n11917.n0 a_12800_83.n0 0.00591213484598585f
CMODEL14997 a_0_n11917.n0 a_12800_83.t0 9.63818322493139e-05f
CMODEL14998 a_0_n11917.n0 a_12800_83.t2 9.50550992778445e-05f
CMODEL14999 a_0_n11917.n0 a_12800_83.t3 9.50550992778445e-05f
CMODEL15000 a_0_n11917.n0 a_12800_83.n1 0.0399436192882965f
CMODEL15001 a_0_n11917.t6 a_12800_83.t1 2.65259278518878e-05f
CMODEL15002 a_0_n11917.t6 a_12800_83.n0 0.000369396577753333f
CMODEL15003 a_0_n11917.t6 a_12800_83.t0 6.0220410931029e-06f
CMODEL15004 a_0_n11917.t6 a_12800_83.t2 5.93914538249743e-06f
CMODEL15005 a_0_n11917.t6 a_12800_83.t3 5.93914538249743e-06f
CMODEL15006 a_0_n11917.t6 a_12800_83.n1 0.00249572052271388f
CMODEL15007 a_0_n11917.n1 a_12800_83.t1 0.00164587105501282f
CMODEL15008 a_0_n11917.n1 a_12800_83.n0 0.022920183547952f
CMODEL15009 a_0_n11917.n1 a_12800_83.t0 0.000373653399895319f
CMODEL15010 a_0_n11917.n1 a_12800_83.t2 0.000368509917208037f
CMODEL15011 a_0_n11917.n1 a_12800_83.t3 0.000368509917208037f
CMODEL15012 a_0_n11917.n1 a_12800_83.n1 0.15485355282092f
CMODEL15013 a_0_n11917.t4 a_12800_83.t1 2.10582423595582e-06f
CMODEL15014 a_0_n11917.t4 a_12800_83.n0 2.93254309691091e-05f
CMODEL15015 a_0_n11917.t4 a_12800_83.t0 4.78074137673394e-07f
CMODEL15016 a_0_n11917.t4 a_12800_83.t2 4.7149326338977e-07f
CMODEL15017 a_0_n11917.t4 a_12800_83.t3 4.7149326338977e-07f
CMODEL15018 a_0_n11917.t4 a_12800_83.n1 0.000198128743780368f
CMODEL15019 a_0_n11917.t5 a_12800_83.t1 2.12610400683992e-06f
CMODEL15020 a_0_n11917.t5 a_12800_83.n0 2.96078443875591e-05f
CMODEL15021 a_0_n11917.t5 a_12800_83.t0 4.82678146788728e-07f
CMODEL15022 a_0_n11917.t5 a_12800_83.t2 4.76033896549784e-07f
CMODEL15023 a_0_n11917.t5 a_12800_83.t3 4.76033896549784e-07f
CMODEL15024 a_0_n11917.t5 a_12800_83.n1 0.00020003678789004f
CMODEL15025 a_0_n11917.n2 a_12800_83.t1 0.000534687315103023f
CMODEL15026 a_0_n11917.n2 a_12800_83.n0 0.00744598513085067f
CMODEL15027 a_0_n11917.n2 a_12800_83.t0 0.00012138723295525f
CMODEL15028 a_0_n11917.n2 a_12800_83.t2 0.000119716291030629f
CMODEL15029 a_0_n11917.n2 a_12800_83.t3 0.000119716291030629f
CMODEL15030 a_0_n11917.n2 a_12800_83.n1 0.0503066325516838f
CMODEL15031 a_0_n11917.t0 a_12800_83.t1 4.21423485940914e-06f
CMODEL15032 a_0_n11917.t0 a_12800_83.n0 5.86868796298767e-05f
CMODEL15033 a_0_n11917.t0 a_12800_83.t0 9.56735449219826e-07f
CMODEL15034 a_0_n11917.t0 a_12800_83.t2 9.43565617978497e-07f
CMODEL15035 a_0_n11917.t0 a_12800_83.t3 9.43565617978497e-07f
CMODEL15036 a_0_n11917.t0 a_12800_83.n1 0.000396500830617132f
CMODEL15037 a_0_n11917.t3 a_12800_83.t1 7.56820607585081e-06f
CMODEL15038 a_0_n11917.t3 a_12800_83.n0 0.000105393841066046f
CMODEL15039 a_0_n11917.t3 a_12800_83.t0 1.71816979388342e-06f
CMODEL15040 a_0_n11917.t3 a_12800_83.t2 1.69451852618152e-06f
CMODEL15041 a_0_n11917.t3 a_12800_83.t3 1.69451852618152e-06f
CMODEL15042 a_0_n11917.t3 a_12800_83.n1 0.000712062828832753f
CMODEL15043 a_0_n11917.n3 a_12800_83.t1 0.00117340349793728f
CMODEL15044 a_0_n11917.n3 a_12800_83.n0 0.0163406625729389f
CMODEL15045 a_0_n11917.n3 a_12800_83.t0 0.000266391589497823f
CMODEL15046 a_0_n11917.n3 a_12800_83.t2 0.000262724606863641f
CMODEL15047 a_0_n11917.n3 a_12800_83.t3 0.000262724606863641f
CMODEL15048 a_0_n11917.n3 a_12800_83.n1 0.1104009332898f
CMODEL15049 a_0_n11917.n4 a_12800_83.t1 0.00213739062794352f
CMODEL15050 a_0_n11917.n4 a_12800_83.n0 0.0297650203865797f
CMODEL15051 a_0_n11917.n4 a_12800_83.t0 0.000485240488678055f
CMODEL15052 a_0_n11917.n4 a_12800_83.t2 0.000478560966818003f
CMODEL15053 a_0_n11917.n4 a_12800_83.t3 0.000478560966818003f
CMODEL15054 a_0_n11917.n4 a_12800_83.n1 0.201098701806026f
CMODEL15055 a a_9600_169.t1 3.93239680156981e-06f
CMODEL15056 a a_9600_169.n0 7.40417245775076e-05f
CMODEL15057 a a_9600_169.t2 5.74090888810987e-06f
CMODEL15058 a a_9600_169.t3 1.19831737142099e-05f
CMODEL15059 a a_9600_169.t4 2.5521836880284e-06f
CMODEL15060 a a_9600_169.t0 6.38326678112233e-06f
CMODEL15061 a a_9600_169.n1 5.77139960490387e-06f
CMODEL15062 a.t3 a_9600_169.t1 2.21380504828975e-05f
CMODEL15063 a.t3 a_9600_169.n0 0.000416829612892401f
CMODEL15064 a.t3 a_9600_169.t2 3.23193556489407e-05f
CMODEL15065 a.t3 a_9600_169.t3 6.74611739396719e-05f
CMODEL15066 a.t3 a_9600_169.t4 1.43679222057768e-05f
CMODEL15067 a.t3 a_9600_169.t0 3.59356111239529e-05f
CMODEL15068 a.t3 a_9600_169.n1 3.24910079672865e-05f
CMODEL15069 a.t0 a_9600_169.t1 2.29062393007437e-05f
CMODEL15070 a.t0 a_9600_169.n0 0.000431293571578306f
CMODEL15071 a.t0 a_9600_169.t2 3.34408350506021e-05f
CMODEL15072 a.t0 a_9600_169.t3 6.9802072001101e-05f
CMODEL15073 a.t0 a_9600_169.t4 1.48664881107867e-05f
CMODEL15074 a.t0 a_9600_169.t0 3.71825743400327e-05f
CMODEL15075 a.t0 a_9600_169.n1 3.3618443692501e-05f
CMODEL15076 a.n0 a_9600_169.t1 0.00139852588116062f
CMODEL15077 a.n0 a_9600_169.n0 0.0263323548798722f
CMODEL15078 a.n0 a_9600_169.t2 0.00204170892881451f
CMODEL15079 a.n0 a_9600_169.t3 0.00426172113940184f
CMODEL15080 a.n0 a_9600_169.t4 0.000907663982372994f
CMODEL15081 a.n0 a_9600_169.t0 0.00227015844285823f
CMODEL15082 a.n0 a_9600_169.n1 0.0020525527115565f
CMODEL15083 a.t2 a_9600_169.t1 4.36975909855281e-05f
CMODEL15084 a.t2 a_9600_169.n0 0.000822766663618348f
CMODEL15085 a.t2 a_9600_169.t2 6.3794144166139e-05f
CMODEL15086 a.t2 a_9600_169.t3 0.000133159457220351f
CMODEL15087 a.t2 a_9600_169.t4 2.83603828776591e-05f
CMODEL15088 a.t2 a_9600_169.t0 7.09321553820922e-05f
CMODEL15089 a.t2 a_9600_169.n1 6.41329631965043e-05f
CMODEL15090 a.t1 a_9600_169.t1 2.68385429969816e-05f
CMODEL15091 a.t1 a_9600_169.n0 0.000505333543108068f
CMODEL15092 a.t1 a_9600_169.t2 3.91816080141716e-05f
CMODEL15093 a.t1 a_9600_169.t3 8.1784961995884e-05f
CMODEL15094 a.t1 a_9600_169.t4 1.74186113720775e-05f
CMODEL15095 a.t1 a_9600_169.t0 4.35656899878379e-05f
CMODEL15096 a.t1 a_9600_169.n1 3.93897066509515e-05f
CMODEL15097 a_0_n11917.t2 a_16000_n24000.t0 4.08611190912827e-05f
CMODEL15098 a_0_n11917.t2 a_16000_n24000.t1 4.08530763420946e-05f
CMODEL15099 a_0_n11917.t1 a_16000_n24000.t0 6.39215572909593e-05f
CMODEL15100 a_0_n11917.t1 a_16000_n24000.t1 6.39089755246142e-05f
CMODEL15101 a_0_n11917.n0 a_16000_n24000.t0 0.00174302513014672f
CMODEL15102 a_0_n11917.n0 a_16000_n24000.t1 0.0017426820481592f
CMODEL15103 a_0_n11917.t6 a_16000_n24000.t0 0.000108906094801174f
CMODEL15104 a_0_n11917.t6 a_16000_n24000.t1 0.000108884658667631f
CMODEL15105 a_0_n11917.n1 a_16000_n24000.t0 0.00675736547835693f
CMODEL15106 a_0_n11917.n1 a_16000_n24000.t1 0.00675603541699485f
CMODEL15107 a_0_n11917.t4 a_16000_n24000.t0 8.64577085318776e-06f
CMODEL15108 a_0_n11917.t4 a_16000_n24000.t1 8.64406909444848e-06f
CMODEL15109 a_0_n11917.t5 a_16000_n24000.t0 8.72903243268018e-06f
CMODEL15110 a_0_n11917.t5 a_16000_n24000.t1 8.7273142854519e-06f
CMODEL15111 a_0_n11917.n2 a_16000_n24000.t0 0.00219523734486259f
CMODEL15112 a_0_n11917.n2 a_16000_n24000.t1 0.00219480525333485f
CMODEL15113 a_0_n11917.t0 a_16000_n24000.t0 1.73021605003181e-05f
CMODEL15114 a_0_n11917.t0 a_16000_n24000.t1 1.72987548927281e-05f
CMODEL15115 a_0_n11917.t3 a_16000_n24000.t0 3.10723821980375e-05f
CMODEL15116 a_0_n11917.t3 a_16000_n24000.t1 3.10662661791361e-05f
CMODEL15117 a_0_n11917.n3 a_16000_n24000.t0 0.00481758049331689f
CMODEL15118 a_0_n11917.n3 a_16000_n24000.t1 0.00481663224244998f
CMODEL15119 a_0_n11917.n4 a_16000_n24000.t0 0.00877537131419854f
CMODEL15120 a_0_n11917.n4 a_16000_n24000.t1 0.00877364404602572f
CMODEL15121 a_0_n11917.t2 a_20800_n23917.t0 0.000105568073564509f
CMODEL15122 a_0_n11917.t2 a_20800_n23917.t1 0.000105528150972863f
CMODEL15123 a_0_n11917.t1 a_20800_n23917.t0 0.000165146618901331f
CMODEL15124 a_0_n11917.t1 a_20800_n23917.t1 0.000165084165540145f
CMODEL15125 a_0_n11917.n0 a_20800_n23917.t0 0.00450324928088848f
CMODEL15126 a_0_n11917.n0 a_20800_n23917.t1 0.00450154629080776f
CMODEL15127 a_0_n11917.t6 a_20800_n23917.t0 0.000281367884269388f
CMODEL15128 a_0_n11917.t6 a_20800_n23917.t1 0.000281261479607763f
CMODEL15129 a_0_n11917.n1 a_20800_n23917.t0 0.017458211419218f
CMODEL15130 a_0_n11917.n1 a_20800_n23917.t1 0.0174516092617491f
CMODEL15131 a_0_n11917.t4 a_20800_n23917.t0 2.23370625609207e-05f
CMODEL15132 a_0_n11917.t4 a_20800_n23917.t1 2.2328615372324e-05f
CMODEL15133 a_0_n11917.t5 a_20800_n23917.t0 2.25521757233703e-05f
CMODEL15134 a_0_n11917.t5 a_20800_n23917.t1 2.25436471856057e-05f
CMODEL15135 a_0_n11917.n2 a_20800_n23917.t0 0.00567157686005355f
CMODEL15136 a_0_n11917.n2 a_20800_n23917.t1 0.0056694320444921f
CMODEL15137 a_0_n11917.t0 a_20800_n23917.t0 4.47015596523936e-05f
CMODEL15138 a_0_n11917.t0 a_20800_n23917.t1 4.46846549003063e-05f
CMODEL15139 a_0_n11917.t3 a_20800_n23917.t0 8.02780639066436e-05f
CMODEL15140 a_0_n11917.t3 a_20800_n23917.t1 8.02477052171719e-05f
CMODEL15141 a_0_n11917.n3 a_20800_n23917.t0 0.0124466168140246f
CMODEL15142 a_0_n11917.n3 a_20800_n23917.t1 0.0124419098871701f
CMODEL15143 a_0_n11917.n4 a_20800_n23917.t0 0.0226718960482615f
CMODEL15144 a_0_n11917.n4 a_20800_n23917.t1 0.02266332223596f
CMODEL15145 a_1600_n11917.t5 we 2.94513056643033e-07f
CMODEL15146 a_1600_n11917.t5 we.t1 1.68383486497308e-06f
CMODEL15147 a_1600_n11917.t5 we.t3 1.71554258837881e-06f
CMODEL15148 a_1600_n11917.t5 we.n0 5.86184600793942e-05f
CMODEL15149 a_1600_n11917.t5 we.t0 2.07930886894632e-06f
CMODEL15150 a_1600_n11917.t5 we.n1 0.000160078729969779f
CMODEL15151 a_1600_n11917.t5 we.t2 3.12902219178963e-06f
CMODEL15152 a_1600_n11917.t4 we 4.68136312824062e-07f
CMODEL15153 a_1600_n11917.t4 we.t1 2.67650016633566e-06f
CMODEL15154 a_1600_n11917.t4 we.t3 2.72690043344909e-06f
CMODEL15155 a_1600_n11917.t4 we.n0 9.31755966196525e-05f
CMODEL15156 a_1600_n11917.t4 we.t0 3.30511658201531e-06f
CMODEL15157 a_1600_n11917.t4 we.n1 0.000254449385924649f
CMODEL15158 a_1600_n11917.t4 we.t2 4.97366374280817e-06f
CMODEL15159 a_1600_n11917.n0 we 8.14972223745017e-06f
CMODEL15160 a_1600_n11917.n0 we.t1 4.65948321601844e-05f
CMODEL15161 a_1600_n11917.n0 we.t3 4.74722436457194e-05f
CMODEL15162 a_1600_n11917.n0 we.n0 0.00162208145567262f
CMODEL15163 a_1600_n11917.n0 we.t0 5.7538330968866e-05f
CMODEL15164 a_1600_n11917.n0 we.n1 0.00442967520777436f
CMODEL15165 a_1600_n11917.n0 we.t2 8.65858445413893e-05f
CMODEL15166 a_1600_n11917.t6 we 8.64242649437367e-07f
CMODEL15167 a_1600_n11917.t6 we.t1 4.94117959151531e-06f
CMODEL15168 a_1600_n11917.t6 we.t3 5.03422526900121e-06f
CMODEL15169 a_1600_n11917.t6 we.n0 0.000172014693753825f
CMODEL15170 a_1600_n11917.t6 we.t0 6.10169011309705e-06f
CMODEL15171 a_1600_n11917.t6 we.n1 0.000469747817922161f
CMODEL15172 a_1600_n11917.t6 we.t2 9.18205277553544e-06f
CMODEL15173 a_1600_n11917.n1 we 4.80124127664135e-05f
CMODEL15174 a_1600_n11917.n1 we.t1 0.000274503872558542f
CMODEL15175 a_1600_n11917.n1 we.t3 0.000279672961906877f
CMODEL15176 a_1600_n11917.n1 we.n0 0.0095561593538267f
CMODEL15177 a_1600_n11917.n1 we.t0 0.00033897524552101f
CMODEL15178 a_1600_n11917.n1 we.n1 0.0260965206298065f
CMODEL15179 a_1600_n11917.n1 we.t2 0.00051010269880687f
CMODEL15180 a_1600_n11917.t2 we 6.03648766309906e-08f
CMODEL15181 a_1600_n11917.t2 we.t1 3.45127258701673e-07f
CMODEL15182 a_1600_n11917.t2 we.t3 3.51626233088254e-07f
CMODEL15183 a_1600_n11917.t2 we.n0 1.20147342577078e-05f
CMODEL15184 a_1600_n11917.t2 we.t0 4.26185598636476e-07f
CMODEL15185 a_1600_n11917.t2 we.n1 3.28105412235887e-05f
CMODEL15186 a_1600_n11917.t2 we.t2 6.41340118281921e-07f
CMODEL15187 a_1600_n11917.t3 we 6.03648766309906e-08f
CMODEL15188 a_1600_n11917.t3 we.t1 3.45127258701673e-07f
CMODEL15189 a_1600_n11917.t3 we.t3 3.51626233088254e-07f
CMODEL15190 a_1600_n11917.t3 we.n0 1.20147342577078e-05f
CMODEL15191 a_1600_n11917.t3 we.t0 4.26185598636476e-07f
CMODEL15192 a_1600_n11917.t3 we.n1 3.28105412235887e-05f
CMODEL15193 a_1600_n11917.t3 we.t2 6.41340118281921e-07f
CMODEL15194 a_1600_n11917.n2 we 1.4643305402708e-05f
CMODEL15195 a_1600_n11917.n2 we.t1 8.37209339938162e-05f
CMODEL15196 a_1600_n11917.n2 we.t3 8.52974545146619e-05f
CMODEL15197 a_1600_n11917.n2 we.n0 0.00291453296829353f
CMODEL15198 a_1600_n11917.n2 we.t0 0.000103384057540936f
CMODEL15199 a_1600_n11917.n2 we.n1 0.00795917762744986f
CMODEL15200 a_1600_n11917.n2 we.t2 0.000155576218210801f
CMODEL15201 a_1600_n11917.t1 we 2.13262894029264e-07f
CMODEL15202 a_1600_n11917.t1 we.t1 1.21929907103162e-06f
CMODEL15203 a_1600_n11917.t1 we.t3 1.24225927841143e-06f
CMODEL15204 a_1600_n11917.t1 we.n0 4.24468191073192e-05f
CMODEL15205 a_1600_n11917.t1 we.t0 1.50566984033473e-06f
CMODEL15206 a_1600_n11917.t1 we.n1 0.000115916264002048f
CMODEL15207 a_1600_n11917.t1 we.t2 2.26578860614542e-06f
CMODEL15208 a_1600_n11917.t0 we 2.93120506223628e-07f
CMODEL15209 a_1600_n11917.t0 we.t1 1.67587316380385e-06f
CMODEL15210 a_1600_n11917.t0 we.t3 1.70743096311443e-06f
CMODEL15211 a_1600_n11917.t0 we.n0 5.83412935520461e-05f
CMODEL15212 a_1600_n11917.t0 we.t0 2.06947724222482e-06f
CMODEL15213 a_1600_n11917.t0 we.n1 0.000159321827355348f
CMODEL15214 a_1600_n11917.t0 we.t2 3.11422719011747e-06f
CMODEL15215 a_1600_n11917.n3 we 4.06317208195492e-05f
CMODEL15216 a_1600_n11917.n3 we.t1 0.000232305857402903f
CMODEL15217 a_1600_n11917.n3 we.t3 0.000236680330235891f
CMODEL15218 a_1600_n11917.n3 we.n0 0.00808714198265472f
CMODEL15219 a_1600_n11917.n3 we.t0 0.00028686639031777f
CMODEL15220 a_1600_n11917.n3 we.n1 0.0220848418043606f
CMODEL15221 a_1600_n11917.n3 we.t2 0.000431687333607991f
CMODEL15222 a_1600_n11917.n4 we 5.95725032116679e-05f
CMODEL15223 a_1600_n11917.n4 we.t1 0.000340596980809272f
CMODEL15224 a_1600_n11917.n4 we.t3 0.000347010647068938f
CMODEL15225 a_1600_n11917.n4 we.n0 0.0118570240693108f
CMODEL15226 a_1600_n11917.n4 we.t0 0.000420591316681391f
CMODEL15227 a_1600_n11917.n4 we.n1 0.0323798569881502f
CMODEL15228 a_1600_n11917.n4 we.t2 0.000632921632386913f
CMODEL15229 a_0_n11917.t2 vdd 1.37901391429578e-06f
CMODEL15230 a_0_n11917.t2 vdd.n0 0.000462771408293237f
CMODEL15231 a_0_n11917.t2 vdd.n1 4.28853771435257e-05f
CMODEL15232 a_0_n11917.t2 vdd.t7 3.53531618168442e-06f
CMODEL15233 a_0_n11917.t2 vdd.t6 2.79448426889584e-05f
CMODEL15234 a_0_n11917.t2 vdd.n2 3.84570433261409e-05f
CMODEL15235 a_0_n11917.t2 vdd.t27 3.53531618168442e-06f
CMODEL15236 a_0_n11917.t2 vdd.t26 2.79448426889584e-05f
CMODEL15237 a_0_n11917.t2 vdd.n3 7.21311623025361e-05f
CMODEL15238 a_0_n11917.t2 vdd.n4 3.84570433261409e-05f
CMODEL15239 a_0_n11917.t2 vdd.t36 3.53531618168442e-06f
CMODEL15240 a_0_n11917.t2 vdd.t35 2.79448426889584e-05f
CMODEL15241 a_0_n11917.t2 vdd.n5 5.48721562721775e-05f
CMODEL15242 a_0_n11917.t2 vdd.t3 5.63154530783262e-06f
CMODEL15243 a_0_n11917.t2 vdd.n6 5.38799504355071e-05f
CMODEL15244 a_0_n11917.t2 vdd.t2 7.06133852932431e-05f
CMODEL15245 a_0_n11917.t2 vdd.n7 7.22283103935939e-05f
CMODEL15246 a_0_n11917.t2 vdd.t25 5.63154530783262e-06f
CMODEL15247 a_0_n11917.t2 vdd.n8 3.25439628504228e-05f
CMODEL15248 a_0_n11917.t2 vdd.t24 7.06133852932431e-05f
CMODEL15249 a_0_n11917.t2 vdd.n9 7.22283103935939e-05f
CMODEL15250 a_0_n11917.t2 vdd.t5 5.63154530783262e-06f
CMODEL15251 a_0_n11917.t2 vdd.n10 9.6365725097815e-05f
CMODEL15252 a_0_n11917.t2 vdd.t4 7.06522445296662e-05f
CMODEL15253 a_0_n11917.t2 vdd.n11 0.000232996095669386f
CMODEL15254 a_0_n11917.t2 vdd.n12 0.000574481998200602f
CMODEL15255 a_0_n11917.t2 vdd.n13 4.35450126818081e-05f
CMODEL15256 a_0_n11917.t2 vdd.t42 3.53531618168442e-06f
CMODEL15257 a_0_n11917.t2 vdd.t41 2.79448426889584e-05f
CMODEL15258 a_0_n11917.t2 vdd.n14 3.91503568693234e-05f
CMODEL15259 a_0_n11917.t2 vdd.t9 3.53531618168442e-06f
CMODEL15260 a_0_n11917.t2 vdd.t8 2.79448426889584e-05f
CMODEL15261 a_0_n11917.t2 vdd.n15 7.51634780514203e-05f
CMODEL15262 a_0_n11917.t2 vdd.t15 5.95381790856836e-06f
CMODEL15263 a_0_n11917.t2 vdd.n16 4.68315326022935e-05f
CMODEL15264 a_0_n11917.t2 vdd.t14 8.03132983583943e-05f
CMODEL15265 a_0_n11917.t2 vdd.n17 6.56008676216308e-05f
CMODEL15266 a_0_n11917.t2 vdd.t32 8.03132983583943e-05f
CMODEL15267 a_0_n11917.t2 vdd.n18 6.47569745373087e-05f
CMODEL15268 a_0_n11917.t2 vdd.t34 5.95381790856836e-06f
CMODEL15269 a_0_n11917.t2 vdd.n19 6.52109799495188e-05f
CMODEL15270 a_0_n11917.t2 vdd.t33 8.03132983583943e-05f
CMODEL15271 a_0_n11917.t2 vdd.n20 0.000130137963646179f
CMODEL15272 a_0_n11917.t2 vdd.t48 8.04667923422656e-05f
CMODEL15273 a_0_n11917.t2 vdd.n21 0.000231009093380284f
CMODEL15274 a_0_n11917.t2 vdd.n22 0.00101236730383453f
CMODEL15275 a_0_n11917.t2 vdd.t47 1.14455671133688e-06f
CMODEL15276 a_0_n11917.t2 vdd.t45 1.13280503058859e-06f
CMODEL15277 a_0_n11917.t2 vdd.n23 1.29353330897402e-05f
CMODEL15278 a_0_n11917.t2 vdd.t46 3.08708784262253e-05f
CMODEL15279 a_0_n11917.t2 vdd.n24 3.31679774219841e-05f
CMODEL15280 a_0_n11917.t2 vdd.t44 3.08708784262253e-05f
CMODEL15281 a_0_n11917.t2 vdd.n25 5.23090658031025e-05f
CMODEL15282 a_0_n11917.t2 vdd.t43 3.09377486955701e-05f
CMODEL15283 a_0_n11917.t2 vdd.n26 0.000279883002683583f
CMODEL15284 a_0_n11917.t2 vdd.n27 0.000187107547204294f
CMODEL15285 a_0_n11917.t2 vdd.n28 4.22642770146961e-05f
CMODEL15286 a_0_n11917.t2 vdd.t29 3.53531618168442e-06f
CMODEL15287 a_0_n11917.t2 vdd.t28 2.79448426889584e-05f
CMODEL15288 a_0_n11917.t2 vdd.n29 6.30899132947568e-06f
CMODEL15289 a_0_n11917.t2 vdd.n30 2.01270767399611e-06f
CMODEL15290 a_0_n11917.t2 vdd.t38 9.26695640600359e-07f
CMODEL15291 a_0_n11917.t2 vdd.t40 9.26695640600359e-07f
CMODEL15292 a_0_n11917.t2 vdd.t37 1.87257479091493e-05f
CMODEL15293 a_0_n11917.t2 vdd.t39 1.87257479091493e-05f
CMODEL15294 a_0_n11917.t2 vdd.n31 6.06482579395041e-06f
CMODEL15295 a_0_n11917.t2 vdd.n32 7.3189752668096e-05f
CMODEL15296 a_0_n11917.t2 vdd.n33 3.70853122804048e-05f
CMODEL15297 a_0_n11917.t2 vdd.t17 3.53531618168442e-06f
CMODEL15298 a_0_n11917.t2 vdd.t16 2.79448426889584e-05f
CMODEL15299 a_0_n11917.t2 vdd.n34 6.30899132947568e-06f
CMODEL15300 a_0_n11917.t2 vdd.n35 2.01270767399611e-06f
CMODEL15301 a_0_n11917.t2 vdd.t1 9.26695640600359e-07f
CMODEL15302 a_0_n11917.t2 vdd.t31 9.26695640600359e-07f
CMODEL15303 a_0_n11917.t2 vdd.t0 1.87257479091493e-05f
CMODEL15304 a_0_n11917.t2 vdd.t30 1.87257479091493e-05f
CMODEL15305 a_0_n11917.t2 vdd.n36 6.06482579395041e-06f
CMODEL15306 a_0_n11917.t2 vdd.n37 7.0979633596531e-05f
CMODEL15307 a_0_n11917.t2 vdd.n38 4.09443582841908e-05f
CMODEL15308 a_0_n11917.t2 vdd.t19 3.53531618168442e-06f
CMODEL15309 a_0_n11917.t2 vdd.t18 2.79448426889584e-05f
CMODEL15310 a_0_n11917.t2 vdd.n39 3.45513662386471e-05f
CMODEL15311 a_0_n11917.t2 vdd.t21 3.53534856438144e-06f
CMODEL15312 a_0_n11917.t2 vdd.t20 2.79448426889584e-05f
CMODEL15313 a_0_n11917.t2 vdd.n40 3.45513662386471e-05f
CMODEL15314 a_0_n11917.t2 vdd.t11 3.53531618168442e-06f
CMODEL15315 a_0_n11917.t2 vdd.t10 2.79448426889584e-05f
CMODEL15316 a_0_n11917.t2 vdd.n41 0.000148646294127541f
CMODEL15317 a_0_n11917.t2 vdd.n42 0.000284731663908278f
CMODEL15318 a_0_n11917.t2 vdd.n43 3.45513662386471e-05f
CMODEL15319 a_0_n11917.t2 vdd.t13 3.53531618168442e-06f
CMODEL15320 a_0_n11917.t2 vdd.t12 2.79448426889584e-05f
CMODEL15321 a_0_n11917.t2 vdd.n44 3.45513662386471e-05f
CMODEL15322 a_0_n11917.t2 vdd.t23 3.53531618168442e-06f
CMODEL15323 a_0_n11917.t2 vdd.t22 2.79448426889584e-05f
CMODEL15324 a_0_n11917.t2 vdd.n45 4.26522217249869e-05f
CMODEL15325 a_0_n11917.t2 vdd.n46 0.000704019262817073f
CMODEL15326 a_0_n11917.t1 vdd 2.15727613163912e-06f
CMODEL15327 a_0_n11917.t1 vdd.n0 0.000723941726161506f
CMODEL15328 a_0_n11917.t1 vdd.n1 6.70882284427962e-05f
CMODEL15329 a_0_n11917.t1 vdd.t7 5.5305121561736e-06f
CMODEL15330 a_0_n11917.t1 vdd.t6 4.37158331111442e-05f
CMODEL15331 a_0_n11917.t1 vdd.n2 6.01607139716656e-05f
CMODEL15332 a_0_n11917.t1 vdd.t27 5.5305121561736e-06f
CMODEL15333 a_0_n11917.t1 vdd.t26 4.37158331111442e-05f
CMODEL15334 a_0_n11917.t1 vdd.n3 0.000112839205732099f
CMODEL15335 a_0_n11917.t1 vdd.n4 6.01607139716656e-05f
CMODEL15336 a_0_n11917.t1 vdd.t36 5.5305121561736e-06f
CMODEL15337 a_0_n11917.t1 vdd.t35 4.37158331111442e-05f
CMODEL15338 a_0_n11917.t1 vdd.n5 8.58398829702821e-05f
CMODEL15339 a_0_n11917.t1 vdd.t3 8.80977207763391e-06f
CMODEL15340 a_0_n11917.t1 vdd.n6 8.428771446282e-05f
CMODEL15341 a_0_n11917.t1 vdd.t2 0.0001104648539715f
CMODEL15342 a_0_n11917.t1 vdd.n7 0.000112991180455415f
CMODEL15343 a_0_n11917.t1 vdd.t25 8.80977207763391e-06f
CMODEL15344 a_0_n11917.t1 vdd.n8 5.09105191458634e-05f
CMODEL15345 a_0_n11917.t1 vdd.t24 0.0001104648539715f
CMODEL15346 a_0_n11917.t1 vdd.n9 0.000112991180455415f
CMODEL15347 a_0_n11917.t1 vdd.t5 8.80977207763391e-06f
CMODEL15348 a_0_n11917.t1 vdd.n10 0.000150750820210378f
CMODEL15349 a_0_n11917.t1 vdd.t4 0.000110525643860826f
CMODEL15350 a_0_n11917.t1 vdd.n11 0.000364490097410913f
CMODEL15351 a_0_n11917.t1 vdd.n12 0.000898697460501975f
CMODEL15352 a_0_n11917.t1 vdd.n13 6.81201368141083e-05f
CMODEL15353 a_0_n11917.t1 vdd.t42 5.5305121561736e-06f
CMODEL15354 a_0_n11917.t1 vdd.t41 4.37158331111442e-05f
CMODEL15355 a_0_n11917.t1 vdd.n14 6.1245306913727e-05f
CMODEL15356 a_0_n11917.t1 vdd.t9 5.5305121561736e-06f
CMODEL15357 a_0_n11917.t1 vdd.t8 4.37158331111442e-05f
CMODEL15358 a_0_n11917.t1 vdd.n15 0.000117582843429186f
CMODEL15359 a_0_n11917.t1 vdd.t15 9.31392289311246e-06f
CMODEL15360 a_0_n11917.t1 vdd.n16 7.32614417038709e-05f
CMODEL15361 a_0_n11917.t1 vdd.t14 0.00012563902351214f
CMODEL15362 a_0_n11917.t1 vdd.n17 0.000102623464830833f
CMODEL15363 a_0_n11917.t1 vdd.t32 0.00012563902351214f
CMODEL15364 a_0_n11917.t1 vdd.n18 0.000101303311067632f
CMODEL15365 a_0_n11917.t1 vdd.t34 9.31392289311246e-06f
CMODEL15366 a_0_n11917.t1 vdd.n19 0.000102013539607926f
CMODEL15367 a_0_n11917.t1 vdd.t33 0.00012563902351214f
CMODEL15368 a_0_n11917.t1 vdd.n20 0.000203582806441361f
CMODEL15369 a_0_n11917.t1 vdd.t48 0.000125879143574978f
CMODEL15370 a_0_n11917.t1 vdd.n21 0.0003613817077367f
CMODEL15371 a_0_n11917.t1 vdd.n22 0.00158370832837417f
CMODEL15372 a_0_n11917.t1 vdd.t47 1.79050033438954e-06f
CMODEL15373 a_0_n11917.t1 vdd.t45 1.77211645869248e-06f
CMODEL15374 a_0_n11917.t1 vdd.n23 2.02355357259383e-05f
CMODEL15375 a_0_n11917.t1 vdd.t46 4.82932104609242e-05f
CMODEL15376 a_0_n11917.t1 vdd.n24 5.18867034519598e-05f
CMODEL15377 a_0_n11917.t1 vdd.t44 4.82932104609242e-05f
CMODEL15378 a_0_n11917.t1 vdd.n25 8.18302831868087e-05f
CMODEL15379 a_0_n11917.t1 vdd.t43 4.83978197288064e-05f
CMODEL15380 a_0_n11917.t1 vdd.n26 0.000437838164707073f
CMODEL15381 a_0_n11917.t1 vdd.n27 0.000292703823688024f
CMODEL15382 a_0_n11917.t1 vdd.n28 6.61166033783992e-05f
CMODEL15383 a_0_n11917.t1 vdd.t29 5.5305121561736e-06f
CMODEL15384 a_0_n11917.t1 vdd.t28 4.37158331111442e-05f
CMODEL15385 a_0_n11917.t1 vdd.n29 9.86954248155385e-06f
CMODEL15386 a_0_n11917.t1 vdd.n30 3.14860218600188e-06f
CMODEL15387 a_0_n11917.t1 vdd.t38 1.44968688570636e-06f
CMODEL15388 a_0_n11917.t1 vdd.t40 1.44968688570636e-06f
CMODEL15389 a_0_n11917.t1 vdd.t37 2.92938371344341e-05f
CMODEL15390 a_0_n11917.t1 vdd.t39 2.92938371344341e-05f
CMODEL15391 a_0_n11917.t1 vdd.n31 9.48757934362094e-06f
CMODEL15392 a_0_n11917.t1 vdd.n32 0.000114495223633827f
CMODEL15393 a_0_n11917.t1 vdd.n33 5.8014830878451e-05f
CMODEL15394 a_0_n11917.t1 vdd.t17 5.5305121561736e-06f
CMODEL15395 a_0_n11917.t1 vdd.t16 4.37158331111442e-05f
CMODEL15396 a_0_n11917.t1 vdd.n34 9.86954248155385e-06f
CMODEL15397 a_0_n11917.t1 vdd.n35 3.14860218600188e-06f
CMODEL15398 a_0_n11917.t1 vdd.t1 1.44968688570636e-06f
CMODEL15399 a_0_n11917.t1 vdd.t31 1.44968688570636e-06f
CMODEL15400 a_0_n11917.t1 vdd.t0 2.92938371344341e-05f
CMODEL15401 a_0_n11917.t1 vdd.t30 2.92938371344341e-05f
CMODEL15402 a_0_n11917.t1 vdd.n36 9.48757934362094e-06f
CMODEL15403 a_0_n11917.t1 vdd.n37 0.0001110377986784f
CMODEL15404 a_0_n11917.t1 vdd.n38 6.40517734709529e-05f
CMODEL15405 a_0_n11917.t1 vdd.t19 5.5305121561736e-06f
CMODEL15406 a_0_n11917.t1 vdd.t18 4.37158331111442e-05f
CMODEL15407 a_0_n11917.t1 vdd.n39 5.40508235119723e-05f
CMODEL15408 a_0_n11917.t1 vdd.t21 5.53056281441471e-06f
CMODEL15409 a_0_n11917.t1 vdd.t20 4.37158331111442e-05f
CMODEL15410 a_0_n11917.t1 vdd.n40 5.40508235119723e-05f
CMODEL15411 a_0_n11917.t1 vdd.t11 5.5305121561736e-06f
CMODEL15412 a_0_n11917.t1 vdd.t10 4.37158331111442e-05f
CMODEL15413 a_0_n11917.t1 vdd.n41 0.000232536524145015f
CMODEL15414 a_0_n11917.t1 vdd.n42 0.000445423223147749f
CMODEL15415 a_0_n11917.t1 vdd.n43 5.40508235119723e-05f
CMODEL15416 a_0_n11917.t1 vdd.t13 5.5305121561736e-06f
CMODEL15417 a_0_n11917.t1 vdd.t12 4.37158331111442e-05f
CMODEL15418 a_0_n11917.t1 vdd.n44 5.40508235119723e-05f
CMODEL15419 a_0_n11917.t1 vdd.t23 5.5305121561736e-06f
CMODEL15420 a_0_n11917.t1 vdd.t22 4.37158331111442e-05f
CMODEL15421 a_0_n11917.t1 vdd.n45 6.6723489106839e-05f
CMODEL15422 a_0_n11917.t1 vdd.n46 0.00110134055657084f
CMODEL15423 a_0_n11917.n0 vdd 5.88250141184296e-05f
CMODEL15424 a_0_n11917.n0 vdd.n0 0.0197405800944053f
CMODEL15425 a_0_n11917.n0 vdd.n1 0.00182937451884259f
CMODEL15426 a_0_n11917.n0 vdd.t7 0.0001508070528838f
CMODEL15427 a_0_n11917.n0 vdd.t6 0.00119205161650218f
CMODEL15428 a_0_n11917.n0 vdd.n2 0.00164047374225992f
CMODEL15429 a_0_n11917.n0 vdd.t27 0.0001508070528838f
CMODEL15430 a_0_n11917.n0 vdd.t26 0.00119205161650218f
CMODEL15431 a_0_n11917.n0 vdd.n3 0.00307692083222544f
CMODEL15432 a_0_n11917.n0 vdd.n4 0.00164047374225992f
CMODEL15433 a_0_n11917.n0 vdd.t36 0.0001508070528838f
CMODEL15434 a_0_n11917.n0 vdd.t35 0.00119205161650218f
CMODEL15435 a_0_n11917.n0 vdd.n5 0.00234069818582497f
CMODEL15436 a_0_n11917.n0 vdd.t3 0.000240226533472654f
CMODEL15437 a_0_n11917.n0 vdd.n6 0.00229837336100235f
CMODEL15438 a_0_n11917.n0 vdd.t2 0.00301217655874515f
CMODEL15439 a_0_n11917.n0 vdd.n7 0.0030810649077629f
CMODEL15440 a_0_n11917.n0 vdd.t25 0.000240226533472654f
CMODEL15441 a_0_n11917.n0 vdd.n8 0.0013882376778797f
CMODEL15442 a_0_n11917.n0 vdd.t24 0.00301217655874515f
CMODEL15443 a_0_n11917.n0 vdd.n9 0.0030810649077629f
CMODEL15444 a_0_n11917.n0 vdd.t5 0.000240226533472654f
CMODEL15445 a_0_n11917.n0 vdd.n10 0.00411070191580085f
CMODEL15446 a_0_n11917.n0 vdd.t4 0.00301383418896014f
CMODEL15447 a_0_n11917.n0 vdd.n11 0.00993898500602867f
CMODEL15448 a_0_n11917.n0 vdd.n12 0.0245058525549335f
CMODEL15449 a_0_n11917.n0 vdd.n13 0.00185751279174196f
CMODEL15450 a_0_n11917.n0 vdd.t42 0.0001508070528838f
CMODEL15451 a_0_n11917.n0 vdd.t41 0.00119205161650218f
CMODEL15452 a_0_n11917.n0 vdd.n14 0.00167004862801228f
CMODEL15453 a_0_n11917.n0 vdd.t9 0.0001508070528838f
CMODEL15454 a_0_n11917.n0 vdd.t8 0.00119205161650218f
CMODEL15455 a_0_n11917.n0 vdd.n15 0.00320627124333477f
CMODEL15456 a_0_n11917.n0 vdd.t15 0.00025397381338893f
CMODEL15457 a_0_n11917.n0 vdd.n16 0.00199770686717432f
CMODEL15458 a_0_n11917.n0 vdd.t14 0.00342594868757566f
CMODEL15459 a_0_n11917.n0 vdd.n17 0.00279835607459721f
CMODEL15460 a_0_n11917.n0 vdd.t32 0.00342594868757566f
CMODEL15461 a_0_n11917.n0 vdd.n18 0.00276235787176178f
CMODEL15462 a_0_n11917.n0 vdd.t34 0.00025397381338893f
CMODEL15463 a_0_n11917.n0 vdd.n19 0.00278172451810686f
CMODEL15464 a_0_n11917.n0 vdd.t33 0.00342594868757566f
CMODEL15465 a_0_n11917.n0 vdd.n20 0.0055513345220592f
CMODEL15466 a_0_n11917.n0 vdd.t48 0.00343249632692485f
CMODEL15467 a_0_n11917.n0 vdd.n21 0.00985422484770244f
CMODEL15468 a_0_n11917.n0 vdd.n22 0.0431848586324922f
CMODEL15469 a_0_n11917.n0 vdd.t47 4.88237022163175e-05f
CMODEL15470 a_0_n11917.n0 vdd.t45 4.83224072121358e-05f
CMODEL15471 a_0_n11917.n0 vdd.n23 0.000551786420530163f
CMODEL15472 a_0_n11917.n0 vdd.t46 0.00131686840897352f
CMODEL15473 a_0_n11917.n0 vdd.n24 0.00141485645641534f
CMODEL15474 a_0_n11917.n0 vdd.t44 0.00131686840897352f
CMODEL15475 a_0_n11917.n0 vdd.n25 0.00223136365956158f
CMODEL15476 a_0_n11917.n0 vdd.t43 0.00131972091430181f
CMODEL15477 a_0_n11917.n0 vdd.n26 0.0119390539962593f
CMODEL15478 a_0_n11917.n0 vdd.n27 0.00798150329873799f
CMODEL15479 a_0_n11917.n0 vdd.n28 0.00180288006257308f
CMODEL15480 a_0_n11917.n0 vdd.t29 0.0001508070528838f
CMODEL15481 a_0_n11917.n0 vdd.t28 0.00119205161650218f
CMODEL15482 a_0_n11917.n0 vdd.n29 0.000269124553553893f
CMODEL15483 a_0_n11917.n0 vdd.n30 8.58566807134465e-05f
CMODEL15484 a_0_n11917.n0 vdd.t38 3.95303365518552e-05f
CMODEL15485 a_0_n11917.n0 vdd.t40 3.95303365518552e-05f
CMODEL15486 a_0_n11917.n0 vdd.t37 0.000798789898865081f
CMODEL15487 a_0_n11917.n0 vdd.t39 0.000798789898865081f
CMODEL15488 a_0_n11917.n0 vdd.n31 0.000258709110369737f
CMODEL15489 a_0_n11917.n0 vdd.n32 0.00312207744199866f
CMODEL15490 a_0_n11917.n0 vdd.n33 0.00158195939567095f
CMODEL15491 a_0_n11917.n0 vdd.t17 0.0001508070528838f
CMODEL15492 a_0_n11917.n0 vdd.t16 0.00119205161650218f
CMODEL15493 a_0_n11917.n0 vdd.n34 0.000269124553553893f
CMODEL15494 a_0_n11917.n0 vdd.n35 8.58566807134465e-05f
CMODEL15495 a_0_n11917.n0 vdd.t1 3.95303365518552e-05f
CMODEL15496 a_0_n11917.n0 vdd.t31 3.95303365518552e-05f
CMODEL15497 a_0_n11917.n0 vdd.t0 0.000798789898865081f
CMODEL15498 a_0_n11917.n0 vdd.t30 0.000798789898865081f
CMODEL15499 a_0_n11917.n0 vdd.n36 0.000258709110369737f
CMODEL15500 a_0_n11917.n0 vdd.n37 0.00302779972352138f
CMODEL15501 a_0_n11917.n0 vdd.n38 0.00174657588960409f
CMODEL15502 a_0_n11917.n0 vdd.t19 0.0001508070528838f
CMODEL15503 a_0_n11917.n0 vdd.t18 0.00119205161650218f
CMODEL15504 a_0_n11917.n0 vdd.n39 0.0014738680920688f
CMODEL15505 a_0_n11917.n0 vdd.t21 0.000150808434242312f
CMODEL15506 a_0_n11917.n0 vdd.t20 0.00119205161650218f
CMODEL15507 a_0_n11917.n0 vdd.n40 0.0014738680920688f
CMODEL15508 a_0_n11917.n0 vdd.t11 0.0001508070528838f
CMODEL15509 a_0_n11917.n0 vdd.t10 0.00119205161650218f
CMODEL15510 a_0_n11917.n0 vdd.n41 0.00634084997987144f
CMODEL15511 a_0_n11917.n0 vdd.n42 0.0121458848063341f
CMODEL15512 a_0_n11917.n0 vdd.n43 0.0014738680920688f
CMODEL15513 a_0_n11917.n0 vdd.t13 0.0001508070528838f
CMODEL15514 a_0_n11917.n0 vdd.t12 0.00119205161650218f
CMODEL15515 a_0_n11917.n0 vdd.n44 0.0014738680920688f
CMODEL15516 a_0_n11917.n0 vdd.t23 0.0001508070528838f
CMODEL15517 a_0_n11917.n0 vdd.t22 0.00119205161650218f
CMODEL15518 a_0_n11917.n0 vdd.n45 0.00181942873755268f
CMODEL15519 a_0_n11917.n0 vdd.n46 0.0300315628765861f
CMODEL15520 a_0_n11917.t6 vdd 3.67545048746532e-06f
CMODEL15521 a_0_n11917.t6 vdd.n0 0.00123341278906891f
CMODEL15522 a_0_n11917.t6 vdd.n1 0.000114301297973341f
CMODEL15523 a_0_n11917.t6 vdd.t7 9.4225877263549e-06f
CMODEL15524 a_0_n11917.t6 vdd.t6 7.4480673921064e-05f
CMODEL15525 a_0_n11917.t6 vdd.n2 0.000102498573200925f
CMODEL15526 a_0_n11917.t6 vdd.t27 9.4225877263549e-06f
CMODEL15527 a_0_n11917.t6 vdd.t26 7.4480673921064e-05f
CMODEL15528 a_0_n11917.t6 vdd.n3 0.000192249340559905f
CMODEL15529 a_0_n11917.t6 vdd.n4 0.000102498573200925f
CMODEL15530 a_0_n11917.t6 vdd.t36 9.4225877263549e-06f
CMODEL15531 a_0_n11917.t6 vdd.t35 7.4480673921064e-05f
CMODEL15532 a_0_n11917.t6 vdd.n5 0.000146249353562063f
CMODEL15533 a_0_n11917.t6 vdd.t3 1.50096135595749e-05f
CMODEL15534 a_0_n11917.t6 vdd.n6 0.000143604852742854f
CMODEL15535 a_0_n11917.t6 vdd.t2 0.000188204048347231f
CMODEL15536 a_0_n11917.t6 vdd.n7 0.000192508266880323f
CMODEL15537 a_0_n11917.t6 vdd.t25 1.50096135595749e-05f
CMODEL15538 a_0_n11917.t6 vdd.n8 8.67385911647766e-05f
CMODEL15539 a_0_n11917.t6 vdd.t24 0.000188204048347231f
CMODEL15540 a_0_n11917.t6 vdd.n9 0.000192508266880323f
CMODEL15541 a_0_n11917.t6 vdd.t5 1.50096135595749e-05f
CMODEL15542 a_0_n11917.t6 vdd.n10 0.00025684110045154f
CMODEL15543 a_0_n11917.t6 vdd.t4 0.000188307618875398f
CMODEL15544 a_0_n11917.t6 vdd.n11 0.000620998529839261f
CMODEL15545 a_0_n11917.t6 vdd.n12 0.00153115216491831f
CMODEL15546 a_0_n11917.t6 vdd.n13 0.000116059407688984f
CMODEL15547 a_0_n11917.t6 vdd.t42 9.4225877263549e-06f
CMODEL15548 a_0_n11917.t6 vdd.t41 7.4480673921064e-05f
CMODEL15549 a_0_n11917.t6 vdd.n14 0.000104346444040979f
CMODEL15550 a_0_n11917.t6 vdd.t9 9.4225877263549e-06f
CMODEL15551 a_0_n11917.t6 vdd.t8 7.4480673921064e-05f
CMODEL15552 a_0_n11917.t6 vdd.n15 0.000200331294107905f
CMODEL15553 a_0_n11917.t6 vdd.t15 1.58685584731771e-05f
CMODEL15554 a_0_n11917.t6 vdd.n16 0.000124818885108747f
CMODEL15555 a_0_n11917.t6 vdd.t14 0.000214056978353298f
CMODEL15556 a_0_n11917.t6 vdd.n17 0.000174844313301364f
CMODEL15557 a_0_n11917.t6 vdd.t32 0.000214056978353298f
CMODEL15558 a_0_n11917.t6 vdd.n18 0.00017259510666466f
CMODEL15559 a_0_n11917.t6 vdd.t34 1.58685584731771e-05f
CMODEL15560 a_0_n11917.t6 vdd.n19 0.00017380515566875f
CMODEL15561 a_0_n11917.t6 vdd.t33 0.000214056978353298f
CMODEL15562 a_0_n11917.t6 vdd.n20 0.000346853383394143f
CMODEL15563 a_0_n11917.t6 vdd.t48 0.000214466081939559f
CMODEL15564 a_0_n11917.t6 vdd.n21 0.000615702623498965f
CMODEL15565 a_0_n11917.t6 vdd.n22 0.00269823666157331f
CMODEL15566 a_0_n11917.t6 vdd.t47 3.05055770576696e-06f
CMODEL15567 a_0_n11917.t6 vdd.t45 3.01923625187365e-06f
CMODEL15568 a_0_n11917.t6 vdd.n23 3.44762121812895e-05f
CMODEL15569 a_0_n11917.t6 vdd.t46 8.22793620745266e-05f
CMODEL15570 a_0_n11917.t6 vdd.n24 8.8401761229599e-05f
CMODEL15571 a_0_n11917.t6 vdd.t44 8.22793620745266e-05f
CMODEL15572 a_0_n11917.t6 vdd.n25 0.000139418014141685f
CMODEL15573 a_0_n11917.t6 vdd.t43 8.24575896917482e-05f
CMODEL15574 a_0_n11917.t6 vdd.n26 0.000745965002950646f
CMODEL15575 a_0_n11917.t6 vdd.n27 0.000498692956214045f
CMODEL15576 a_0_n11917.t6 vdd.n28 0.000112645895698131f
CMODEL15577 a_0_n11917.t6 vdd.t29 9.4225877263549e-06f
CMODEL15578 a_0_n11917.t6 vdd.t28 7.4480673921064e-05f
CMODEL15579 a_0_n11917.t6 vdd.n29 1.68151931006276e-05f
CMODEL15580 a_0_n11917.t6 vdd.n30 5.36441824467879e-06f
CMODEL15581 a_0_n11917.t6 vdd.t38 2.46989817047345e-06f
CMODEL15582 a_0_n11917.t6 vdd.t40 2.46989817047345e-06f
CMODEL15583 a_0_n11917.t6 vdd.t37 4.99092565835224e-05f
CMODEL15584 a_0_n11917.t6 vdd.t39 4.99092565835224e-05f
CMODEL15585 a_0_n11917.t6 vdd.n31 1.61644249486421e-05f
CMODEL15586 a_0_n11917.t6 vdd.n32 0.000195070774364733f
CMODEL15587 a_0_n11917.t6 vdd.n33 9.88425335566135e-05f
CMODEL15588 a_0_n11917.t6 vdd.t17 9.4225877263549e-06f
CMODEL15589 a_0_n11917.t6 vdd.t16 7.4480673921064e-05f
CMODEL15590 a_0_n11917.t6 vdd.n34 1.68151931006276e-05f
CMODEL15591 a_0_n11917.t6 vdd.n35 5.36441824467879e-06f
CMODEL15592 a_0_n11917.t6 vdd.t1 2.46989817047345e-06f
CMODEL15593 a_0_n11917.t6 vdd.t31 2.46989817047345e-06f
CMODEL15594 a_0_n11917.t6 vdd.t0 4.99092565835224e-05f
CMODEL15595 a_0_n11917.t6 vdd.t30 4.99092565835224e-05f
CMODEL15596 a_0_n11917.t6 vdd.n36 1.61644249486421e-05f
CMODEL15597 a_0_n11917.t6 vdd.n37 0.000189180200575209f
CMODEL15598 a_0_n11917.t6 vdd.n38 0.000109127950091377f
CMODEL15599 a_0_n11917.t6 vdd.t19 9.4225877263549e-06f
CMODEL15600 a_0_n11917.t6 vdd.t18 7.4480673921064e-05f
CMODEL15601 a_0_n11917.t6 vdd.n39 9.20888720323605e-05f
CMODEL15602 a_0_n11917.t6 vdd.t21 9.42267403512838e-06f
CMODEL15603 a_0_n11917.t6 vdd.t20 7.4480673921064e-05f
CMODEL15604 a_0_n11917.t6 vdd.n40 9.20888720323605e-05f
CMODEL15605 a_0_n11917.t6 vdd.t11 9.4225877263549e-06f
CMODEL15606 a_0_n11917.t6 vdd.t10 7.4480673921064e-05f
CMODEL15607 a_0_n11917.t6 vdd.n41 0.000396183162872568f
CMODEL15608 a_0_n11917.t6 vdd.n42 0.000758888015602741f
CMODEL15609 a_0_n11917.t6 vdd.n43 9.20888720323605e-05f
CMODEL15610 a_0_n11917.t6 vdd.t13 9.4225877263549e-06f
CMODEL15611 a_0_n11917.t6 vdd.t12 7.4480673921064e-05f
CMODEL15612 a_0_n11917.t6 vdd.n44 9.20888720323605e-05f
CMODEL15613 a_0_n11917.t6 vdd.t23 9.4225877263549e-06f
CMODEL15614 a_0_n11917.t6 vdd.t22 7.4480673921064e-05f
CMODEL15615 a_0_n11917.t6 vdd.n45 0.000113679874804337f
CMODEL15616 a_0_n11917.t6 vdd.n46 0.00187640452056453f
CMODEL15617 a_0_n11917.n1 vdd 0.000228053005543457f
CMODEL15618 a_0_n11917.n1 vdd.n0 0.0765303449419837f
CMODEL15619 a_0_n11917.n1 vdd.n1 0.00709212506854229f
CMODEL15620 a_0_n11917.n1 vdd.t7 0.000584649271788729f
CMODEL15621 a_0_n11917.n1 vdd.t6 0.00462134957348167f
CMODEL15622 a_0_n11917.n1 vdd.n2 0.00635979392515419f
CMODEL15623 a_0_n11917.n1 vdd.t27 0.000584649271788729f
CMODEL15624 a_0_n11917.n1 vdd.t26 0.00462134957348167f
CMODEL15625 a_0_n11917.n1 vdd.n3 0.0119286166628976f
CMODEL15626 a_0_n11917.n1 vdd.n4 0.00635979392515419f
CMODEL15627 a_0_n11917.n1 vdd.t36 0.000584649271788729f
CMODEL15628 a_0_n11917.n1 vdd.t35 0.00462134957348167f
CMODEL15629 a_0_n11917.n1 vdd.n5 0.00907442631926651f
CMODEL15630 a_0_n11917.n1 vdd.t3 0.000931311004183183f
CMODEL15631 a_0_n11917.n1 vdd.n6 0.00891034130110628f
CMODEL15632 a_0_n11917.n1 vdd.t2 0.01167761585346f
CMODEL15633 a_0_n11917.n1 vdd.n7 0.0119446824283833f
CMODEL15634 a_0_n11917.n1 vdd.t25 0.000931311004183183f
CMODEL15635 a_0_n11917.n1 vdd.n8 0.00538192433259356f
CMODEL15636 a_0_n11917.n1 vdd.t24 0.01167761585346f
CMODEL15637 a_0_n11917.n1 vdd.n9 0.0119446824283833f
CMODEL15638 a_0_n11917.n1 vdd.t5 0.000931311004183183f
CMODEL15639 a_0_n11917.n1 vdd.n10 0.0159363825209509f
CMODEL15640 a_0_n11917.n1 vdd.t4 0.0116840421596542f
CMODEL15641 a_0_n11917.n1 vdd.n11 0.0385314893101925f
CMODEL15642 a_0_n11917.n1 vdd.n12 0.0950043686739465f
CMODEL15643 a_0_n11917.n1 vdd.n13 0.00720121161618993f
CMODEL15644 a_0_n11917.n1 vdd.t42 0.000584649271788729f
CMODEL15645 a_0_n11917.n1 vdd.t41 0.00462134957348167f
CMODEL15646 a_0_n11917.n1 vdd.n14 0.0064744499381702f
CMODEL15647 a_0_n11917.n1 vdd.t9 0.000584649271788729f
CMODEL15648 a_0_n11917.n1 vdd.t8 0.00462134957348167f
CMODEL15649 a_0_n11917.n1 vdd.n15 0.0124300827562567f
CMODEL15650 a_0_n11917.n1 vdd.t15 0.000984606503554286f
CMODEL15651 a_0_n11917.n1 vdd.n16 0.00774471646256988f
CMODEL15652 a_0_n11917.n1 vdd.t14 0.0132817289846517f
CMODEL15653 a_0_n11917.n1 vdd.n17 0.0108486759069514f
CMODEL15654 a_0_n11917.n1 vdd.t32 0.0132817289846517f
CMODEL15655 a_0_n11917.n1 vdd.n18 0.0107091179574326f
CMODEL15656 a_0_n11917.n1 vdd.t34 0.000984606503554286f
CMODEL15657 a_0_n11917.n1 vdd.n19 0.0107841986348023f
CMODEL15658 a_0_n11917.n1 vdd.t33 0.0132817289846517f
CMODEL15659 a_0_n11917.n1 vdd.n20 0.0215214316818348f
CMODEL15660 a_0_n11917.n1 vdd.t48 0.013307112894119f
CMODEL15661 a_0_n11917.n1 vdd.n21 0.0382028908534591f
CMODEL15662 a_0_n11917.n1 vdd.n22 0.16741920002402f
CMODEL15663 a_0_n11917.n1 vdd.t47 0.00018927988712036f
CMODEL15664 a_0_n11917.n1 vdd.t45 0.000187336465022111f
CMODEL15665 a_0_n11917.n1 vdd.n23 0.00213916738492623f
CMODEL15666 a_0_n11917.n1 vdd.t46 0.00510523971939948f
CMODEL15667 a_0_n11917.n1 vdd.n24 0.00548512009956313f
CMODEL15668 a_0_n11917.n1 vdd.t44 0.00510523971939948f
CMODEL15669 a_0_n11917.n1 vdd.n25 0.00865055787320313f
CMODEL15670 a_0_n11917.n1 vdd.t43 0.00511629832130878f
CMODEL15671 a_0_n11917.n1 vdd.n26 0.0462853632590892f
CMODEL15672 a_0_n11917.n1 vdd.n27 0.0309427178779368f
CMODEL15673 a_0_n11917.n1 vdd.n28 0.00698941127453729f
CMODEL15674 a_0_n11917.n1 vdd.t29 0.000584649271788729f
CMODEL15675 a_0_n11917.n1 vdd.t28 0.00462134957348167f
CMODEL15676 a_0_n11917.n1 vdd.n29 0.00104334294216987f
CMODEL15677 a_0_n11917.n1 vdd.n30 0.000332849458280914f
CMODEL15678 a_0_n11917.n1 vdd.t38 0.000153251336967731f
CMODEL15679 a_0_n11917.n1 vdd.t40 0.000153251336967731f
CMODEL15680 a_0_n11917.n1 vdd.t37 0.00309675127093363f
CMODEL15681 a_0_n11917.n1 vdd.t39 0.00309675127093363f
CMODEL15682 a_0_n11917.n1 vdd.n31 0.00100296431824924f
CMODEL15683 a_0_n11917.n1 vdd.n32 0.0121036799541397f
CMODEL15684 a_0_n11917.n1 vdd.n33 0.00613294531649664f
CMODEL15685 a_0_n11917.n1 vdd.t17 0.000584649271788729f
CMODEL15686 a_0_n11917.n1 vdd.t16 0.00462134957348167f
CMODEL15687 a_0_n11917.n1 vdd.n34 0.00104334294216987f
CMODEL15688 a_0_n11917.n1 vdd.n35 0.000332849458280914f
CMODEL15689 a_0_n11917.n1 vdd.t1 0.000153251336967731f
CMODEL15690 a_0_n11917.n1 vdd.t31 0.000153251336967731f
CMODEL15691 a_0_n11917.n1 vdd.t0 0.00309675127093363f
CMODEL15692 a_0_n11917.n1 vdd.t30 0.00309675127093363f
CMODEL15693 a_0_n11917.n1 vdd.n36 0.00100296431824924f
CMODEL15694 a_0_n11917.n1 vdd.n37 0.0117381837893409f
CMODEL15695 a_0_n11917.n1 vdd.n38 0.00677113107413876f
CMODEL15696 a_0_n11917.n1 vdd.t19 0.000584649271788729f
CMODEL15697 a_0_n11917.n1 vdd.t18 0.00462134957348167f
CMODEL15698 a_0_n11917.n1 vdd.n39 0.00571389660007895f
CMODEL15699 a_0_n11917.n1 vdd.t21 0.000584654627043891f
CMODEL15700 a_0_n11917.n1 vdd.t20 0.00462134957348167f
CMODEL15701 a_0_n11917.n1 vdd.n40 0.00571389660007895f
CMODEL15702 a_0_n11917.n1 vdd.t11 0.000584649271788729f
CMODEL15703 a_0_n11917.n1 vdd.t10 0.00462134957348167f
CMODEL15704 a_0_n11917.n1 vdd.n41 0.0245822277696115f
CMODEL15705 a_0_n11917.n1 vdd.n42 0.0470872056144786f
CMODEL15706 a_0_n11917.n1 vdd.n43 0.00571389660007895f
CMODEL15707 a_0_n11917.n1 vdd.t13 0.000584649271788729f
CMODEL15708 a_0_n11917.n1 vdd.t12 0.00462134957348167f
CMODEL15709 a_0_n11917.n1 vdd.n44 0.00571389660007895f
CMODEL15710 a_0_n11917.n1 vdd.t23 0.000584649271788729f
CMODEL15711 a_0_n11917.n1 vdd.t22 0.00462134957348167f
CMODEL15712 a_0_n11917.n1 vdd.n45 0.0070535672313767f
CMODEL15713 a_0_n11917.n1 vdd.n46 0.116426460372528f
CMODEL15714 a_0_n11917.t4 vdd 2.91784429098085e-07f
CMODEL15715 a_0_n11917.t4 vdd.n0 9.79174247423853e-05f
CMODEL15716 a_0_n11917.t4 vdd.n1 9.07408196303072e-06f
CMODEL15717 a_0_n11917.t4 vdd.t7 7.48034666699352e-07f
CMODEL15718 a_0_n11917.t4 vdd.t6 5.91282646658246e-06f
CMODEL15719 a_0_n11917.t4 vdd.n2 8.13709442333559e-06f
CMODEL15720 a_0_n11917.t4 vdd.t27 7.48034666699352e-07f
CMODEL15721 a_0_n11917.t4 vdd.t26 5.91282646658246e-06f
CMODEL15722 a_0_n11917.t4 vdd.n3 1.5262173785516e-05f
CMODEL15723 a_0_n11917.t4 vdd.n4 8.13709442333559e-06f
CMODEL15724 a_0_n11917.t4 vdd.t36 7.48034666699352e-07f
CMODEL15725 a_0_n11917.t4 vdd.t35 5.91282646658246e-06f
CMODEL15726 a_0_n11917.t4 vdd.n5 1.16103547798026e-05f
CMODEL15727 a_0_n11917.t4 vdd.t3 1.19157407735445e-06f
CMODEL15728 a_0_n11917.t4 vdd.n6 1.14004147562833e-05f
CMODEL15729 a_0_n11917.t4 vdd.t2 1.49410285863532e-05f
CMODEL15730 a_0_n11917.t4 vdd.n7 1.52827292708475e-05f
CMODEL15731 a_0_n11917.t4 vdd.t25 1.19157407735445e-06f
CMODEL15732 a_0_n11917.t4 vdd.n8 6.8859505494904e-06f
CMODEL15733 a_0_n11917.t4 vdd.t24 1.49410285863532e-05f
CMODEL15734 a_0_n11917.t4 vdd.n9 1.52827292708475e-05f
CMODEL15735 a_0_n11917.t4 vdd.t5 1.19157407735445e-06f
CMODEL15736 a_0_n11917.t4 vdd.n10 2.0389945156317e-05f
CMODEL15737 a_0_n11917.t4 vdd.t4 1.49492507804858e-05f
CMODEL15738 a_0_n11917.t4 vdd.n11 4.92994537997048e-05f
CMODEL15739 a_0_n11917.t4 vdd.n12 0.0001215541773251f
CMODEL15740 a_0_n11917.t4 vdd.n13 9.21365370843175e-06f
CMODEL15741 a_0_n11917.t4 vdd.t42 7.48034666699352e-07f
CMODEL15742 a_0_n11917.t4 vdd.t41 5.91282646658246e-06f
CMODEL15743 a_0_n11917.t4 vdd.n14 8.28379207031821e-06f
CMODEL15744 a_0_n11917.t4 vdd.t9 7.48034666699352e-07f
CMODEL15745 a_0_n11917.t4 vdd.t8 5.91282646658246e-06f
CMODEL15746 a_0_n11917.t4 vdd.n15 1.59037790009972e-05f
CMODEL15747 a_0_n11917.t4 vdd.t15 1.25976347402755e-06f
CMODEL15748 a_0_n11917.t4 vdd.n16 9.90904577719708e-06f
CMODEL15749 a_0_n11917.t4 vdd.t14 1.69934252784211e-05f
CMODEL15750 a_0_n11917.t4 vdd.n17 1.38804340615312e-05f
CMODEL15751 a_0_n11917.t4 vdd.t32 1.69934252784211e-05f
CMODEL15752 a_0_n11917.t4 vdd.n18 1.37018754122847e-05f
CMODEL15753 a_0_n11917.t4 vdd.t34 1.25976347402755e-06f
CMODEL15754 a_0_n11917.t4 vdd.n19 1.37979380470674e-05f
CMODEL15755 a_0_n11917.t4 vdd.t33 1.69934252784211e-05f
CMODEL15756 a_0_n11917.t4 vdd.n20 2.75357855586823e-05f
CMODEL15757 a_0_n11917.t4 vdd.t48 1.70259029452449e-05f
CMODEL15758 a_0_n11917.t4 vdd.n21 4.88790256063908e-05f
CMODEL15759 a_0_n11917.t4 vdd.n22 0.000214205971908395f
CMODEL15760 a_0_n11917.t4 vdd.t47 2.42175820798994e-07f
CMODEL15761 a_0_n11917.t4 vdd.t45 2.39689292256725e-07f
CMODEL15762 a_0_n11917.t4 vdd.n23 2.7369765755488e-06f
CMODEL15763 a_0_n11917.t4 vdd.t46 6.53194398111095e-06f
CMODEL15764 a_0_n11917.t4 vdd.n24 7.0179852836032e-06f
CMODEL15765 a_0_n11917.t4 vdd.t44 6.53194398111095e-06f
CMODEL15766 a_0_n11917.t4 vdd.n25 1.10680325584726e-05f
CMODEL15767 a_0_n11917.t4 vdd.t43 6.54609300684749e-06f
CMODEL15768 a_0_n11917.t4 vdd.n26 5.92202162035409e-05f
CMODEL15769 a_0_n11917.t4 vdd.n27 3.95899332667924e-05f
CMODEL15770 a_0_n11917.t4 vdd.n28 8.94266389347787e-06f
CMODEL15771 a_0_n11917.t4 vdd.t29 7.48034666699352e-07f
CMODEL15772 a_0_n11917.t4 vdd.t28 5.91282646658246e-06f
CMODEL15773 a_0_n11917.t4 vdd.n29 1.33491432839959e-06f
CMODEL15774 a_0_n11917.t4 vdd.n30 4.25867174732747e-07f
CMODEL15775 a_0_n11917.t4 vdd.t38 1.96078774577371e-07f
CMODEL15776 a_0_n11917.t4 vdd.t40 1.96078774577371e-07f
CMODEL15777 a_0_n11917.t4 vdd.t37 3.96216572324874e-06f
CMODEL15778 a_0_n11917.t4 vdd.t39 3.96216572324874e-06f
CMODEL15779 a_0_n11917.t4 vdd.n31 1.28325154193303e-06f
CMODEL15780 a_0_n11917.t4 vdd.n32 1.54861600573451e-05f
CMODEL15781 a_0_n11917.t4 vdd.n33 7.84685097045453e-06f
CMODEL15782 a_0_n11917.t4 vdd.t17 7.48034666699352e-07f
CMODEL15783 a_0_n11917.t4 vdd.t16 5.91282646658246e-06f
CMODEL15784 a_0_n11917.t4 vdd.n34 1.33491432839959e-06f
CMODEL15785 a_0_n11917.t4 vdd.n35 4.25867174732747e-07f
CMODEL15786 a_0_n11917.t4 vdd.t1 1.96078774577371e-07f
CMODEL15787 a_0_n11917.t4 vdd.t31 1.96078774577371e-07f
CMODEL15788 a_0_n11917.t4 vdd.t0 3.96216572324874e-06f
CMODEL15789 a_0_n11917.t4 vdd.t30 3.96216572324874e-06f
CMODEL15790 a_0_n11917.t4 vdd.n36 1.28325154193303e-06f
CMODEL15791 a_0_n11917.t4 vdd.n37 1.50185227660531e-05f
CMODEL15792 a_0_n11917.t4 vdd.n38 8.66338336610695e-06f
CMODEL15793 a_0_n11917.t4 vdd.t19 7.48034666699352e-07f
CMODEL15794 a_0_n11917.t4 vdd.t18 5.91282646658246e-06f
CMODEL15795 a_0_n11917.t4 vdd.n39 7.31069539472404e-06f
CMODEL15796 a_0_n11917.t4 vdd.t21 7.48041518527796e-07f
CMODEL15797 a_0_n11917.t4 vdd.t20 5.91282646658246e-06f
CMODEL15798 a_0_n11917.t4 vdd.n40 7.31069539472404e-06f
CMODEL15799 a_0_n11917.t4 vdd.t11 7.48034666699352e-07f
CMODEL15800 a_0_n11917.t4 vdd.t10 5.91282646658246e-06f
CMODEL15801 a_0_n11917.t4 vdd.n41 3.14519481057591e-05f
CMODEL15802 a_0_n11917.t4 vdd.n42 6.0246140476437e-05f
CMODEL15803 a_0_n11917.t4 vdd.n43 7.31069539472404e-06f
CMODEL15804 a_0_n11917.t4 vdd.t13 7.48034666699352e-07f
CMODEL15805 a_0_n11917.t4 vdd.t12 5.91282646658246e-06f
CMODEL15806 a_0_n11917.t4 vdd.n44 7.31069539472404e-06f
CMODEL15807 a_0_n11917.t4 vdd.t23 7.48034666699352e-07f
CMODEL15808 a_0_n11917.t4 vdd.t22 5.91282646658246e-06f
CMODEL15809 a_0_n11917.t4 vdd.n45 9.02474879823508e-06f
CMODEL15810 a_0_n11917.t4 vdd.n46 0.000148962861466149f
CMODEL15811 a_0_n11917.t5 vdd 2.94594407855392e-07f
CMODEL15812 a_0_n11917.t5 vdd.n0 9.88604013239212e-05f
CMODEL15813 a_0_n11917.t5 vdd.n1 9.16146831752878e-06f
CMODEL15814 a_0_n11917.t5 vdd.t7 7.55238483330869e-07f
CMODEL15815 a_0_n11917.t5 vdd.t6 5.9697689045943e-06f
CMODEL15816 a_0_n11917.t5 vdd.n2 8.21545728370635e-06f
CMODEL15817 a_0_n11917.t5 vdd.t27 7.55238483330869e-07f
CMODEL15818 a_0_n11917.t5 vdd.t26 5.9697689045943e-06f
CMODEL15819 a_0_n11917.t5 vdd.n3 1.54091534727467e-05f
CMODEL15820 a_0_n11917.t5 vdd.n4 8.21545728370635e-06f
CMODEL15821 a_0_n11917.t5 vdd.t36 7.55238483330869e-07f
CMODEL15822 a_0_n11917.t5 vdd.t35 5.9697689045943e-06f
CMODEL15823 a_0_n11917.t5 vdd.n5 1.17221662647296e-05f
CMODEL15824 a_0_n11917.t5 vdd.t3 1.20304932247111e-06f
CMODEL15825 a_0_n11917.t5 vdd.n6 1.15102044506432e-05f
CMODEL15826 a_0_n11917.t5 vdd.t2 1.50849155410812e-05f
CMODEL15827 a_0_n11917.t5 vdd.n7 1.54299069140737e-05f
CMODEL15828 a_0_n11917.t5 vdd.t25 1.20304932247111e-06f
CMODEL15829 a_0_n11917.t5 vdd.n8 6.95226448826959e-06f
CMODEL15830 a_0_n11917.t5 vdd.t24 1.50849155410812e-05f
CMODEL15831 a_0_n11917.t5 vdd.n9 1.54299069140737e-05f
CMODEL15832 a_0_n11917.t5 vdd.t5 1.20304932247111e-06f
CMODEL15833 a_0_n11917.t5 vdd.n10 2.05863069461802e-05f
CMODEL15834 a_0_n11917.t5 vdd.t4 1.5093216917612e-05f
CMODEL15835 a_0_n11917.t5 vdd.n11 4.97742235410245e-05f
CMODEL15836 a_0_n11917.t5 vdd.n12 0.000122724783505839f
CMODEL15837 a_0_n11917.t5 vdd.n13 9.30238418413911e-06f
CMODEL15838 a_0_n11917.t5 vdd.t42 7.55238483330869e-07f
CMODEL15839 a_0_n11917.t5 vdd.t41 5.9697689045943e-06f
CMODEL15840 a_0_n11917.t5 vdd.n14 8.36356767664337e-06f
CMODEL15841 a_0_n11917.t5 vdd.t9 7.55238483330869e-07f
CMODEL15842 a_0_n11917.t5 vdd.t8 5.9697689045943e-06f
CMODEL15843 a_0_n11917.t5 vdd.n15 1.60569375547001e-05f
CMODEL15844 a_0_n11917.t5 vdd.t15 1.27189540516654e-06f
CMODEL15845 a_0_n11917.t5 vdd.n16 1.00044731042315e-05f
CMODEL15846 a_0_n11917.t5 vdd.t14 1.71570774794444e-05f
CMODEL15847 a_0_n11917.t5 vdd.n17 1.40141071467458e-05f
CMODEL15848 a_0_n11917.t5 vdd.t32 1.71570774794444e-05f
CMODEL15849 a_0_n11917.t5 vdd.n18 1.38338289197519e-05f
CMODEL15850 a_0_n11917.t5 vdd.t34 1.27189540516654e-06f
CMODEL15851 a_0_n11917.t5 vdd.n19 1.39308166688867e-05f
CMODEL15852 a_0_n11917.t5 vdd.t33 1.71570774794444e-05f
CMODEL15853 a_0_n11917.t5 vdd.n20 2.78009641109609e-05f
CMODEL15854 a_0_n11917.t5 vdd.t48 1.71898679167411e-05f
CMODEL15855 a_0_n11917.t5 vdd.n21 4.93497464877496e-05f
CMODEL15856 a_0_n11917.t5 vdd.n22 0.00021626884494316f
CMODEL15857 a_0_n11917.t5 vdd.t47 2.44508052556809e-07f
CMODEL15858 a_0_n11917.t5 vdd.t45 2.4199757793762e-07f
CMODEL15859 a_0_n11917.t5 vdd.n23 2.76333454831764e-06f
CMODEL15860 a_0_n11917.t5 vdd.t46 6.59484872173599e-06f
CMODEL15861 a_0_n11917.t5 vdd.n24 7.08557075972669e-06f
CMODEL15862 a_0_n11917.t5 vdd.t44 6.59484872173599e-06f
CMODEL15863 a_0_n11917.t5 vdd.n25 1.11746213043856e-05f
CMODEL15864 a_0_n11917.t5 vdd.t43 6.60913400718275e-06f
CMODEL15865 a_0_n11917.t5 vdd.n26 5.97905261068124e-05f
CMODEL15866 a_0_n11917.t5 vdd.n27 3.99711971739404e-05f
CMODEL15867 a_0_n11917.t5 vdd.n28 9.02878464931149e-06f
CMODEL15868 a_0_n11917.t5 vdd.t29 7.55238483330869e-07f
CMODEL15869 a_0_n11917.t5 vdd.t28 5.9697689045943e-06f
CMODEL15870 a_0_n11917.t5 vdd.n29 1.34776998665806e-06f
CMODEL15871 a_0_n11917.t5 vdd.n30 4.29968413850038e-07f
CMODEL15872 a_0_n11917.t5 vdd.t38 1.97967076818256e-07f
CMODEL15873 a_0_n11917.t5 vdd.t40 1.97967076818256e-07f
CMODEL15874 a_0_n11917.t5 vdd.t37 4.00032266517217e-06f
CMODEL15875 a_0_n11917.t5 vdd.t39 4.00032266517217e-06f
CMODEL15876 a_0_n11917.t5 vdd.n31 1.29560967078953e-06f
CMODEL15877 a_0_n11917.t5 vdd.n32 1.56352968050733e-05f
CMODEL15878 a_0_n11917.t5 vdd.n33 7.9224186921691e-06f
CMODEL15879 a_0_n11917.t5 vdd.t17 7.55238483330869e-07f
CMODEL15880 a_0_n11917.t5 vdd.t16 5.9697689045943e-06f
CMODEL15881 a_0_n11917.t5 vdd.n34 1.34776998665806e-06f
CMODEL15882 a_0_n11917.t5 vdd.n35 4.29968413850038e-07f
CMODEL15883 a_0_n11917.t5 vdd.t1 1.97967076818256e-07f
CMODEL15884 a_0_n11917.t5 vdd.t31 1.97967076818256e-07f
CMODEL15885 a_0_n11917.t5 vdd.t0 4.00032266517217e-06f
CMODEL15886 a_0_n11917.t5 vdd.t30 4.00032266517217e-06f
CMODEL15887 a_0_n11917.t5 vdd.n36 1.29560967078953e-06f
CMODEL15888 a_0_n11917.t5 vdd.n37 1.5163156014884e-05f
CMODEL15889 a_0_n11917.t5 vdd.n38 8.74681455981531e-06f
CMODEL15890 a_0_n11917.t5 vdd.t19 7.55238483330869e-07f
CMODEL15891 a_0_n11917.t5 vdd.t18 5.9697689045943e-06f
CMODEL15892 a_0_n11917.t5 vdd.n39 7.38109976422318e-06f
CMODEL15893 a_0_n11917.t5 vdd.t21 7.55245401144645e-07f
CMODEL15894 a_0_n11917.t5 vdd.t20 5.9697689045943e-06f
CMODEL15895 a_0_n11917.t5 vdd.n40 7.38109976422318e-06f
CMODEL15896 a_0_n11917.t5 vdd.t11 7.55238483330869e-07f
CMODEL15897 a_0_n11917.t5 vdd.t10 5.9697689045943e-06f
CMODEL15898 a_0_n11917.t5 vdd.n41 3.17548405744432e-05f
CMODEL15899 a_0_n11917.t5 vdd.n42 6.0826330363443e-05f
CMODEL15900 a_0_n11917.t5 vdd.n43 7.38109976422318e-06f
CMODEL15901 a_0_n11917.t5 vdd.t13 7.55238483330869e-07f
CMODEL15902 a_0_n11917.t5 vdd.t12 5.9697689045943e-06f
CMODEL15903 a_0_n11917.t5 vdd.n44 7.38109976422318e-06f
CMODEL15904 a_0_n11917.t5 vdd.t23 7.55238483330869e-07f
CMODEL15905 a_0_n11917.t5 vdd.t22 5.9697689045943e-06f
CMODEL15906 a_0_n11917.t5 vdd.n45 9.11166005834398e-06f
CMODEL15907 a_0_n11917.t5 vdd.n46 0.000150397422171261f
CMODEL15908 a_0_n11917.n2 vdd 7.40866356837754e-05f
CMODEL15909 a_0_n11917.n2 vdd.n0 0.0248620962962489f
CMODEL15910 a_0_n11917.n2 vdd.n1 0.00230398930689269f
CMODEL15911 a_0_n11917.n2 vdd.t7 0.000189932588253226f
CMODEL15912 a_0_n11917.n2 vdd.t6 0.00150131870177289f
CMODEL15913 a_0_n11917.n2 vdd.n2 0.0020660799204727f
CMODEL15914 a_0_n11917.n2 vdd.t27 0.000189932588253226f
CMODEL15915 a_0_n11917.n2 vdd.t26 0.00150131870177289f
CMODEL15916 a_0_n11917.n2 vdd.n3 0.00387520030621611f
CMODEL15917 a_0_n11917.n2 vdd.n4 0.0020660799204727f
CMODEL15918 a_0_n11917.n2 vdd.t36 0.000189932588253226f
CMODEL15919 a_0_n11917.n2 vdd.t35 0.00150131870177289f
CMODEL15920 a_0_n11917.n2 vdd.n5 0.00294797130672611f
CMODEL15921 a_0_n11917.n2 vdd.t3 0.000302551149943352f
CMODEL15922 a_0_n11917.n2 vdd.n6 0.00289466568625146f
CMODEL15923 a_0_n11917.n2 vdd.t2 0.00379365871249396f
CMODEL15924 a_0_n11917.n2 vdd.n7 0.00388041952493099f
CMODEL15925 a_0_n11917.n2 vdd.t25 0.000302551149943352f
CMODEL15926 a_0_n11917.n2 vdd.n8 0.00174840347469363f
CMODEL15927 a_0_n11917.n2 vdd.t24 0.00379365871249396f
CMODEL15928 a_0_n11917.n2 vdd.n9 0.00388041952493099f
CMODEL15929 a_0_n11917.n2 vdd.t5 0.000302551149943352f
CMODEL15930 a_0_n11917.n2 vdd.n10 0.00517718660683027f
CMODEL15931 a_0_n11917.n2 vdd.t4 0.00379574639997991f
CMODEL15932 a_0_n11917.n2 vdd.n11 0.0125175653970215f
CMODEL15933 a_0_n11917.n2 vdd.n12 0.0308636758964903f
CMODEL15934 a_0_n11917.n2 vdd.n13 0.00233942780196673f
CMODEL15935 a_0_n11917.n2 vdd.t42 0.000189932588253226f
CMODEL15936 a_0_n11917.n2 vdd.t41 0.00150131870177289f
CMODEL15937 a_0_n11917.n2 vdd.n14 0.00210332774470124f
CMODEL15938 a_0_n11917.n2 vdd.t9 0.000189932588253226f
CMODEL15939 a_0_n11917.n2 vdd.t8 0.00150131870177289f
CMODEL15940 a_0_n11917.n2 vdd.n15 0.00403810951970326f
CMODEL15941 a_0_n11917.n2 vdd.t15 0.000319865038160183f
CMODEL15942 a_0_n11917.n2 vdd.n16 0.00251599397109114f
CMODEL15943 a_0_n11917.n2 vdd.t14 0.00431478030377909f
CMODEL15944 a_0_n11917.n2 vdd.n17 0.00352436442420183f
CMODEL15945 a_0_n11917.n2 vdd.t32 0.00431478030377909f
CMODEL15946 a_0_n11917.n2 vdd.n18 0.00347902681096523f
CMODEL15947 a_0_n11917.n2 vdd.t34 0.000319865038160183f
CMODEL15948 a_0_n11917.n2 vdd.n19 0.00350341795975944f
CMODEL15949 a_0_n11917.n2 vdd.t33 0.00431478030377909f
CMODEL15950 a_0_n11917.n2 vdd.n20 0.00699157840347571f
CMODEL15951 a_0_n11917.n2 vdd.t48 0.0043230266693486f
CMODEL15952 a_0_n11917.n2 vdd.n21 0.0124108149769064f
CMODEL15953 a_0_n11917.n2 vdd.n22 0.0543887823319439f
CMODEL15954 a_0_n11917.n2 vdd.t47 6.14905732372822e-05f
CMODEL15955 a_0_n11917.n2 vdd.t45 6.08592217467388e-05f
CMODEL15956 a_0_n11917.n2 vdd.n23 0.000694942451365519f
CMODEL15957 a_0_n11917.n2 vdd.t46 0.00165851808998595f
CMODEL15958 a_0_n11917.n2 vdd.n24 0.00178192825623888f
CMODEL15959 a_0_n11917.n2 vdd.t44 0.00165851808998595f
CMODEL15960 a_0_n11917.n2 vdd.n25 0.00281027091963184f
CMODEL15961 a_0_n11917.n2 vdd.t43 0.00166211065220136f
CMODEL15962 a_0_n11917.n2 vdd.n26 0.0150365343227801f
CMODEL15963 a_0_n11917.n2 vdd.n27 0.0100522326422561f
CMODEL15964 a_0_n11917.n2 vdd.n28 0.00227062110190888f
CMODEL15965 a_0_n11917.n2 vdd.t29 0.000189932588253226f
CMODEL15966 a_0_n11917.n2 vdd.t28 0.00150131870177289f
CMODEL15967 a_0_n11917.n2 vdd.n29 0.000338946501781787f
CMODEL15968 a_0_n11917.n2 vdd.n30 0.000108131425386986f
CMODEL15969 a_0_n11917.n2 vdd.t38 4.97861273212477e-05f
CMODEL15970 a_0_n11917.n2 vdd.t40 4.97861273212477e-05f
CMODEL15971 a_0_n11917.n2 vdd.t37 0.00100602876364727f
CMODEL15972 a_0_n11917.n2 vdd.t39 0.00100602876364727f
CMODEL15973 a_0_n11917.n2 vdd.n31 0.00032582886541172f
CMODEL15974 a_0_n11917.n2 vdd.n32 0.0039320723928126f
CMODEL15975 a_0_n11917.n2 vdd.n33 0.00199238455221859f
CMODEL15976 a_0_n11917.n2 vdd.t17 0.000189932588253226f
CMODEL15977 a_0_n11917.n2 vdd.t16 0.00150131870177289f
CMODEL15978 a_0_n11917.n2 vdd.n34 0.000338946501781787f
CMODEL15979 a_0_n11917.n2 vdd.n35 0.000108131425386986f
CMODEL15980 a_0_n11917.n2 vdd.t1 4.97861273212477e-05f
CMODEL15981 a_0_n11917.n2 vdd.t31 4.97861273212477e-05f
CMODEL15982 a_0_n11917.n2 vdd.t0 0.00100602876364727f
CMODEL15983 a_0_n11917.n2 vdd.t30 0.00100602876364727f
CMODEL15984 a_0_n11917.n2 vdd.n36 0.00032582886541172f
CMODEL15985 a_0_n11917.n2 vdd.n37 0.00381333516704906f
CMODEL15986 a_0_n11917.n2 vdd.n38 0.00219970931696937f
CMODEL15987 a_0_n11917.n2 vdd.t19 0.000189932588253226f
CMODEL15988 a_0_n11917.n2 vdd.t18 0.00150131870177289f
CMODEL15989 a_0_n11917.n2 vdd.n39 0.00185624993073878f
CMODEL15990 a_0_n11917.n2 vdd.t21 0.000189934327992798f
CMODEL15991 a_0_n11917.n2 vdd.t20 0.00150131870177289f
CMODEL15992 a_0_n11917.n2 vdd.n40 0.00185624993073878f
CMODEL15993 a_0_n11917.n2 vdd.t11 0.000189932588253226f
CMODEL15994 a_0_n11917.n2 vdd.t10 0.00150131870177289f
CMODEL15995 a_0_n11917.n2 vdd.n41 0.00798592655563908f
CMODEL15996 a_0_n11917.n2 vdd.n42 0.0152970255288398f
CMODEL15997 a_0_n11917.n2 vdd.n43 0.00185624993073878f
CMODEL15998 a_0_n11917.n2 vdd.t13 0.000189932588253226f
CMODEL15999 a_0_n11917.n2 vdd.t12 0.00150131870177289f
CMODEL16000 a_0_n11917.n2 vdd.n44 0.00185624993073878f
CMODEL16001 a_0_n11917.n2 vdd.t23 0.000189932588253226f
CMODEL16002 a_0_n11917.n2 vdd.t22 0.00150131870177289f
CMODEL16003 a_0_n11917.n2 vdd.n45 0.00229146318197697f
CMODEL16004 a_0_n11917.n2 vdd.n46 0.0378229821309123f
CMODEL16005 a_0_n11917.t0 vdd 5.83927229795519e-07f
CMODEL16006 a_0_n11917.t0 vdd.n0 0.000195955112324764f
CMODEL16007 a_0_n11917.t0 vdd.n1 1.81593087745915e-05f
CMODEL16008 a_0_n11917.t0 vdd.t7 1.49698807461016e-06f
CMODEL16009 a_0_n11917.t0 vdd.t6 1.18329151064209e-05f
CMODEL16010 a_0_n11917.t0 vdd.n2 1.62841828807996e-05f
CMODEL16011 a_0_n11917.t0 vdd.t27 1.49698807461016e-06f
CMODEL16012 a_0_n11917.t0 vdd.t26 1.18329151064209e-05f
CMODEL16013 a_0_n11917.t0 vdd.n3 3.05430926755805e-05f
CMODEL16014 a_0_n11917.t0 vdd.n4 1.62841828807996e-05f
CMODEL16015 a_0_n11917.t0 vdd.t36 1.49698807461016e-06f
CMODEL16016 a_0_n11917.t0 vdd.t35 1.18329151064209e-05f
CMODEL16017 a_0_n11917.t0 vdd.n5 2.32349694754763e-05f
CMODEL16018 a_0_n11917.t0 vdd.t3 2.38461165400928e-06f
CMODEL16019 a_0_n11917.t0 vdd.n6 2.28148315786881e-05f
CMODEL16020 a_0_n11917.t0 vdd.t2 2.99004078445602e-05f
CMODEL16021 a_0_n11917.t0 vdd.n7 3.05842288926289e-05f
CMODEL16022 a_0_n11917.t0 vdd.t25 2.38461165400928e-06f
CMODEL16023 a_0_n11917.t0 vdd.n8 1.37803584697839e-05f
CMODEL16024 a_0_n11917.t0 vdd.t24 2.99004078445602e-05f
CMODEL16025 a_0_n11917.t0 vdd.n9 3.05842288926289e-05f
CMODEL16026 a_0_n11917.t0 vdd.t5 2.38461165400928e-06f
CMODEL16027 a_0_n11917.t0 vdd.n10 4.0804933380487e-05f
CMODEL16028 a_0_n11917.t0 vdd.t4 2.99168623313796e-05f
CMODEL16029 a_0_n11917.t0 vdd.n11 9.86594575203217e-05f
CMODEL16030 a_0_n11917.t0 vdd.n12 0.000243257648308777f
CMODEL16031 a_0_n11917.t0 vdd.n13 1.84386236883505e-05f
CMODEL16032 a_0_n11917.t0 vdd.t42 1.49698807461016e-06f
CMODEL16033 a_0_n11917.t0 vdd.t41 1.18329151064209e-05f
CMODEL16034 a_0_n11917.t0 vdd.n14 1.6577758349802e-05f
CMODEL16035 a_0_n11917.t0 vdd.t9 1.49698807461016e-06f
CMODEL16036 a_0_n11917.t0 vdd.t8 1.18329151064209e-05f
CMODEL16037 a_0_n11917.t0 vdd.n15 3.18270911303861e-05f
CMODEL16038 a_0_n11917.t0 vdd.t15 2.52107419803134e-06f
CMODEL16039 a_0_n11917.t0 vdd.n16 1.98302619110995e-05f
CMODEL16040 a_0_n11917.t0 vdd.t14 3.40077219961245e-05f
CMODEL16041 a_0_n11917.t0 vdd.n17 2.77779161655837e-05f
CMODEL16042 a_0_n11917.t0 vdd.t32 3.40077219961245e-05f
CMODEL16043 a_0_n11917.t0 vdd.n18 2.74205795601561e-05f
CMODEL16044 a_0_n11917.t0 vdd.t34 2.52107419803134e-06f
CMODEL16045 a_0_n11917.t0 vdd.n19 2.76128228144959e-05f
CMODEL16046 a_0_n11917.t0 vdd.t33 3.40077219961245e-05f
CMODEL16047 a_0_n11917.t0 vdd.n20 5.51053907544868e-05f
CMODEL16048 a_0_n11917.t0 vdd.t48 3.4072717219061e-05f
CMODEL16049 a_0_n11917.t0 vdd.n21 9.78180847609574e-05f
CMODEL16050 a_0_n11917.t0 vdd.n22 0.000428675033032963f
CMODEL16051 a_0_n11917.t0 vdd.t47 4.84649083570789e-07f
CMODEL16052 a_0_n11917.t0 vdd.t45 4.79672972515162e-07f
CMODEL16053 a_0_n11917.t0 vdd.n23 5.47731472414588e-06f
CMODEL16054 a_0_n11917.t0 vdd.t46 1.30719105397755e-05f
CMODEL16055 a_0_n11917.t0 vdd.n24 1.40445901039585e-05f
CMODEL16056 a_0_n11917.t0 vdd.t44 1.30719105397755e-05f
CMODEL16057 a_0_n11917.t0 vdd.n25 2.21496589490147e-05f
CMODEL16058 a_0_n11917.t0 vdd.t43 1.31002259691772e-05f
CMODEL16059 a_0_n11917.t0 vdd.n26 0.000118513167075139f
CMODEL16060 a_0_n11917.t0 vdd.n27 7.92284911560391e-05f
CMODEL16061 a_0_n11917.t0 vdd.n28 1.78963112269284e-05f
CMODEL16062 a_0_n11917.t0 vdd.t29 1.49698807461016e-06f
CMODEL16063 a_0_n11917.t0 vdd.t28 1.18329151064209e-05f
CMODEL16064 a_0_n11917.t0 vdd.n29 2.67146820756047e-06f
CMODEL16065 a_0_n11917.t0 vdd.n30 8.52257402395327e-07f
CMODEL16066 a_0_n11917.t0 vdd.t38 3.92398374425169e-07f
CMODEL16067 a_0_n11917.t0 vdd.t40 3.92398374425169e-07f
CMODEL16068 a_0_n11917.t0 vdd.t37 7.92919780510172e-06f
CMODEL16069 a_0_n11917.t0 vdd.t39 7.92919780510172e-06f
CMODEL16070 a_0_n11917.t0 vdd.n31 2.56807918204537e-06f
CMODEL16071 a_0_n11917.t0 vdd.n32 3.09913403206851e-05f
CMODEL16072 a_0_n11917.t0 vdd.n33 1.57033394960755e-05f
CMODEL16073 a_0_n11917.t0 vdd.t17 1.49698807461016e-06f
CMODEL16074 a_0_n11917.t0 vdd.t16 1.18329151064209e-05f
CMODEL16075 a_0_n11917.t0 vdd.n34 2.67146820756047e-06f
CMODEL16076 a_0_n11917.t0 vdd.n35 8.52257402395327e-07f
CMODEL16077 a_0_n11917.t0 vdd.t1 3.92398374425169e-07f
CMODEL16078 a_0_n11917.t0 vdd.t31 3.92398374425169e-07f
CMODEL16079 a_0_n11917.t0 vdd.t0 7.92919780510172e-06f
CMODEL16080 a_0_n11917.t0 vdd.t30 7.92919780510172e-06f
CMODEL16081 a_0_n11917.t0 vdd.n36 2.56807918204537e-06f
CMODEL16082 a_0_n11917.t0 vdd.n37 3.00554913828329e-05f
CMODEL16083 a_0_n11917.t0 vdd.n38 1.73374071579634e-05f
CMODEL16084 a_0_n11917.t0 vdd.t19 1.49698807461016e-06f
CMODEL16085 a_0_n11917.t0 vdd.t18 1.18329151064209e-05f
CMODEL16086 a_0_n11917.t0 vdd.n39 1.46303698347284e-05f
CMODEL16087 a_0_n11917.t0 vdd.t21 1.49700178668251e-06f
CMODEL16088 a_0_n11917.t0 vdd.t20 1.18329151064209e-05f
CMODEL16089 a_0_n11917.t0 vdd.n40 1.46303698347284e-05f
CMODEL16090 a_0_n11917.t0 vdd.t11 1.49698807461016e-06f
CMODEL16091 a_0_n11917.t0 vdd.t10 1.18329151064209e-05f
CMODEL16092 a_0_n11917.t0 vdd.n41 6.29425257058341e-05f
CMODEL16093 a_0_n11917.t0 vdd.n42 0.000120566275668027f
CMODEL16094 a_0_n11917.t0 vdd.n43 1.46303698347284e-05f
CMODEL16095 a_0_n11917.t0 vdd.t13 1.49698807461016e-06f
CMODEL16096 a_0_n11917.t0 vdd.t12 1.18329151064209e-05f
CMODEL16097 a_0_n11917.t0 vdd.n44 1.46303698347284e-05f
CMODEL16098 a_0_n11917.t0 vdd.t23 1.49698807461016e-06f
CMODEL16099 a_0_n11917.t0 vdd.t22 1.18329151064209e-05f
CMODEL16100 a_0_n11917.t0 vdd.n45 1.80605818536752e-05f
CMODEL16101 a_0_n11917.t0 vdd.n46 0.000298108680121181f
CMODEL16102 a_0_n11917.t3 vdd 1.04865574791738e-06f
CMODEL16103 a_0_n11917.t3 vdd.n0 0.000351909355117961f
CMODEL16104 a_0_n11917.t3 vdd.n1 3.26117066528141e-05f
CMODEL16105 a_0_n11917.t3 vdd.t7 2.68839175311869e-06f
CMODEL16106 a_0_n11917.t3 vdd.t6 2.1250343891844e-05f
CMODEL16107 a_0_n11917.t3 vdd.n2 2.92442296004386e-05f
CMODEL16108 a_0_n11917.t3 vdd.t27 2.68839175311869e-06f
CMODEL16109 a_0_n11917.t3 vdd.t26 2.1250343891844e-05f
CMODEL16110 a_0_n11917.t3 vdd.n3 5.48513377337047e-05f
CMODEL16111 a_0_n11917.t3 vdd.n4 2.92442296004386e-05f
CMODEL16112 a_0_n11917.t3 vdd.t36 2.68839175311869e-06f
CMODEL16113 a_0_n11917.t3 vdd.t35 2.1250343891844e-05f
CMODEL16114 a_0_n11917.t3 vdd.n5 4.17269191259934e-05f
CMODEL16115 a_0_n11917.t3 vdd.t3 4.28244580819303e-06f
CMODEL16116 a_0_n11917.t3 vdd.n6 4.09724072657756e-05f
CMODEL16117 a_0_n11917.t3 vdd.t2 5.36971611381301e-05f
CMODEL16118 a_0_n11917.t3 vdd.n7 5.4925212915841e-05f
CMODEL16119 a_0_n11917.t3 vdd.t25 4.28244580819303e-06f
CMODEL16120 a_0_n11917.t3 vdd.n8 2.47476935144149e-05f
CMODEL16121 a_0_n11917.t3 vdd.t24 5.36971611381301e-05f
CMODEL16122 a_0_n11917.t3 vdd.n9 5.4925212915841e-05f
CMODEL16123 a_0_n11917.t3 vdd.t5 4.28244580819303e-06f
CMODEL16124 a_0_n11917.t3 vdd.n10 7.32802406694028e-05f
CMODEL16125 a_0_n11917.t3 vdd.t4 5.37267112109846e-05f
CMODEL16126 a_0_n11917.t3 vdd.n11 0.000177179281828192f
CMODEL16127 a_0_n11917.t3 vdd.n12 0.000436858427056385f
CMODEL16128 a_0_n11917.t3 vdd.n13 3.31133191395189e-05f
CMODEL16129 a_0_n11917.t3 vdd.t42 2.68839175311869e-06f
CMODEL16130 a_0_n11917.t3 vdd.t41 2.1250343891844e-05f
CMODEL16131 a_0_n11917.t3 vdd.n14 2.9771452150284e-05f
CMODEL16132 a_0_n11917.t3 vdd.t9 2.68839175311869e-06f
CMODEL16133 a_0_n11917.t3 vdd.t8 2.1250343891844e-05f
CMODEL16134 a_0_n11917.t3 vdd.n15 5.71572284187829e-05f
CMODEL16135 a_0_n11917.t3 vdd.t15 4.52751441239954e-06f
CMODEL16136 a_0_n11917.t3 vdd.n16 3.56125165511868e-05f
CMODEL16137 a_0_n11917.t3 vdd.t14 6.10733518238232e-05f
CMODEL16138 a_0_n11917.t3 vdd.n17 4.98854479905089e-05f
CMODEL16139 a_0_n11917.t3 vdd.t32 6.10733518238232e-05f
CMODEL16140 a_0_n11917.t3 vdd.n18 4.92437189083524e-05f
CMODEL16141 a_0_n11917.t3 vdd.t34 4.52751441239954e-06f
CMODEL16142 a_0_n11917.t3 vdd.n19 4.95889622595356e-05f
CMODEL16143 a_0_n11917.t3 vdd.t33 6.10733518238232e-05f
CMODEL16144 a_0_n11917.t3 vdd.n20 9.89619627366264e-05f
CMODEL16145 a_0_n11917.t3 vdd.t48 6.11900746115984e-05f
CMODEL16146 a_0_n11917.t3 vdd.n21 0.000175668288102899f
CMODEL16147 a_0_n11917.t3 vdd.n22 0.000769843423017122f
CMODEL16148 a_0_n11917.t3 vdd.t47 8.70365383349858e-07f
CMODEL16149 a_0_n11917.t3 vdd.t45 8.61428948817448e-07f
CMODEL16150 a_0_n11917.t3 vdd.n23 9.8365297515573e-06f
CMODEL16151 a_0_n11917.t3 vdd.t46 2.34754151276651e-05f
CMODEL16152 a_0_n11917.t3 vdd.n24 2.52222184343365e-05f
CMODEL16153 a_0_n11917.t3 vdd.t44 2.34754151276651e-05f
CMODEL16154 a_0_n11917.t3 vdd.n25 3.97778455706332e-05f
CMODEL16155 a_0_n11917.t3 vdd.t43 2.35262658780356e-05f
CMODEL16156 a_0_n11917.t3 vdd.n26 0.000212833907233196f
CMODEL16157 a_0_n11917.t3 vdd.n27 0.000142283847044941f
CMODEL16158 a_0_n11917.t3 vdd.n28 3.21393979883566e-05f
CMODEL16159 a_0_n11917.t3 vdd.t29 2.68839175311869e-06f
CMODEL16160 a_0_n11917.t3 vdd.t28 2.1250343891844e-05f
CMODEL16161 a_0_n11917.t3 vdd.n29 4.79760207828951e-06f
CMODEL16162 a_0_n11917.t3 vdd.n30 1.53054109848578e-06f
CMODEL16163 a_0_n11917.t3 vdd.t38 7.04695362397272e-07f
CMODEL16164 a_0_n11917.t3 vdd.t40 7.04695362397272e-07f
CMODEL16165 a_0_n11917.t3 vdd.t37 1.42397861076037e-05f
CMODEL16166 a_0_n11917.t3 vdd.t39 1.42397861076037e-05f
CMODEL16167 a_0_n11917.t3 vdd.n31 4.61192912052051e-06f
CMODEL16168 a_0_n11917.t3 vdd.n32 5.56563309683823e-05f
CMODEL16169 a_0_n11917.t3 vdd.n33 2.82011120286754e-05f
CMODEL16170 a_0_n11917.t3 vdd.t17 2.68839175311869e-06f
CMODEL16171 a_0_n11917.t3 vdd.t16 2.1250343891844e-05f
CMODEL16172 a_0_n11917.t3 vdd.n34 4.79760207828951e-06f
CMODEL16173 a_0_n11917.t3 vdd.n35 1.53054109848578e-06f
CMODEL16174 a_0_n11917.t3 vdd.t1 7.04695362397272e-07f
CMODEL16175 a_0_n11917.t3 vdd.t31 7.04695362397272e-07f
CMODEL16176 a_0_n11917.t3 vdd.t0 1.42397861076037e-05f
CMODEL16177 a_0_n11917.t3 vdd.t30 1.42397861076037e-05f
CMODEL16178 a_0_n11917.t3 vdd.n36 4.61192912052051e-06f
CMODEL16179 a_0_n11917.t3 vdd.n37 5.39756705747836e-05f
CMODEL16180 a_0_n11917.t3 vdd.n38 3.11356805137327e-05f
CMODEL16181 a_0_n11917.t3 vdd.t19 2.68839175311869e-06f
CMODEL16182 a_0_n11917.t3 vdd.t18 2.1250343891844e-05f
CMODEL16183 a_0_n11917.t3 vdd.n39 2.6274201027956e-05f
CMODEL16184 a_0_n11917.t3 vdd.t21 2.6884163781794e-06f
CMODEL16185 a_0_n11917.t3 vdd.t20 2.1250343891844e-05f
CMODEL16186 a_0_n11917.t3 vdd.n40 2.6274201027956e-05f
CMODEL16187 a_0_n11917.t3 vdd.t11 2.68839175311869e-06f
CMODEL16188 a_0_n11917.t3 vdd.t10 2.1250343891844e-05f
CMODEL16189 a_0_n11917.t3 vdd.n41 0.000113036416186609f
CMODEL16190 a_0_n11917.t3 vdd.n42 0.000216521017573614f
CMODEL16191 a_0_n11917.t3 vdd.n43 2.6274201027956e-05f
CMODEL16192 a_0_n11917.t3 vdd.t13 2.68839175311869e-06f
CMODEL16193 a_0_n11917.t3 vdd.t12 2.1250343891844e-05f
CMODEL16194 a_0_n11917.t3 vdd.n44 2.6274201027956e-05f
CMODEL16195 a_0_n11917.t3 vdd.t23 2.68839175311869e-06f
CMODEL16196 a_0_n11917.t3 vdd.t22 2.1250343891844e-05f
CMODEL16197 a_0_n11917.t3 vdd.n45 3.24344062156872e-05f
CMODEL16198 a_0_n11917.t3 vdd.n46 0.000535363594916803f
CMODEL16199 a_0_n11917.n3 vdd 0.000162587581575592f
CMODEL16200 a_0_n11917.n3 vdd.n0 0.0545613668700012f
CMODEL16201 a_0_n11917.n3 vdd.n1 0.00505624322020256f
CMODEL16202 a_0_n11917.n3 vdd.t7 0.000416818497715202f
CMODEL16203 a_0_n11917.n3 vdd.t6 0.0032947342613496f
CMODEL16204 a_0_n11917.n3 vdd.n2 0.00453413675099722f
CMODEL16205 a_0_n11917.n3 vdd.t27 0.000416818497715202f
CMODEL16206 a_0_n11917.n3 vdd.t26 0.0032947342613496f
CMODEL16207 a_0_n11917.n3 vdd.n3 0.00850436033562057f
CMODEL16208 a_0_n11917.n3 vdd.n4 0.00453413675099722f
CMODEL16209 a_0_n11917.n3 vdd.t36 0.000416818497715202f
CMODEL16210 a_0_n11917.n3 vdd.t35 0.0032947342613496f
CMODEL16211 a_0_n11917.n3 vdd.n5 0.00646950048265994f
CMODEL16212 a_0_n11917.n3 vdd.t3 0.000663966710300715f
CMODEL16213 a_0_n11917.n3 vdd.n6 0.00635251808985225f
CMODEL16214 a_0_n11917.n3 vdd.t2 0.00832541239988635f
CMODEL16215 a_0_n11917.n3 vdd.n7 0.00851581422525579f
CMODEL16216 a_0_n11917.n3 vdd.t25 0.000663966710300715f
CMODEL16217 a_0_n11917.n3 vdd.n8 0.00383697666853365f
CMODEL16218 a_0_n11917.n3 vdd.t24 0.00832541239988635f
CMODEL16219 a_0_n11917.n3 vdd.n9 0.00851581422525579f
CMODEL16220 a_0_n11917.n3 vdd.t5 0.000663966710300715f
CMODEL16221 a_0_n11917.n3 vdd.n10 0.0113616476440219f
CMODEL16222 a_0_n11917.n3 vdd.t4 0.00832999395574044f
CMODEL16223 a_0_n11917.n3 vdd.n11 0.0274705507455204f
CMODEL16224 a_0_n11917.n3 vdd.n12 0.0677321945615379f
CMODEL16225 a_0_n11917.n3 vdd.n13 0.00513401513082568f
CMODEL16226 a_0_n11917.n3 vdd.t42 0.000416818497715202f
CMODEL16227 a_0_n11917.n3 vdd.t41 0.0032947342613496f
CMODEL16228 a_0_n11917.n3 vdd.n14 0.00461587934336056f
CMODEL16229 a_0_n11917.n3 vdd.t9 0.000416818497715202f
CMODEL16230 a_0_n11917.n3 vdd.t8 0.0032947342613496f
CMODEL16231 a_0_n11917.n3 vdd.n15 0.00886187441076783f
CMODEL16232 a_0_n11917.n3 vdd.t15 0.000701963080183943f
CMODEL16233 a_0_n11917.n3 vdd.n16 0.00552150021718509f
CMODEL16234 a_0_n11917.n3 vdd.t14 0.00946904510033071f
CMODEL16235 a_0_n11917.n3 vdd.n17 0.00773442987434124f
CMODEL16236 a_0_n11917.n3 vdd.t32 0.00946904510033071f
CMODEL16237 a_0_n11917.n3 vdd.n18 0.00763493375304332f
CMODEL16238 a_0_n11917.n3 vdd.t34 0.000701963080183943f
CMODEL16239 a_0_n11917.n3 vdd.n19 0.00768846159727191f
CMODEL16240 a_0_n11917.n3 vdd.t33 0.00946904510033071f
CMODEL16241 a_0_n11917.n3 vdd.n20 0.0153434396571769f
CMODEL16242 a_0_n11917.n3 vdd.t48 0.00948714224595435f
CMODEL16243 a_0_n11917.n3 vdd.n21 0.0272362805228481f
CMODEL16244 a_0_n11917.n3 vdd.n22 0.119359456703317f
CMODEL16245 a_0_n11917.n3 vdd.t47 0.000134944764329958f
CMODEL16246 a_0_n11917.n3 vdd.t45 0.000133559225480418f
CMODEL16247 a_0_n11917.n3 vdd.n23 0.00152509304085564f
CMODEL16248 a_0_n11917.n3 vdd.t46 0.00363971778123593f
CMODEL16249 a_0_n11917.n3 vdd.n24 0.00391054881962386f
CMODEL16250 a_0_n11917.n3 vdd.t44 0.00363971778123593f
CMODEL16251 a_0_n11917.n3 vdd.n25 0.00616730869445078f
CMODEL16252 a_0_n11917.n3 vdd.t43 0.00364760187526817f
CMODEL16253 a_0_n11917.n3 vdd.n26 0.0329985796797976f
CMODEL16254 a_0_n11917.n3 vdd.n27 0.0220602296170611f
CMODEL16255 a_0_n11917.n3 vdd.n28 0.0049830146858014f
CMODEL16256 a_0_n11917.n3 vdd.t29 0.000416818497715202f
CMODEL16257 a_0_n11917.n3 vdd.t28 0.0032947342613496f
CMODEL16258 a_0_n11917.n3 vdd.n29 0.000743838500690299f
CMODEL16259 a_0_n11917.n3 vdd.n30 0.000237300921869795f
CMODEL16260 a_0_n11917.n3 vdd.t38 0.00010925865323034f
CMODEL16261 a_0_n11917.n3 vdd.t40 0.00010925865323034f
CMODEL16262 a_0_n11917.n3 vdd.t37 0.00220779067867315f
CMODEL16263 a_0_n11917.n3 vdd.t39 0.00220779067867315f
CMODEL16264 a_0_n11917.n3 vdd.n31 0.000715051058073785f
CMODEL16265 a_0_n11917.n3 vdd.n32 0.00862916955301232f
CMODEL16266 a_0_n11917.n3 vdd.n33 0.00437240782934795f
CMODEL16267 a_0_n11917.n3 vdd.t17 0.000416818497715202f
CMODEL16268 a_0_n11917.n3 vdd.t16 0.0032947342613496f
CMODEL16269 a_0_n11917.n3 vdd.n34 0.000743838500690299f
CMODEL16270 a_0_n11917.n3 vdd.n35 0.000237300921869795f
CMODEL16271 a_0_n11917.n3 vdd.t1 0.00010925865323034f
CMODEL16272 a_0_n11917.n3 vdd.t31 0.00010925865323034f
CMODEL16273 a_0_n11917.n3 vdd.t0 0.00220779067867315f
CMODEL16274 a_0_n11917.n3 vdd.t30 0.00220779067867315f
CMODEL16275 a_0_n11917.n3 vdd.n36 0.000715051058073785f
CMODEL16276 a_0_n11917.n3 vdd.n37 0.00836859356381112f
CMODEL16277 a_0_n11917.n3 vdd.n38 0.00482739450529091f
CMODEL16278 a_0_n11917.n3 vdd.t19 0.000416818497715202f
CMODEL16279 a_0_n11917.n3 vdd.t18 0.0032947342613496f
CMODEL16280 a_0_n11917.n3 vdd.n39 0.00407365220802936f
CMODEL16281 a_0_n11917.n3 vdd.t21 0.000416822315678414f
CMODEL16282 a_0_n11917.n3 vdd.t20 0.0032947342613496f
CMODEL16283 a_0_n11917.n3 vdd.n40 0.00407365220802936f
CMODEL16284 a_0_n11917.n3 vdd.t11 0.000416818497715202f
CMODEL16285 a_0_n11917.n3 vdd.t10 0.0032947342613496f
CMODEL16286 a_0_n11917.n3 vdd.n41 0.0175255965308464f
CMODEL16287 a_0_n11917.n3 vdd.n42 0.0335702433114913f
CMODEL16288 a_0_n11917.n3 vdd.n43 0.00407365220802936f
CMODEL16289 a_0_n11917.n3 vdd.t13 0.000416818497715202f
CMODEL16290 a_0_n11917.n3 vdd.t12 0.0032947342613496f
CMODEL16291 a_0_n11917.n3 vdd.n44 0.00407365220802936f
CMODEL16292 a_0_n11917.n3 vdd.t23 0.000416818497715202f
CMODEL16293 a_0_n11917.n3 vdd.t22 0.0032947342613496f
CMODEL16294 a_0_n11917.n3 vdd.n45 0.00502875388507804f
CMODEL16295 a_0_n11917.n3 vdd.n46 0.083004811001137f
CMODEL16296 a_0_n11917.n4 vdd 0.000296158289702191f
CMODEL16297 a_0_n11917.n4 vdd.n0 0.0993852109702523f
CMODEL16298 a_0_n11917.n4 vdd.n1 0.00921010282521039f
CMODEL16299 a_0_n11917.n4 vdd.t7 0.00075924773714761f
CMODEL16300 a_0_n11917.n4 vdd.t6 0.00600145997873058f
CMODEL16301 a_0_n11917.n4 vdd.n2 0.00825906980372215f
CMODEL16302 a_0_n11917.n4 vdd.t27 0.00075924773714761f
CMODEL16303 a_0_n11917.n4 vdd.t26 0.00600145997873058f
CMODEL16304 a_0_n11917.n4 vdd.n3 0.0154909543988607f
CMODEL16305 a_0_n11917.n4 vdd.n4 0.00825906980372215f
CMODEL16306 a_0_n11917.n4 vdd.t36 0.00075924773714761f
CMODEL16307 a_0_n11917.n4 vdd.t35 0.00600145997873058f
CMODEL16308 a_0_n11917.n4 vdd.n5 0.0117843944759167f
CMODEL16309 a_0_n11917.n4 vdd.t3 0.00120943582182767f
CMODEL16310 a_0_n11917.n4 vdd.n6 0.0115713074428023f
CMODEL16311 a_0_n11917.n4 vdd.t2 0.0151649952199418f
CMODEL16312 a_0_n11917.n4 vdd.n7 0.0155118180117635f
CMODEL16313 a_0_n11917.n4 vdd.t25 0.00120943582182767f
CMODEL16314 a_0_n11917.n4 vdd.n8 0.00698917123170203f
CMODEL16315 a_0_n11917.n4 vdd.t24 0.0151649952199418f
CMODEL16316 a_0_n11917.n4 vdd.n9 0.0155118180117635f
CMODEL16317 a_0_n11917.n4 vdd.t5 0.00120943582182767f
CMODEL16318 a_0_n11917.n4 vdd.n10 0.0206955912736056f
CMODEL16319 a_0_n11917.n4 vdd.t4 0.015173340665103f
CMODEL16320 a_0_n11917.n4 vdd.n11 0.0500384546416791f
CMODEL16321 a_0_n11917.n4 vdd.n12 0.123376279447239f
CMODEL16322 a_0_n11917.n4 vdd.n13 0.00935176675682075f
CMODEL16323 a_0_n11917.n4 vdd.t42 0.00075924773714761f
CMODEL16324 a_0_n11917.n4 vdd.t41 0.00600145997873058f
CMODEL16325 a_0_n11917.n4 vdd.n14 0.00840796645447216f
CMODEL16326 a_0_n11917.n4 vdd.t9 0.00075924773714761f
CMODEL16327 a_0_n11917.n4 vdd.t8 0.00600145997873058f
CMODEL16328 a_0_n11917.n4 vdd.n15 0.016142177302935f
CMODEL16329 a_0_n11917.n4 vdd.t15 0.00127864738036406f
CMODEL16330 a_0_n11917.n4 vdd.n16 0.0100575827813242f
CMODEL16331 a_0_n11917.n4 vdd.t14 0.017248157422915f
CMODEL16332 a_0_n11917.n4 vdd.n17 0.0140885023395311f
CMODEL16333 a_0_n11917.n4 vdd.t32 0.017248157422915f
CMODEL16334 a_0_n11917.n4 vdd.n18 0.0139072670887817f
CMODEL16335 a_0_n11917.n4 vdd.t34 0.00127864738036406f
CMODEL16336 a_0_n11917.n4 vdd.n19 0.0140047697064143f
CMODEL16337 a_0_n11917.n4 vdd.t33 0.017248157422915f
CMODEL16338 a_0_n11917.n4 vdd.n20 0.027948548117776f
CMODEL16339 a_0_n11917.n4 vdd.t48 0.0172811219313015f
CMODEL16340 a_0_n11917.n4 vdd.n21 0.0496117242124394f
CMODEL16341 a_0_n11917.n4 vdd.n22 0.217416928245545f
CMODEL16342 a_0_n11917.n4 vdd.t47 0.000245806046322453f
CMODEL16343 a_0_n11917.n4 vdd.t45 0.000243282244614971f
CMODEL16344 a_0_n11917.n4 vdd.n23 0.00277800396708973f
CMODEL16345 a_0_n11917.n4 vdd.t46 0.00662985809028914f
CMODEL16346 a_0_n11917.n4 vdd.n24 0.00712318517191466f
CMODEL16347 a_0_n11917.n4 vdd.t44 0.00662985809028914f
CMODEL16348 a_0_n11917.n4 vdd.n25 0.0112339428221632f
CMODEL16349 a_0_n11917.n4 vdd.t43 0.00664421921050394f
CMODEL16350 a_0_n11917.n4 vdd.n26 0.0601079296823578f
CMODEL16351 a_0_n11917.n4 vdd.n27 0.0401833879962652f
CMODEL16352 a_0_n11917.n4 vdd.n28 0.00907671479338484f
CMODEL16353 a_0_n11917.n4 vdd.t29 0.00075924773714761f
CMODEL16354 a_0_n11917.n4 vdd.t28 0.00600145997873058f
CMODEL16355 a_0_n11917.n4 vdd.n29 0.00135492474913688f
CMODEL16356 a_0_n11917.n4 vdd.n30 0.000432250941213717f
CMODEL16357 a_0_n11917.n4 vdd.t38 0.000199018003480285f
CMODEL16358 a_0_n11917.n4 vdd.t40 0.000199018003480285f
CMODEL16359 a_0_n11917.n4 vdd.t37 0.0040215587505512f
CMODEL16360 a_0_n11917.n4 vdd.t39 0.0040215587505512f
CMODEL16361 a_0_n11917.n4 vdd.n31 0.00130248753537438f
CMODEL16362 a_0_n11917.n4 vdd.n32 0.0157182982341254f
CMODEL16363 a_0_n11917.n4 vdd.n33 0.00796447558953392f
CMODEL16364 a_0_n11917.n4 vdd.t17 0.00075924773714761f
CMODEL16365 a_0_n11917.n4 vdd.t16 0.00600145997873058f
CMODEL16366 a_0_n11917.n4 vdd.n34 0.00135492474913688f
CMODEL16367 a_0_n11917.n4 vdd.n35 0.000432250941213717f
CMODEL16368 a_0_n11917.n4 vdd.t1 0.000199018003480285f
CMODEL16369 a_0_n11917.n4 vdd.t31 0.000199018003480285f
CMODEL16370 a_0_n11917.n4 vdd.t0 0.0040215587505512f
CMODEL16371 a_0_n11917.n4 vdd.t30 0.0040215587505512f
CMODEL16372 a_0_n11917.n4 vdd.n36 0.00130248753537438f
CMODEL16373 a_0_n11917.n4 vdd.n37 0.0152436510405856f
CMODEL16374 a_0_n11917.n4 vdd.n38 0.00879324783941146f
CMODEL16375 a_0_n11917.n4 vdd.t19 0.00075924773714761f
CMODEL16376 a_0_n11917.n4 vdd.t18 0.00600145997873058f
CMODEL16377 a_0_n11917.n4 vdd.n39 0.00742028301965125f
CMODEL16378 a_0_n11917.n4 vdd.t21 0.000759254691685245f
CMODEL16379 a_0_n11917.n4 vdd.t20 0.00600145997873058f
CMODEL16380 a_0_n11917.n4 vdd.n40 0.00742028301965125f
CMODEL16381 a_0_n11917.n4 vdd.t11 0.00075924773714761f
CMODEL16382 a_0_n11917.n4 vdd.t10 0.00600145997873058f
CMODEL16383 a_0_n11917.n4 vdd.n41 0.0319234141026506f
CMODEL16384 a_0_n11917.n4 vdd.n42 0.0611492326023391f
CMODEL16385 a_0_n11917.n4 vdd.n43 0.00742028301965125f
CMODEL16386 a_0_n11917.n4 vdd.t13 0.00075924773714761f
CMODEL16387 a_0_n11917.n4 vdd.t12 0.00600145997873058f
CMODEL16388 a_0_n11917.n4 vdd.n44 0.00742028301965125f
CMODEL16389 a_0_n11917.n4 vdd.t23 0.00075924773714761f
CMODEL16390 a_0_n11917.n4 vdd.t22 0.00600145997873058f
CMODEL16391 a_0_n11917.n4 vdd.n45 0.00916003015424356f
CMODEL16392 a_0_n11917.n4 vdd.n46 0.151195820891899f
CMODEL16393 a_16000_n24000.t0 we 0.000147867994352259f
CMODEL16394 a_16000_n24000.t0 we.t1 0.000845413399127365f
CMODEL16395 a_16000_n24000.t0 we.t3 0.000861333092192669f
CMODEL16396 a_16000_n24000.t0 we.n0 0.02943093329293f
CMODEL16397 a_16000_n24000.t0 we.t0 0.00104397148158569f
CMODEL16398 a_16000_n24000.t0 we.n1 0.0803717193692304f
CMODEL16399 a_16000_n24000.t0 we.t2 0.0015710075507601f
CMODEL16400 a_16000_n24000.t1 we 0.000147838889295472f
CMODEL16401 a_16000_n24000.t1 we.t1 0.00084524699526764f
CMODEL16402 a_16000_n24000.t1 we.t3 0.000861163554838285f
CMODEL16403 a_16000_n24000.t1 we.n0 0.0294251403626307f
CMODEL16404 a_16000_n24000.t1 we.t0 0.00104376599527076f
CMODEL16405 a_16000_n24000.t1 we.n1 0.080355899695294f
CMODEL16406 a_16000_n24000.t1 we.t2 0.00157069832722476f
CMODEL16407 a_n104_n35959.t0 sa_en 5.139297130828e-05f
CMODEL16408 a_n104_n35959.t0 sa_en.t1 0.000348229884592575f
CMODEL16409 a_n104_n35959.t0 sa_en.n0 0.0152580659212013f
CMODEL16410 a_n104_n35959.t0 sa_en.t0 0.000426614053539303f
CMODEL16411 a_n104_n35959.t3 sa_en 4.48494175832601e-05f
CMODEL16412 a_n104_n35959.t3 sa_en.t1 0.000303891896333043f
CMODEL16413 a_n104_n35959.t3 sa_en.n0 0.0133153494065952f
CMODEL16414 a_n104_n35959.t3 sa_en.t0 0.00037229588690835f
CMODEL16415 a_n104_n35959.t4 sa_en 1.79818185003897e-05f
CMODEL16416 a_n104_n35959.t4 sa_en.t1 0.000121841692000916f
CMODEL16417 a_n104_n35959.t4 sa_en.n0 0.00533862442815833f
CMODEL16418 a_n104_n35959.t4 sa_en.t0 0.000149267424808796f
CMODEL16419 a_n104_n35959.t2 sa_en 2.46118999282201e-05f
CMODEL16420 a_n104_n35959.t2 sa_en.t1 0.000166765977008753f
CMODEL16421 a_n104_n35959.t2 sa_en.n0 0.00730703016368098f
CMODEL16422 a_n104_n35959.t2 sa_en.t0 0.000204303859582255f
CMODEL16423 a_n104_n35959.n0 sa_en 0.00183726048434093f
CMODEL16424 a_n104_n35959.n0 sa_en.t1 0.0124489592670324f
CMODEL16425 a_n104_n35959.n0 sa_en.n0 0.545464503625143f
CMODEL16426 a_n104_n35959.n0 sa_en.t0 0.0152511349836274f
CMODEL16427 a_n104_n35959.t1 sa_en 4.55471198471893e-05f
CMODEL16428 a_n104_n35959.t1 sa_en.t1 0.000308619406197975f
CMODEL16429 a_n104_n35959.t1 sa_en.n0 0.0135224903222769f
CMODEL16430 a_n104_n35959.t1 sa_en.t0 0.000378087526959534f
CMODEL16431 a_n104_n35959.n1 sa_en 0.000858276754260002f
CMODEL16432 a_n104_n35959.n1 sa_en.t1 0.00581553483824933f
CMODEL16433 a_n104_n35959.n1 sa_en.n0 0.254813896954504f
CMODEL16434 a_n104_n35959.n1 sa_en.t0 0.00712457201583175f
CMODEL16435 a_20800_n23917.t0 we 0.00036741917237621f
CMODEL16436 a_20800_n23917.t0 we.t1 0.00210066480433322f
CMODEL16437 a_20800_n23917.t0 we.t3 0.00214022171099284f
CMODEL16438 a_20800_n23917.t0 we.n0 0.0731293421549175f
CMODEL16439 a_20800_n23917.t0 we.t0 0.00259403760380226f
CMODEL16440 a_20800_n23917.t0 we.n1 0.19970589810495f
CMODEL16441 a_20800_n23917.t0 we.t2 0.00390360535168938f
CMODEL16442 a_20800_n23917.t1 we 0.000367280225769662f
CMODEL16443 a_20800_n23917.t1 we.t1 0.00209987039765006f
CMODEL16444 a_20800_n23917.t1 we.t3 0.00213941234510679f
CMODEL16445 a_20800_n23917.t1 we.n0 0.0731016868916773f
CMODEL16446 a_20800_n23917.t1 we.t0 0.00259305661873287f
CMODEL16447 a_20800_n23917.t1 we.n1 0.199630375489541f
CMODEL16448 a_20800_n23917.t1 we.t2 0.00390212912846071f
CMODEL16449 a_0_n35917.t1 vdd 5.66742077336585e-06f
CMODEL16450 a_0_n35917.t1 vdd.n0 0.00190188094949006f
CMODEL16451 a_0_n35917.t1 vdd.n1 0.000176248749035259f
CMODEL16452 a_0_n35917.t1 vdd.t7 1.45293126927777e-05f
CMODEL16453 a_0_n35917.t1 vdd.t6 0.000114846688870954f
CMODEL16454 a_0_n35917.t1 vdd.n2 0.00015804934523819f
CMODEL16455 a_0_n35917.t1 vdd.t27 1.45293126927777e-05f
CMODEL16456 a_0_n35917.t1 vdd.t26 0.000114846688870954f
CMODEL16457 a_0_n35917.t1 vdd.n3 0.00029644200352335f
CMODEL16458 a_0_n35917.t1 vdd.n4 0.00015804934523819f
CMODEL16459 a_0_n35917.t1 vdd.t36 1.45293126927777e-05f
CMODEL16460 a_0_n35917.t1 vdd.t35 0.000114846688870954f
CMODEL16461 a_0_n35917.t1 vdd.n5 0.000225511573967784f
CMODEL16462 a_0_n35917.t1 vdd.t3 2.31443182210822e-05f
CMODEL16463 a_0_n35917.t1 vdd.n6 0.000221433842835483f
CMODEL16464 a_0_n35917.t1 vdd.t2 0.000290204299274951f
CMODEL16465 a_0_n35917.t1 vdd.n7 0.000296841259182518f
CMODEL16466 a_0_n35917.t1 vdd.t25 2.31443182210822e-05f
CMODEL16467 a_0_n35917.t1 vdd.n8 0.00013374798411684f
CMODEL16468 a_0_n35917.t1 vdd.t24 0.000290204299274951f
CMODEL16469 a_0_n35917.t1 vdd.n9 0.000296841259182518f
CMODEL16470 a_0_n35917.t1 vdd.t5 2.31443182210822e-05f
CMODEL16471 a_0_n35917.t1 vdd.n10 0.000396040320259365f
CMODEL16472 a_0_n35917.t1 vdd.t4 0.000290364001538618f
CMODEL16473 a_0_n35917.t1 vdd.n11 0.000957558802721837f
CMODEL16474 a_0_n35917.t1 vdd.n12 0.00236098503196719f
CMODEL16475 a_0_n35917.t1 vdd.n13 0.000178959694961009f
CMODEL16476 a_0_n35917.t1 vdd.t42 1.45293126927777e-05f
CMODEL16477 a_0_n35917.t1 vdd.t41 0.000114846688870954f
CMODEL16478 a_0_n35917.t1 vdd.n14 0.000160898699792452f
CMODEL16479 a_0_n35917.t1 vdd.t9 1.45293126927777e-05f
CMODEL16480 a_0_n35917.t1 vdd.t8 0.000114846688870954f
CMODEL16481 a_0_n35917.t1 vdd.n15 0.000308904103498176f
CMODEL16482 a_0_n35917.t1 vdd.t15 2.44687823277617e-05f
CMODEL16483 a_0_n35917.t1 vdd.n16 0.000192466513910658f
CMODEL16484 a_0_n35917.t1 vdd.t14 0.000330068645990664f
CMODEL16485 a_0_n35917.t1 vdd.n17 0.000269604038114086f
CMODEL16486 a_0_n35917.t1 vdd.t32 0.000330068645990664f
CMODEL16487 a_0_n35917.t1 vdd.n18 0.000266135837288114f
CMODEL16488 a_0_n35917.t1 vdd.t34 2.44687823277617e-05f
CMODEL16489 a_0_n35917.t1 vdd.n19 0.000268001692068626f
CMODEL16490 a_0_n35917.t1 vdd.t33 0.000330068645990664f
CMODEL16491 a_0_n35917.t1 vdd.n20 0.000534836226760284f
CMODEL16492 a_0_n35917.t1 vdd.t48 0.00033069946993215f
CMODEL16493 a_0_n35917.t1 vdd.n21 0.000949392693639657f
CMODEL16494 a_0_n35917.t1 vdd.n22 0.00416058999010042f
CMODEL16495 a_0_n35917.t1 vdd.t47 4.70385716553013e-06f
CMODEL16496 a_0_n35917.t1 vdd.t45 4.65556053929279e-06f
CMODEL16497 a_0_n35917.t1 vdd.n23 5.31611571886405e-05f
CMODEL16498 a_0_n35917.t1 vdd.t46 0.000126872003154651f
CMODEL16499 a_0_n35917.t1 vdd.n24 0.000136312536300895f
CMODEL16500 a_0_n35917.t1 vdd.t44 0.000126872003154651f
CMODEL16501 a_0_n35917.t1 vdd.n25 0.000214977878826739f
CMODEL16502 a_0_n35917.t1 vdd.t43 0.000127146824133378f
CMODEL16503 a_0_n35917.t1 vdd.n26 0.00115025289235822f
CMODEL16504 a_0_n35917.t1 vdd.n27 0.000768967730409502f
CMODEL16505 a_0_n35917.t1 vdd.n28 0.000173696174520979f
CMODEL16506 a_0_n35917.t1 vdd.t29 1.45293126927777e-05f
CMODEL16507 a_0_n35917.t1 vdd.t28 0.000114846688870954f
CMODEL16508 a_0_n35917.t1 vdd.n29 2.59284610176794e-05f
CMODEL16509 a_0_n35917.t1 vdd.n30 8.27175212959585e-06f
CMODEL16510 a_0_n35917.t1 vdd.t38 3.80849973280225e-06f
CMODEL16511 a_0_n35917.t1 vdd.t40 3.80849973280225e-06f
CMODEL16512 a_0_n35917.t1 vdd.t37 7.69583914976818e-05f
CMODEL16513 a_0_n35917.t1 vdd.t39 7.69583914976818e-05f
CMODEL16514 a_0_n35917.t1 vdd.n31 2.49249984609708e-05f
CMODEL16515 a_0_n35917.t1 vdd.n32 0.000300792559356082f
CMODEL16516 a_0_n35917.t1 vdd.n33 0.00015241185533074f
CMODEL16517 a_0_n35917.t1 vdd.t17 1.45293126927777e-05f
CMODEL16518 a_0_n35917.t1 vdd.t16 0.000114846688870954f
CMODEL16519 a_0_n35917.t1 vdd.n34 2.59284610176794e-05f
CMODEL16520 a_0_n35917.t1 vdd.n35 8.27175212959585e-06f
CMODEL16521 a_0_n35917.t1 vdd.t1 3.80849973280225e-06f
CMODEL16522 a_0_n35917.t1 vdd.t31 3.80849973280225e-06f
CMODEL16523 a_0_n35917.t1 vdd.t0 7.69583914976818e-05f
CMODEL16524 a_0_n35917.t1 vdd.t30 7.69583914976818e-05f
CMODEL16525 a_0_n35917.t1 vdd.n36 2.49249984609708e-05f
CMODEL16526 a_0_n35917.t1 vdd.n37 0.000291709493110013f
CMODEL16527 a_0_n35917.t1 vdd.n38 0.000168271620965085f
CMODEL16528 a_0_n35917.t1 vdd.t19 1.45293126927777e-05f
CMODEL16529 a_0_n35917.t1 vdd.t18 0.000114846688870954f
CMODEL16530 a_0_n35917.t1 vdd.n39 0.000141997936887445f
CMODEL16531 a_0_n35917.t1 vdd.t21 1.45294457779974e-05f
CMODEL16532 a_0_n35917.t1 vdd.t20 0.000114846688870954f
CMODEL16533 a_0_n35917.t1 vdd.n40 0.000141997936887445f
CMODEL16534 a_0_n35917.t1 vdd.t11 1.45293126927777e-05f
CMODEL16535 a_0_n35917.t1 vdd.t10 0.000114846688870954f
CMODEL16536 a_0_n35917.t1 vdd.n41 0.000610901084092748f
CMODEL16537 a_0_n35917.t1 vdd.n42 0.00117017974230729f
CMODEL16538 a_0_n35917.t1 vdd.n43 0.000141997936887445f
CMODEL16539 a_0_n35917.t1 vdd.t13 1.45293126927777e-05f
CMODEL16540 a_0_n35917.t1 vdd.t12 0.000114846688870954f
CMODEL16541 a_0_n35917.t1 vdd.n44 0.000141997936887445f
CMODEL16542 a_0_n35917.t1 vdd.t23 1.45293126927777e-05f
CMODEL16543 a_0_n35917.t1 vdd.t22 0.000114846688870954f
CMODEL16544 a_0_n35917.t1 vdd.n45 0.000175290535453256f
CMODEL16545 a_0_n35917.t1 vdd.n46 0.00289335252790162f
CMODEL16546 a_0_n35917.n0 vdd 7.0591744404671e-05f
CMODEL16547 a_0_n35917.n0 vdd.n0 0.0236892758175746f
CMODEL16548 a_0_n35917.n0 vdd.n1 0.00219530314424685f
CMODEL16549 a_0_n35917.n0 vdd.t7 0.000180972892078909f
CMODEL16550 a_0_n35917.n0 vdd.t6 0.0014304969457361f
CMODEL16551 a_0_n35917.n0 vdd.n2 0.00196861666506436f
CMODEL16552 a_0_n35917.n0 vdd.t27 0.000180972892078909f
CMODEL16553 a_0_n35917.n0 vdd.t26 0.0014304969457361f
CMODEL16554 a_0_n35917.n0 vdd.n3 0.00369239535590381f
CMODEL16555 a_0_n35917.n0 vdd.n4 0.00196861666506436f
CMODEL16556 a_0_n35917.n0 vdd.t36 0.000180972892078909f
CMODEL16557 a_0_n35917.n0 vdd.t35 0.0014304969457361f
CMODEL16558 a_0_n35917.n0 vdd.n5 0.00280890656021902f
CMODEL16559 a_0_n35917.n0 vdd.t3 0.000288278894688932f
CMODEL16560 a_0_n35917.n0 vdd.n6 0.0027581155275159f
CMODEL16561 a_0_n35917.n0 vdd.t2 0.00361470032643922f
CMODEL16562 a_0_n35917.n0 vdd.n7 0.0036973683682442f
CMODEL16563 a_0_n35917.n0 vdd.t25 0.000288278894688932f
CMODEL16564 a_0_n35917.n0 vdd.n8 0.00166592598061299f
CMODEL16565 a_0_n35917.n0 vdd.t24 0.00361470032643922f
CMODEL16566 a_0_n35917.n0 vdd.n9 0.0036973683682442f
CMODEL16567 a_0_n35917.n0 vdd.t5 0.000288278894688932f
CMODEL16568 a_0_n35917.n0 vdd.n10 0.00493296301433597f
CMODEL16569 a_0_n35917.n0 vdd.t4 0.00361668953137537f
CMODEL16570 a_0_n35917.n0 vdd.n11 0.011927073876683f
CMODEL16571 a_0_n35917.n0 vdd.n12 0.029407742707782f
CMODEL16572 a_0_n35917.n0 vdd.n13 0.00222906989803806f
CMODEL16573 a_0_n35917.n0 vdd.t42 0.000180972892078909f
CMODEL16574 a_0_n35917.n0 vdd.t41 0.0014304969457361f
CMODEL16575 a_0_n35917.n0 vdd.n14 0.0020041073964669f
CMODEL16576 a_0_n35917.n0 vdd.t9 0.000180972892078909f
CMODEL16577 a_0_n35917.n0 vdd.t8 0.0014304969457361f
CMODEL16578 a_0_n35917.n0 vdd.n15 0.003847619647755f
CMODEL16579 a_0_n35917.n0 vdd.t15 0.000304776034292766f
CMODEL16580 a_0_n35917.n0 vdd.n16 0.00239730690551325f
CMODEL16581 a_0_n35917.n0 vdd.t14 0.00411123903191875f
CMODEL16582 a_0_n35917.n0 vdd.n17 0.00335810946638321f
CMODEL16583 a_0_n35917.n0 vdd.t32 0.00411123903191875f
CMODEL16584 a_0_n35917.n0 vdd.n18 0.00331491056585308f
CMODEL16585 a_0_n35917.n0 vdd.t34 0.000304776034292766f
CMODEL16586 a_0_n35917.n0 vdd.n19 0.00333815111019047f
CMODEL16587 a_0_n35917.n0 vdd.t33 0.00411123903191875f
CMODEL16588 a_0_n35917.n0 vdd.n20 0.00666176444763922f
CMODEL16589 a_0_n35917.n0 vdd.t48 0.00411909639141655f
CMODEL16590 a_0_n35917.n0 vdd.n21 0.0118253591976144f
CMODEL16591 a_0_n35917.n0 vdd.n22 0.0518230985308282f
CMODEL16592 a_0_n35917.n0 vdd.t47 5.85898764223885e-05f
CMODEL16593 a_0_n35917.n0 vdd.t45 5.79883076962801e-05f
CMODEL16594 a_0_n35917.n0 vdd.n23 0.000662159908463672f
CMODEL16595 a_0_n35917.n0 vdd.t46 0.0015802807620869f
CMODEL16596 a_0_n35917.n0 vdd.n24 0.00169786929654606f
CMODEL16597 a_0_n35917.n0 vdd.t44 0.0015802807620869f
CMODEL16598 a_0_n35917.n0 vdd.n25 0.00267770191797189f
CMODEL16599 a_0_n35917.n0 vdd.t43 0.00158370385224787f
CMODEL16600 a_0_n35917.n0 vdd.n26 0.0143272153992303f
CMODEL16601 a_0_n35917.n0 vdd.n27 0.00957803834428713f
CMODEL16602 a_0_n35917.n0 vdd.n28 0.002163509018684f
CMODEL16603 a_0_n35917.n0 vdd.t29 0.000180972892078909f
CMODEL16604 a_0_n35917.n0 vdd.t28 0.0014304969457361f
CMODEL16605 a_0_n35917.n0 vdd.n29 0.000322957367409209f
CMODEL16606 a_0_n35917.n0 vdd.n30 0.000103030538133917f
CMODEL16607 a_0_n35917.n0 vdd.t38 4.74375647149217e-05f
CMODEL16608 a_0_n35917.n0 vdd.t40 4.74375647149217e-05f
CMODEL16609 a_0_n35917.n0 vdd.t37 0.000958571335999912f
CMODEL16610 a_0_n35917.n0 vdd.t39 0.000958571335999912f
CMODEL16611 a_0_n35917.n0 vdd.n31 0.000310458529727044f
CMODEL16612 a_0_n35917.n0 vdd.n32 0.0037465846137062f
CMODEL16613 a_0_n35917.n0 vdd.n33 0.00189839773081814f
CMODEL16614 a_0_n35917.n0 vdd.t17 0.000180972892078909f
CMODEL16615 a_0_n35917.n0 vdd.t16 0.0014304969457361f
CMODEL16616 a_0_n35917.n0 vdd.n34 0.000322957367409209f
CMODEL16617 a_0_n35917.n0 vdd.n35 0.000103030538133917f
CMODEL16618 a_0_n35917.n0 vdd.t1 4.74375647149217e-05f
CMODEL16619 a_0_n35917.n0 vdd.t31 4.74375647149217e-05f
CMODEL16620 a_0_n35917.n0 vdd.t0 0.000958571335999912f
CMODEL16621 a_0_n35917.n0 vdd.t30 0.000958571335999912f
CMODEL16622 a_0_n35917.n0 vdd.n36 0.000310458529727044f
CMODEL16623 a_0_n35917.n0 vdd.n37 0.00363344858296246f
CMODEL16624 a_0_n35917.n0 vdd.n38 0.00209594235768598f
CMODEL16625 a_0_n35917.n0 vdd.t19 0.000180972892078909f
CMODEL16626 a_0_n35917.n0 vdd.t18 0.0014304969457361f
CMODEL16627 a_0_n35917.n0 vdd.n39 0.00176868499227312f
CMODEL16628 a_0_n35917.n0 vdd.t21 0.000180974549749689f
CMODEL16629 a_0_n35917.n0 vdd.t20 0.0014304969457361f
CMODEL16630 a_0_n35917.n0 vdd.n40 0.00176868499227312f
CMODEL16631 a_0_n35917.n0 vdd.t11 0.000180972892078909f
CMODEL16632 a_0_n35917.n0 vdd.t10 0.0014304969457361f
CMODEL16633 a_0_n35917.n0 vdd.n41 0.00760920618202135f
CMODEL16634 a_0_n35917.n0 vdd.n42 0.0145754184451389f
CMODEL16635 a_0_n35917.n0 vdd.n43 0.00176868499227312f
CMODEL16636 a_0_n35917.n0 vdd.t13 0.000180972892078909f
CMODEL16637 a_0_n35917.n0 vdd.t12 0.0014304969457361f
CMODEL16638 a_0_n35917.n0 vdd.n44 0.00176868499227312f
CMODEL16639 a_0_n35917.n0 vdd.t23 0.000180972892078909f
CMODEL16640 a_0_n35917.n0 vdd.t22 0.0014304969457361f
CMODEL16641 a_0_n35917.n0 vdd.n45 0.00218336791462993f
CMODEL16642 a_0_n35917.n0 vdd.n46 0.0360387573624498f
CMODEL16643 a_0_n35917.t0 vdd 1.28664140537671e-06f
CMODEL16644 a_0_n35917.t0 vdd.n0 0.00043177291321142f
CMODEL16645 a_0_n35917.t0 vdd.n1 4.0012723110364e-05f
CMODEL16646 a_0_n35917.t0 vdd.t7 3.29850491956519e-06f
CMODEL16647 a_0_n35917.t0 vdd.t6 2.60729723591758e-05f
CMODEL16648 a_0_n35917.t0 vdd.n2 3.58810188634299e-05f
CMODEL16649 a_0_n35917.t0 vdd.t27 3.29850491956519e-06f
CMODEL16650 a_0_n35917.t0 vdd.t26 2.60729723591758e-05f
CMODEL16651 a_0_n35917.t0 vdd.n3 6.7299495004577e-05f
CMODEL16652 a_0_n35917.t0 vdd.n4 3.58810188634299e-05f
CMODEL16653 a_0_n35917.t0 vdd.t36 3.29850491956519e-06f
CMODEL16654 a_0_n35917.t0 vdd.t35 2.60729723591758e-05f
CMODEL16655 a_0_n35917.t0 vdd.n5 5.11965742551183e-05f
CMODEL16656 a_0_n35917.t0 vdd.t3 5.25431925972452e-06f
CMODEL16657 a_0_n35917.t0 vdd.n6 5.02708307953299e-05f
CMODEL16658 a_0_n35917.t0 vdd.t2 6.58833854758472e-05f
CMODEL16659 a_0_n35917.t0 vdd.n7 6.73901356827547e-05f
CMODEL16660 a_0_n35917.t0 vdd.t25 5.25431925972452e-06f
CMODEL16661 a_0_n35917.t0 vdd.n8 3.03640229183464e-05f
CMODEL16662 a_0_n35917.t0 vdd.t24 6.58833854758472e-05f
CMODEL16663 a_0_n35917.t0 vdd.n9 6.73901356827547e-05f
CMODEL16664 a_0_n35917.t0 vdd.t5 5.25431925972452e-06f
CMODEL16665 a_0_n35917.t0 vdd.n10 8.99107185827896e-05f
CMODEL16666 a_0_n35917.t0 vdd.t4 6.59196417471183e-05f
CMODEL16667 a_0_n35917.t0 vdd.n11 0.000217388976914302f
CMODEL16668 a_0_n35917.t0 vdd.n12 0.000536000629047973f
CMODEL16669 a_0_n35917.t0 vdd.n13 4.06281733151907e-05f
CMODEL16670 a_0_n35917.t0 vdd.t42 3.29850491956519e-06f
CMODEL16671 a_0_n35917.t0 vdd.t41 2.60729723591758e-05f
CMODEL16672 a_0_n35917.t0 vdd.n14 3.65278911700249e-05f
CMODEL16673 a_0_n35917.t0 vdd.t9 3.29850491956519e-06f
CMODEL16674 a_0_n35917.t0 vdd.t8 2.60729723591758e-05f
CMODEL16675 a_0_n35917.t0 vdd.n15 7.01286927060974e-05f
CMODEL16676 a_0_n35917.t0 vdd.t15 5.55500460279939e-06f
CMODEL16677 a_0_n35917.t0 vdd.n16 4.36945474579428e-05f
CMODEL16678 a_0_n35917.t0 vdd.t14 7.4933555056298e-05f
CMODEL16679 a_0_n35917.t0 vdd.n17 6.12066286174711e-05f
CMODEL16680 a_0_n35917.t0 vdd.t32 7.4933555056298e-05f
CMODEL16681 a_0_n35917.t0 vdd.n18 6.04192632597007e-05f
CMODEL16682 a_0_n35917.t0 vdd.t34 5.55500460279939e-06f
CMODEL16683 a_0_n35917.t0 vdd.n19 6.08428573623845e-05f
CMODEL16684 a_0_n35917.t0 vdd.t33 7.4933555056298e-05f
CMODEL16685 a_0_n35917.t0 vdd.n20 0.000121420741808896f
CMODEL16686 a_0_n35917.t0 vdd.t48 7.50767673278188e-05f
CMODEL16687 a_0_n35917.t0 vdd.n21 0.000215535072909974f
CMODEL16688 a_0_n35917.t0 vdd.n22 0.000944554421866202f
CMODEL16689 a_0_n35917.t0 vdd.t47 1.06788919266262e-06f
CMODEL16690 a_0_n35917.t0 vdd.t45 1.05692469195905e-06f
CMODEL16691 a_0_n35917.t0 vdd.n23 1.20688667264814e-05f
CMODEL16692 a_0_n35917.t0 vdd.t46 2.88030091587698e-05f
CMODEL16693 a_0_n35917.t0 vdd.n24 3.09462382078412e-05f
CMODEL16694 a_0_n35917.t0 vdd.t44 2.88030091587698e-05f
CMODEL16695 a_0_n35917.t0 vdd.n25 4.88051710291962e-05f
CMODEL16696 a_0_n35917.t0 vdd.t43 2.88654001589154e-05f
CMODEL16697 a_0_n35917.t0 vdd.n26 0.000261135189558806f
CMODEL16698 a_0_n35917.t0 vdd.n27 0.000174574248305871f
CMODEL16699 a_0_n35917.t0 vdd.n28 3.94332270412145e-05f
CMODEL16700 a_0_n35917.t0 vdd.t29 3.29850491956519e-06f
CMODEL16701 a_0_n35917.t0 vdd.t28 2.60729723591758e-05f
CMODEL16702 a_0_n35917.t0 vdd.n29 5.88638692221711e-06f
CMODEL16703 a_0_n35917.t0 vdd.n30 1.877887527774e-06f
CMODEL16704 a_0_n35917.t0 vdd.t38 8.64621429137215e-07f
CMODEL16705 a_0_n35917.t0 vdd.t40 8.64621429137215e-07f
CMODEL16706 a_0_n35917.t0 vdd.t37 1.74714137085859e-05f
CMODEL16707 a_0_n35917.t0 vdd.t39 1.74714137085859e-05f
CMODEL16708 a_0_n35917.t0 vdd.n31 5.65857668439712e-06f
CMODEL16709 a_0_n35917.t0 vdd.n32 6.82871762611202e-05f
CMODEL16710 a_0_n35917.t0 vdd.n33 3.46011724875606e-05f
CMODEL16711 a_0_n35917.t0 vdd.t17 3.29850491956519e-06f
CMODEL16712 a_0_n35917.t0 vdd.t16 2.60729723591758e-05f
CMODEL16713 a_0_n35917.t0 vdd.n34 5.88638692221711e-06f
CMODEL16714 a_0_n35917.t0 vdd.n35 1.877887527774e-06f
CMODEL16715 a_0_n35917.t0 vdd.t1 8.64621429137215e-07f
CMODEL16716 a_0_n35917.t0 vdd.t31 8.64621429137215e-07f
CMODEL16717 a_0_n35917.t0 vdd.t0 1.74714137085859e-05f
CMODEL16718 a_0_n35917.t0 vdd.t30 1.74714137085859e-05f
CMODEL16719 a_0_n35917.t0 vdd.n36 5.65857668439712e-06f
CMODEL16720 a_0_n35917.t0 vdd.n37 6.62251008325772e-05f
CMODEL16721 a_0_n35917.t0 vdd.n38 3.82017223603733e-05f
CMODEL16722 a_0_n35917.t0 vdd.t19 3.29850491956519e-06f
CMODEL16723 a_0_n35917.t0 vdd.t18 2.60729723591758e-05f
CMODEL16724 a_0_n35917.t0 vdd.n39 3.22369614650919e-05f
CMODEL16725 a_0_n35917.t0 vdd.t21 3.29853513312459e-06f
CMODEL16726 a_0_n35917.t0 vdd.t20 2.60729723591758e-05f
CMODEL16727 a_0_n35917.t0 vdd.n40 3.22369614650919e-05f
CMODEL16728 a_0_n35917.t0 vdd.t11 3.29850491956519e-06f
CMODEL16729 a_0_n35917.t0 vdd.t10 2.60729723591758e-05f
CMODEL16730 a_0_n35917.t0 vdd.n41 0.00013868930167972f
CMODEL16731 a_0_n35917.t0 vdd.n42 0.000265659065806656f
CMODEL16732 a_0_n35917.t0 vdd.n43 3.22369614650919e-05f
CMODEL16733 a_0_n35917.t0 vdd.t13 3.29850491956519e-06f
CMODEL16734 a_0_n35917.t0 vdd.t12 2.60729723591758e-05f
CMODEL16735 a_0_n35917.t0 vdd.n44 3.22369614650919e-05f
CMODEL16736 a_0_n35917.t0 vdd.t23 3.29850491956519e-06f
CMODEL16737 a_0_n35917.t0 vdd.t22 2.60729723591758e-05f
CMODEL16738 a_0_n35917.t0 vdd.n45 3.97951854827375e-05f
CMODEL16739 a_0_n35917.t0 vdd.n46 0.000656860909330137f
CMODEL16740 a_0_n35917.t2 vdd 9.02462090982513e-06f
CMODEL16741 a_0_n35917.t2 vdd.n0 0.0030284948429147f
CMODEL16742 a_0_n35917.t2 vdd.n1 0.000280652912405776f
CMODEL16743 a_0_n35917.t2 vdd.t7 2.31360162543141e-05f
CMODEL16744 a_0_n35917.t2 vdd.t6 0.000182878221197163f
CMODEL16745 a_0_n35917.t2 vdd.n2 0.000251672759595306f
CMODEL16746 a_0_n35917.t2 vdd.t27 2.31360162543141e-05f
CMODEL16747 a_0_n35917.t2 vdd.t26 0.000182878221197163f
CMODEL16748 a_0_n35917.t2 vdd.n3 0.000472044834948517f
CMODEL16749 a_0_n35917.t2 vdd.n4 0.000251672759595306f
CMODEL16750 a_0_n35917.t2 vdd.t36 2.31360162543141e-05f
CMODEL16751 a_0_n35917.t2 vdd.t35 0.000182878221197163f
CMODEL16752 a_0_n35917.t2 vdd.n5 0.000359097470828617f
CMODEL16753 a_0_n35917.t2 vdd.t3 3.68542775477704e-05f
CMODEL16754 a_0_n35917.t2 vdd.n6 0.000352604221233642f
CMODEL16755 a_0_n35917.t2 vdd.t2 0.000462112112738449f
CMODEL16756 a_0_n35917.t2 vdd.n7 0.000472680596984578f
CMODEL16757 a_0_n35917.t2 vdd.t25 3.68542775477704e-05f
CMODEL16758 a_0_n35917.t2 vdd.n8 0.000212976043667029f
CMODEL16759 a_0_n35917.t2 vdd.t24 0.000462112112738449f
CMODEL16760 a_0_n35917.t2 vdd.n9 0.000472680596984578f
CMODEL16761 a_0_n35917.t2 vdd.t5 3.68542775477704e-05f
CMODEL16762 a_0_n35917.t2 vdd.n10 0.000630642032464419f
CMODEL16763 a_0_n35917.t2 vdd.t4 0.000462366417552874f
CMODEL16764 a_0_n35917.t2 vdd.n11 0.00152478623680846f
CMODEL16765 a_0_n35917.t2 vdd.n12 0.00375955760818181f
CMODEL16766 a_0_n35917.t2 vdd.n13 0.000284969736630633f
CMODEL16767 a_0_n35917.t2 vdd.t42 2.31360162543141e-05f
CMODEL16768 a_0_n35917.t2 vdd.t41 0.000182878221197163f
CMODEL16769 a_0_n35917.t2 vdd.n14 0.000256209981325998f
CMODEL16770 a_0_n35917.t2 vdd.t9 2.31360162543141e-05f
CMODEL16771 a_0_n35917.t2 vdd.t8 0.000182878221197163f
CMODEL16772 a_0_n35917.t2 vdd.n15 0.000491889087300783f
CMODEL16773 a_0_n35917.t2 vdd.t15 3.89633121420651e-05f
CMODEL16774 a_0_n35917.t2 vdd.n16 0.000306477566310594f
CMODEL16775 a_0_n35917.t2 vdd.t14 0.000525590832832403f
CMODEL16776 a_0_n35917.t2 vdd.n17 0.000429308910884463f
CMODEL16777 a_0_n35917.t2 vdd.t32 0.000525590832832403f
CMODEL16778 a_0_n35917.t2 vdd.n18 0.000423786257997875f
CMODEL16779 a_0_n35917.t2 vdd.t34 3.89633121420651e-05f
CMODEL16780 a_0_n35917.t2 vdd.n19 0.000426757385913069f
CMODEL16781 a_0_n35917.t2 vdd.t33 0.000525590832832403f
CMODEL16782 a_0_n35917.t2 vdd.n20 0.000851656227474052f
CMODEL16783 a_0_n35917.t2 vdd.t48 0.00052659533684938f
CMODEL16784 a_0_n35917.t2 vdd.n21 0.00151178278396422f
CMODEL16785 a_0_n35917.t2 vdd.n22 0.00662519140952542f
CMODEL16786 a_0_n35917.t2 vdd.t47 7.49027281199431e-06f
CMODEL16787 a_0_n35917.t2 vdd.t45 7.41336679769873e-06f
CMODEL16788 a_0_n35917.t2 vdd.n23 8.46521389429462e-05f
CMODEL16789 a_0_n35917.t2 vdd.t46 0.000202026949881978f
CMODEL16790 a_0_n35917.t2 vdd.n24 0.000217059755145331f
CMODEL16791 a_0_n35917.t2 vdd.t44 0.000202026949881978f
CMODEL16792 a_0_n35917.t2 vdd.n25 0.000342323949110528f
CMODEL16793 a_0_n35917.t2 vdd.t43 0.000202464566083467f
CMODEL16794 a_0_n35917.t2 vdd.n26 0.00183162618747961f
CMODEL16795 a_0_n35917.t2 vdd.n27 0.00122447980066124f
CMODEL16796 a_0_n35917.t2 vdd.n28 0.000276588273788556f
CMODEL16797 a_0_n35917.t2 vdd.t29 2.31360162543141e-05f
CMODEL16798 a_0_n35917.t2 vdd.t28 0.000182878221197163f
CMODEL16799 a_0_n35917.t2 vdd.n29 4.1287658145906e-05f
CMODEL16800 a_0_n35917.t2 vdd.n30 1.31716754789864e-05f
CMODEL16801 a_0_n35917.t2 vdd.t38 6.06453406199065e-06f
CMODEL16802 a_0_n35917.t2 vdd.t40 6.06453406199065e-06f
CMODEL16803 a_0_n35917.t2 vdd.t37 0.000122546099340356f
CMODEL16804 a_0_n35917.t2 vdd.t39 0.000122546099340356f
CMODEL16805 a_0_n35917.t2 vdd.n31 3.96897762286047e-05f
CMODEL16806 a_0_n35917.t2 vdd.n32 0.0004789725219348f
CMODEL16807 a_0_n35917.t2 vdd.n33 0.000242695799646117f
CMODEL16808 a_0_n35917.t2 vdd.t17 2.31360162543141e-05f
CMODEL16809 a_0_n35917.t2 vdd.t16 0.000182878221197163f
CMODEL16810 a_0_n35917.t2 vdd.n34 4.1287658145906e-05f
CMODEL16811 a_0_n35917.t2 vdd.n35 1.31716754789864e-05f
CMODEL16812 a_0_n35917.t2 vdd.t1 6.06453406199065e-06f
CMODEL16813 a_0_n35917.t2 vdd.t31 6.06453406199065e-06f
CMODEL16814 a_0_n35917.t2 vdd.t0 0.000122546099340356f
CMODEL16815 a_0_n35917.t2 vdd.t30 0.000122546099340356f
CMODEL16816 a_0_n35917.t2 vdd.n36 3.96897762286047e-05f
CMODEL16817 a_0_n35917.t2 vdd.n37 0.000464508935614401f
CMODEL16818 a_0_n35917.t2 vdd.n38 0.000267950386925267f
CMODEL16819 a_0_n35917.t2 vdd.t19 2.31360162543141e-05f
CMODEL16820 a_0_n35917.t2 vdd.t18 0.000182878221197163f
CMODEL16821 a_0_n35917.t2 vdd.n39 0.000226113006538846f
CMODEL16822 a_0_n35917.t2 vdd.t21 2.31362281749928e-05f
CMODEL16823 a_0_n35917.t2 vdd.t20 0.000182878221197163f
CMODEL16824 a_0_n35917.t2 vdd.n40 0.000226113006538846f
CMODEL16825 a_0_n35917.t2 vdd.t11 2.31360162543141e-05f
CMODEL16826 a_0_n35917.t2 vdd.t10 0.000182878221197163f
CMODEL16827 a_0_n35917.t2 vdd.n41 0.000972779491377702f
CMODEL16828 a_0_n35917.t2 vdd.n42 0.00186335707069944f
CMODEL16829 a_0_n35917.t2 vdd.n43 0.000226113006538846f
CMODEL16830 a_0_n35917.t2 vdd.t13 2.31360162543141e-05f
CMODEL16831 a_0_n35917.t2 vdd.t12 0.000182878221197163f
CMODEL16832 a_0_n35917.t2 vdd.n44 0.000226113006538846f
CMODEL16833 a_0_n35917.t2 vdd.t23 2.31360162543141e-05f
CMODEL16834 a_0_n35917.t2 vdd.t22 0.000182878221197163f
CMODEL16835 a_0_n35917.t2 vdd.n45 0.000279127083519228f
CMODEL16836 a_0_n35917.t2 vdd.n46 0.00460728270706622f
CMODEL16837 a_0_n35917.t3 vdd 2.16369389213674e-06f
CMODEL16838 a_0_n35917.t3 vdd.n0 0.000726095407159779f
CMODEL16839 a_0_n35917.t3 vdd.n1 6.72878116931927e-05f
CMODEL16840 a_0_n35917.t3 vdd.t7 5.54696508119648e-06f
CMODEL16841 a_0_n35917.t3 vdd.t6 4.38458849588175e-05f
CMODEL16842 a_0_n35917.t3 vdd.n2 6.03396883032189e-05f
CMODEL16843 a_0_n35917.t3 vdd.t27 5.54696508119648e-06f
CMODEL16844 a_0_n35917.t3 vdd.t26 4.38458849588175e-05f
CMODEL16845 a_0_n35917.t3 vdd.n3 0.000113174895255804f
CMODEL16846 a_0_n35917.t3 vdd.n4 6.03396883032189e-05f
CMODEL16847 a_0_n35917.t3 vdd.t36 5.54696508119648e-06f
CMODEL16848 a_0_n35917.t3 vdd.t35 4.38458849588175e-05f
CMODEL16849 a_0_n35917.t3 vdd.n5 8.60952512107996e-05f
CMODEL16850 a_0_n35917.t3 vdd.t3 8.83598059419962e-06f
CMODEL16851 a_0_n35917.t3 vdd.n6 8.4538465099876e-05f
CMODEL16852 a_0_n35917.t3 vdd.t2 0.000110793479948396f
CMODEL16853 a_0_n35917.t3 vdd.n7 0.000113327322094341f
CMODEL16854 a_0_n35917.t3 vdd.t25 8.83598059419962e-06f
CMODEL16855 a_0_n35917.t3 vdd.n8 5.10619747309393e-05f
CMODEL16856 a_0_n35917.t3 vdd.t24 0.000110793479948396f
CMODEL16857 a_0_n35917.t3 vdd.n9 0.000113327322094341f
CMODEL16858 a_0_n35917.t3 vdd.t5 8.83598059419962e-06f
CMODEL16859 a_0_n35917.t3 vdd.n10 0.00015119929439722f
CMODEL16860 a_0_n35917.t3 vdd.t4 0.000110854450683811f
CMODEL16861 a_0_n35917.t3 vdd.n11 0.000365574432473369f
CMODEL16862 a_0_n35917.t3 vdd.n12 0.000901371028793365f
CMODEL16863 a_0_n35917.t3 vdd.n13 6.83227899268583e-05f
CMODEL16864 a_0_n35917.t3 vdd.t42 5.54696508119648e-06f
CMODEL16865 a_0_n35917.t3 vdd.t41 4.38458849588175e-05f
CMODEL16866 a_0_n35917.t3 vdd.n14 6.14275078409106e-05f
CMODEL16867 a_0_n35917.t3 vdd.t9 5.54696508119648e-06f
CMODEL16868 a_0_n35917.t3 vdd.t8 4.38458849588175e-05f
CMODEL16869 a_0_n35917.t3 vdd.n15 0.000117932644976003f
CMODEL16870 a_0_n35917.t3 vdd.t15 9.34163122657271e-06f
CMODEL16871 a_0_n35917.t3 vdd.n16 7.34793898745618e-05f
CMODEL16872 a_0_n35917.t3 vdd.t14 0.000126012791686844f
CMODEL16873 a_0_n35917.t3 vdd.n17 0.000102928763169353f
CMODEL16874 a_0_n35917.t3 vdd.t32 0.000126012791686844f
CMODEL16875 a_0_n35917.t3 vdd.n18 0.00010160468203193f
CMODEL16876 a_0_n35917.t3 vdd.t34 9.34163122657271e-06f
CMODEL16877 a_0_n35917.t3 vdd.n19 0.000102317023457359f
CMODEL16878 a_0_n35917.t3 vdd.t33 0.000126012791686844f
CMODEL16879 a_0_n35917.t3 vdd.n20 0.000204188452456728f
CMODEL16880 a_0_n35917.t3 vdd.t48 0.000126253626091732f
CMODEL16881 a_0_n35917.t3 vdd.n21 0.000362456795535828f
CMODEL16882 a_0_n35917.t3 vdd.n22 0.00158841976081461f
CMODEL16883 a_0_n35917.t3 vdd.t47 1.79582696001177e-06f
CMODEL16884 a_0_n35917.t3 vdd.t45 1.77738839344342e-06f
CMODEL16885 a_0_n35917.t3 vdd.n23 2.02957351690811e-05f
CMODEL16886 a_0_n35917.t3 vdd.t46 4.84368797176567e-05f
CMODEL16887 a_0_n35917.t3 vdd.n24 5.2041063123808e-05f
CMODEL16888 a_0_n35917.t3 vdd.t44 4.84368797176567e-05f
CMODEL16889 a_0_n35917.t3 vdd.n25 8.20737231207342e-05f
CMODEL16890 a_0_n35917.t3 vdd.t43 4.85418001915163e-05f
CMODEL16891 a_0_n35917.t3 vdd.n26 0.000439140705645897f
CMODEL16892 a_0_n35917.t3 vdd.n27 0.000293574599111539f
CMODEL16893 a_0_n35917.t3 vdd.n28 6.63132961054801e-05f
CMODEL16894 a_0_n35917.t3 vdd.t29 5.54696508119648e-06f
CMODEL16895 a_0_n35917.t3 vdd.t28 4.38458849588175e-05f
CMODEL16896 a_0_n35917.t3 vdd.n29 9.89890374826363e-06f
CMODEL16897 a_0_n35917.t3 vdd.n30 3.15796907901834e-06f
CMODEL16898 a_0_n35917.t3 vdd.t38 1.45399961280353e-06f
CMODEL16899 a_0_n35917.t3 vdd.t40 1.45399961280353e-06f
CMODEL16900 a_0_n35917.t3 vdd.t37 2.93809844532348e-05f
CMODEL16901 a_0_n35917.t3 vdd.t39 2.93809844532348e-05f
CMODEL16902 a_0_n35917.t3 vdd.n31 9.51580429407421e-06f
CMODEL16903 a_0_n35917.t3 vdd.n32 0.000114835839706395f
CMODEL16904 a_0_n35917.t3 vdd.n33 5.81874213430778e-05f
CMODEL16905 a_0_n35917.t3 vdd.t17 5.54696508119648e-06f
CMODEL16906 a_0_n35917.t3 vdd.t16 4.38458849588175e-05f
CMODEL16907 a_0_n35917.t3 vdd.n34 9.89890374826363e-06f
CMODEL16908 a_0_n35917.t3 vdd.n35 3.15796907901834e-06f
CMODEL16909 a_0_n35917.t3 vdd.t1 1.45399961280353e-06f
CMODEL16910 a_0_n35917.t3 vdd.t31 1.45399961280353e-06f
CMODEL16911 a_0_n35917.t3 vdd.t0 2.93809844532348e-05f
CMODEL16912 a_0_n35917.t3 vdd.t30 2.93809844532348e-05f
CMODEL16913 a_0_n35917.t3 vdd.n36 9.51580429407421e-06f
CMODEL16914 a_0_n35917.t3 vdd.n37 0.00011136812912968f
CMODEL16915 a_0_n35917.t3 vdd.n38 6.42423234592254e-05f
CMODEL16916 a_0_n35917.t3 vdd.t19 5.54696508119648e-06f
CMODEL16917 a_0_n35917.t3 vdd.t18 4.38458849588175e-05f
CMODEL16918 a_0_n35917.t3 vdd.n39 5.42116213045735e-05f
CMODEL16919 a_0_n35917.t3 vdd.t21 5.54701589014266e-06f
CMODEL16920 a_0_n35917.t3 vdd.t20 4.38458849588175e-05f
CMODEL16921 a_0_n35917.t3 vdd.n40 5.42116213045735e-05f
CMODEL16922 a_0_n35917.t3 vdd.t11 5.54696508119648e-06f
CMODEL16923 a_0_n35917.t3 vdd.t10 4.38458849588175e-05f
CMODEL16924 a_0_n35917.t3 vdd.n41 0.000233228305645317f
CMODEL16925 a_0_n35917.t3 vdd.n42 0.000446748329157274f
CMODEL16926 a_0_n35917.t3 vdd.n43 5.42116213045735e-05f
CMODEL16927 a_0_n35917.t3 vdd.t13 5.54696508119648e-06f
CMODEL16928 a_0_n35917.t3 vdd.t12 4.38458849588175e-05f
CMODEL16929 a_0_n35917.t3 vdd.n44 5.42116213045735e-05f
CMODEL16930 a_0_n35917.t3 vdd.t23 5.54696508119648e-06f
CMODEL16931 a_0_n35917.t3 vdd.t22 4.38458849588175e-05f
CMODEL16932 a_0_n35917.t3 vdd.n45 6.69219872807042e-05f
CMODEL16933 a_0_n35917.t3 vdd.n46 0.00110461697529847f
CMODEL16934 en vdd 2.17032896420812e-07f
CMODEL16935 en vdd.n0 7.28322013878369e-05f
CMODEL16936 en vdd.n1 6.74941530253619e-06f
CMODEL16937 en vdd.t7 5.56397511816378e-07f
CMODEL16938 en vdd.t6 4.39803404877593e-06f
CMODEL16939 en vdd.n2 6.05247228786325e-06f
CMODEL16940 en vdd.t27 5.56397511816378e-07f
CMODEL16941 en vdd.t26 4.39803404877593e-06f
CMODEL16942 en vdd.n3 1.13521951551254e-05f
CMODEL16943 en vdd.n4 6.05247228786325e-06f
CMODEL16944 en vdd.t36 5.56397511816378e-07f
CMODEL16945 en vdd.t35 4.39803404877593e-06f
CMODEL16946 en vdd.n5 8.63592664667761e-06f
CMODEL16947 en vdd.t3 8.863076556469e-07f
CMODEL16948 en vdd.n6 8.47977063958745e-06f
CMODEL16949 en vdd.t2 1.11133233518514e-05f
CMODEL16950 en vdd.n7 1.13674845814071e-05f
CMODEL16951 en vdd.t25 8.863076556469e-07f
CMODEL16952 en vdd.n8 5.12185587485206e-06f
CMODEL16953 en vdd.t24 1.11133233518514e-05f
CMODEL16954 en vdd.n9 1.13674845814071e-05f
CMODEL16955 en vdd.t5 8.863076556469e-07f
CMODEL16956 en vdd.n10 1.51662954353517e-05f
CMODEL16957 en vdd.t4 1.11194391223641e-05f
CMODEL16958 en vdd.n11 3.66695484169143e-05f
CMODEL16959 en vdd.n12 9.04135126691332e-05f
CMODEL16960 en vdd.n13 6.85323050698876e-06f
CMODEL16961 en vdd.t42 5.56397511816378e-07f
CMODEL16962 en vdd.t41 4.39803404877593e-06f
CMODEL16963 en vdd.n14 6.16158782676012e-06f
CMODEL16964 en vdd.t9 5.56397511816378e-07f
CMODEL16965 en vdd.t8 4.39803404877593e-06f
CMODEL16966 en vdd.n15 1.18294291141307e-05f
CMODEL16967 en vdd.t15 9.37027779098638e-07f
CMODEL16968 en vdd.n16 7.37047179809777e-06f
CMODEL16969 en vdd.t14 1.26399216013222e-05f
CMODEL16970 en vdd.n17 1.03244399204713e-05f
CMODEL16971 en vdd.t32 1.26399216013222e-05f
CMODEL16972 en vdd.n18 1.01916257708379e-05f
CMODEL16973 en vdd.t34 9.37027779098638e-07f
CMODEL16974 en vdd.n19 1.02630783563276e-05f
CMODEL16975 en vdd.t33 1.26399216013222e-05f
CMODEL16976 en vdd.n20 2.04814606231584e-05f
CMODEL16977 en vdd.t48 1.26640788948473e-05f
CMODEL16978 en vdd.n21 3.63568286846998e-05f
CMODEL16979 en vdd.n22 0.000159329072691148f
CMODEL16980 en vdd.t47 1.80133395032621e-07f
CMODEL16981 en vdd.t45 1.78283884100081e-07f
CMODEL16982 en vdd.n23 2.03579730235567e-06f
CMODEL16983 en vdd.t46 4.85854137542908e-06f
CMODEL16984 en vdd.n24 5.22006495633467e-06f
CMODEL16985 en vdd.t44 4.85854137542908e-06f
CMODEL16986 en vdd.n25 8.23254061661279e-06f
CMODEL16987 en vdd.t43 4.8690655971863e-06f
CMODEL16988 en vdd.n26 4.40487351879926e-05f
CMODEL16989 en vdd.n27 2.94474859832573e-05f
CMODEL16990 en vdd.n28 6.65166490384203e-06f
CMODEL16991 en vdd.t29 5.56397511816378e-07f
CMODEL16992 en vdd.t28 4.39803404877593e-06f
CMODEL16993 en vdd.n29 9.92925921584436e-07f
CMODEL16994 en vdd.n30 3.16765314408625e-07f
CMODEL16995 en vdd.t38 1.45845837300883e-07f
CMODEL16996 en vdd.t40 1.45845837300883e-07f
CMODEL16997 en vdd.t37 2.94710826644854e-06f
CMODEL16998 en vdd.t39 2.94710826644854e-06f
CMODEL16999 en vdd.n31 9.54498496863164e-07f
CMODEL17000 en vdd.n32 1.15187989368414e-05f
CMODEL17001 en vdd.n33 5.83658558876602e-06f
CMODEL17002 en vdd.t17 5.56397511816378e-07f
CMODEL17003 en vdd.t16 4.39803404877593e-06f
CMODEL17004 en vdd.n34 9.92925921584436e-07f
CMODEL17005 en vdd.n35 3.16765314408625e-07f
CMODEL17006 en vdd.t1 1.45845837300883e-07f
CMODEL17007 en vdd.t31 1.45845837300883e-07f
CMODEL17008 en vdd.t0 2.94710826644854e-06f
CMODEL17009 en vdd.t30 2.94710826644854e-06f
CMODEL17010 en vdd.n36 9.54498496863164e-07f
CMODEL17011 en vdd.n37 1.11709644889333e-05f
CMODEL17012 en vdd.n38 6.44393256542836e-06f
CMODEL17013 en vdd.t19 5.56397511816378e-07f
CMODEL17014 en vdd.t18 4.39803404877593e-06f
CMODEL17015 en vdd.n39 5.4377863865857e-06f
CMODEL17016 en vdd.t21 5.56402608291805e-07f
CMODEL17017 en vdd.t20 4.39803404877593e-06f
CMODEL17018 en vdd.n40 5.4377863865857e-06f
CMODEL17019 en vdd.t11 5.56397511816378e-07f
CMODEL17020 en vdd.t10 4.39803404877593e-06f
CMODEL17021 en vdd.n41 2.33943511535885e-05f
CMODEL17022 en vdd.n42 4.48118304537109e-05f
CMODEL17023 en vdd.n43 5.4377863865857e-06f
CMODEL17024 en vdd.t13 5.56397511816378e-07f
CMODEL17025 en vdd.t12 4.39803404877593e-06f
CMODEL17026 en vdd.n44 5.4377863865857e-06f
CMODEL17027 en vdd.t23 5.56397511816378e-07f
CMODEL17028 en vdd.t22 4.39803404877593e-06f
CMODEL17029 en vdd.n45 6.71272067946018e-06f
CMODEL17030 en vdd.n46 0.000110800433673117f
CMODEL17031 en.t3 vdd 1.64564697298593e-06f
CMODEL17032 en.t3 vdd.n0 0.00055224850115534f
CMODEL17033 en.t3 vdd.n1 5.11772871542368e-05f
CMODEL17034 en.t3 vdd.t7 4.21887140704318e-06f
CMODEL17035 en.t3 vdd.t6 3.33479925800001e-05f
CMODEL17036 en.t3 vdd.n2 4.58927326864365e-05f
CMODEL17037 en.t3 vdd.t27 4.21887140704318e-06f
CMODEL17038 en.t3 vdd.t26 3.33479925800001e-05f
CMODEL17039 en.t3 vdd.n3 8.60777601085653e-05f
CMODEL17040 en.t3 vdd.n4 4.58927326864365e-05f
CMODEL17041 en.t3 vdd.t36 4.21887140704318e-06f
CMODEL17042 en.t3 vdd.t35 3.33479925800001e-05f
CMODEL17043 en.t3 vdd.n5 6.54817162716111e-05f
CMODEL17044 en.t3 vdd.t3 6.72040752670762e-06f
CMODEL17045 en.t3 vdd.n6 6.4297666919557e-05f
CMODEL17046 en.t3 vdd.t2 8.42665201238794e-05f
CMODEL17047 en.t3 vdd.n7 8.61936918336359e-05f
CMODEL17048 en.t3 vdd.t25 6.72040752670762e-06f
CMODEL17049 en.t3 vdd.n8 3.88363550204744e-05f
CMODEL17050 en.t3 vdd.t24 8.42665201238794e-05f
CMODEL17051 en.t3 vdd.n9 8.61936918336359e-05f
CMODEL17052 en.t3 vdd.t5 6.72040752670762e-06f
CMODEL17053 en.t3 vdd.n10 0.00011499808824467f
CMODEL17054 en.t3 vdd.t4 8.43128928139076e-05f
CMODEL17055 en.t3 vdd.n11 0.000278046012140257f
CMODEL17056 en.t3 vdd.n12 0.000685558391813991f
CMODEL17057 en.t3 vdd.n13 5.1964463567466e-05f
CMODEL17058 en.t3 vdd.t42 4.21887140704318e-06f
CMODEL17059 en.t3 vdd.t41 3.33479925800001e-05f
CMODEL17060 en.t3 vdd.n14 4.67200987643569e-05f
CMODEL17061 en.t3 vdd.t9 4.21887140704318e-06f
CMODEL17062 en.t3 vdd.t8 3.33479925800001e-05f
CMODEL17063 en.t3 vdd.n15 8.96963756871014e-05f
CMODEL17064 en.t3 vdd.t15 7.10499170267506e-06f
CMODEL17065 en.t3 vdd.n16 5.58864338266034e-05f
CMODEL17066 en.t3 vdd.t14 9.58419164330924e-05f
CMODEL17067 en.t3 vdd.n17 7.82848295493214e-05f
CMODEL17068 en.t3 vdd.t32 9.58419164330924e-05f
CMODEL17069 en.t3 vdd.n18 7.72777692975418e-05f
CMODEL17070 en.t3 vdd.t34 7.10499170267506e-06f
CMODEL17071 en.t3 vdd.n19 7.78195568927049e-05f
CMODEL17072 en.t3 vdd.t33 9.58419164330924e-05f
CMODEL17073 en.t3 vdd.n20 0.00015530020670912f
CMODEL17074 en.t3 vdd.t48 9.60250885587039e-05f
CMODEL17075 en.t3 vdd.n21 0.00027567482192348f
CMODEL17076 en.t3 vdd.n22 0.00120810904939709f
CMODEL17077 en.t3 vdd.t47 1.36585734770061e-06f
CMODEL17078 en.t3 vdd.t45 1.35183347335791e-06f
CMODEL17079 en.t3 vdd.n23 1.54363864809633e-05f
CMODEL17080 en.t3 vdd.t46 3.6839778851309e-05f
CMODEL17081 en.t3 vdd.n24 3.95810231345111e-05f
CMODEL17082 en.t3 vdd.t44 3.6839778851309e-05f
CMODEL17083 en.t3 vdd.n25 6.24230509251658e-05f
CMODEL17084 en.t3 vdd.t43 3.69195785220659e-05f
CMODEL17085 en.t3 vdd.n26 0.00033399852705015f
CMODEL17086 en.t3 vdd.n27 0.000223284888925005f
CMODEL17087 en.t3 vdd.n28 5.04360969919523e-05f
CMODEL17088 en.t3 vdd.t29 4.21887140704318e-06f
CMODEL17089 en.t3 vdd.t28 3.33479925800001e-05f
CMODEL17090 en.t3 vdd.n29 7.52883808953307e-06f
CMODEL17091 en.t3 vdd.n30 2.40186575123044e-06f
CMODEL17092 en.t3 vdd.t38 1.10587272544818e-06f
CMODEL17093 en.t3 vdd.t40 1.10587272544818e-06f
CMODEL17094 en.t3 vdd.t37 2.23463810220697e-05f
CMODEL17095 en.t3 vdd.t39 2.23463810220697e-05f
CMODEL17096 en.t3 vdd.n31 7.23746302052237e-06f
CMODEL17097 en.t3 vdd.n32 8.7341029472751e-05f
CMODEL17098 en.t3 vdd.n33 4.42557767284401e-05f
CMODEL17099 en.t3 vdd.t17 4.21887140704318e-06f
CMODEL17100 en.t3 vdd.t16 3.33479925800001e-05f
CMODEL17101 en.t3 vdd.n34 7.52883808953307e-06f
CMODEL17102 en.t3 vdd.n35 2.40186575123044e-06f
CMODEL17103 en.t3 vdd.t1 1.10587272544818e-06f
CMODEL17104 en.t3 vdd.t31 1.10587272544818e-06f
CMODEL17105 en.t3 vdd.t0 2.23463810220697e-05f
CMODEL17106 en.t3 vdd.t30 2.23463810220697e-05f
CMODEL17107 en.t3 vdd.n36 7.23746302052237e-06f
CMODEL17108 en.t3 vdd.n37 8.47035827273954e-05f
CMODEL17109 en.t3 vdd.n38 4.88609712873268e-05f
CMODEL17110 en.t3 vdd.t19 4.21887140704318e-06f
CMODEL17111 en.t3 vdd.t18 3.33479925800001e-05f
CMODEL17112 en.t3 vdd.n39 4.1231890899516e-05f
CMODEL17113 en.t3 vdd.t21 4.21891005095154e-06f
CMODEL17114 en.t3 vdd.t20 3.33479925800001e-05f
CMODEL17115 en.t3 vdd.n40 4.1231890899516e-05f
CMODEL17116 en.t3 vdd.t11 4.21887140704318e-06f
CMODEL17117 en.t3 vdd.t10 3.33479925800001e-05f
CMODEL17118 en.t3 vdd.n41 0.000177387132530482f
CMODEL17119 en.t3 vdd.n42 0.000339784679448422f
CMODEL17120 en.t3 vdd.n43 4.1231890899516e-05f
CMODEL17121 en.t3 vdd.t13 4.21887140704318e-06f
CMODEL17122 en.t3 vdd.t12 3.33479925800001e-05f
CMODEL17123 en.t3 vdd.n44 4.1231890899516e-05f
CMODEL17124 en.t3 vdd.t23 4.21887140704318e-06f
CMODEL17125 en.t3 vdd.t22 3.33479925800001e-05f
CMODEL17126 en.t3 vdd.n45 5.08990510140674e-05f
CMODEL17127 en.t3 vdd.n46 0.000840141754023091f
CMODEL17128 en.t1 vdd 1.48125415427067e-06f
CMODEL17129 en.t1 vdd.n0 0.000497081330293974f
CMODEL17130 en.t1 vdd.n1 4.60649036190123e-05f
CMODEL17131 en.t1 vdd.t7 3.79742490376147e-06f
CMODEL17132 en.t1 vdd.t6 3.00166763325216e-05f
CMODEL17133 en.t1 vdd.n2 4.13082526559593e-05f
CMODEL17134 en.t1 vdd.t27 3.79742490376147e-06f
CMODEL17135 en.t1 vdd.t26 3.00166763325216e-05f
CMODEL17136 en.t1 vdd.n3 7.74789744362848e-05f
CMODEL17137 en.t1 vdd.n4 4.13082526559593e-05f
CMODEL17138 en.t1 vdd.t36 3.79742490376147e-06f
CMODEL17139 en.t1 vdd.t35 3.00166763325216e-05f
CMODEL17140 en.t1 vdd.n5 5.89403838419277e-05f
CMODEL17141 en.t1 vdd.t3 6.04906868285695e-06f
CMODEL17142 en.t1 vdd.n6 5.78746157577745e-05f
CMODEL17143 en.t1 vdd.t2 7.58486692762242e-05f
CMODEL17144 en.t1 vdd.n7 7.75833250972658e-05f
CMODEL17145 en.t1 vdd.t25 6.04906868285695e-06f
CMODEL17146 en.t1 vdd.n8 3.49567757575793e-05f
CMODEL17147 en.t1 vdd.t24 7.58486692762242e-05f
CMODEL17148 en.t1 vdd.n9 7.75833250972658e-05f
CMODEL17149 en.t1 vdd.t5 6.04906868285695e-06f
CMODEL17150 en.t1 vdd.n10 0.000103510290324618f
CMODEL17151 en.t1 vdd.t4 7.58904095406166e-05f
CMODEL17152 en.t1 vdd.n11 0.000250270451270516f
CMODEL17153 en.t1 vdd.n12 0.000617074155356086f
CMODEL17154 en.t1 vdd.n13 4.67734446070736e-05f
CMODEL17155 en.t1 vdd.t42 3.79742490376147e-06f
CMODEL17156 en.t1 vdd.t41 3.00166763325216e-05f
CMODEL17157 en.t1 vdd.n14 4.20529685398274e-05f
CMODEL17158 en.t1 vdd.t9 3.79742490376147e-06f
CMODEL17159 en.t1 vdd.t8 3.00166763325216e-05f
CMODEL17160 en.t1 vdd.n15 8.073610640104e-05f
CMODEL17161 en.t1 vdd.t15 6.39523460888476e-06f
CMODEL17162 en.t1 vdd.n16 5.03036274680626e-05f
CMODEL17163 en.t1 vdd.t14 8.62677349396456e-05f
CMODEL17164 en.t1 vdd.n17 7.04645230051385e-05f
CMODEL17165 en.t1 vdd.t32 8.62677349396456e-05f
CMODEL17166 en.t1 vdd.n18 6.95580635967497e-05f
CMODEL17167 en.t1 vdd.t34 6.39523460888476e-06f
CMODEL17168 en.t1 vdd.n19 7.00457290190678e-05f
CMODEL17169 en.t1 vdd.t33 8.62677349396456e-05f
CMODEL17170 en.t1 vdd.n20 0.000139786406272534f
CMODEL17171 en.t1 vdd.t48 8.64326089839957e-05f
CMODEL17172 en.t1 vdd.n21 0.000248136132417917f
CMODEL17173 en.t1 vdd.n22 0.00108742432466208f
CMODEL17174 en.t1 vdd.t47 1.229414269059e-06f
CMODEL17175 en.t1 vdd.t45 1.21679131743566e-06f
CMODEL17176 en.t1 vdd.n23 1.38943600767344e-05f
CMODEL17177 en.t1 vdd.t46 3.31596486741636e-05f
CMODEL17178 en.t1 vdd.n24 3.56270548366142e-05f
CMODEL17179 en.t1 vdd.t44 3.31596486741636e-05f
CMODEL17180 en.t1 vdd.n25 5.61872655697109e-05f
CMODEL17181 en.t1 vdd.t43 3.32314767124722e-05f
CMODEL17182 en.t1 vdd.n26 0.000300633558615338f
CMODEL17183 en.t1 vdd.n27 0.000200979720885043f
CMODEL17184 en.t1 vdd.n28 4.53977550598067e-05f
CMODEL17185 en.t1 vdd.t29 3.79742490376147e-06f
CMODEL17186 en.t1 vdd.t28 3.00166763325216e-05f
CMODEL17187 en.t1 vdd.n29 6.77674062543149e-06f
CMODEL17188 en.t1 vdd.n30 2.16193003749471e-06f
CMODEL17189 en.t1 vdd.t38 9.95400955098256e-07f
CMODEL17190 en.t1 vdd.t40 9.95400955098256e-07f
CMODEL17191 en.t1 vdd.t37 2.0114076873849e-05f
CMODEL17192 en.t1 vdd.t39 2.0114076873849e-05f
CMODEL17193 en.t1 vdd.n31 6.51447263083244e-06f
CMODEL17194 en.t1 vdd.n32 7.86160488054417e-05f
CMODEL17195 en.t1 vdd.n33 3.98348213229068e-05f
CMODEL17196 en.t1 vdd.t17 3.79742490376147e-06f
CMODEL17197 en.t1 vdd.t16 3.00166763325216e-05f
CMODEL17198 en.t1 vdd.n34 6.77674062543149e-06f
CMODEL17199 en.t1 vdd.n35 2.16193003749471e-06f
CMODEL17200 en.t1 vdd.t1 9.95400955098256e-07f
CMODEL17201 en.t1 vdd.t31 9.95400955098256e-07f
CMODEL17202 en.t1 vdd.t0 2.0114076873849e-05f
CMODEL17203 en.t1 vdd.t30 2.0114076873849e-05f
CMODEL17204 en.t1 vdd.n36 6.51447263083244e-06f
CMODEL17205 en.t1 vdd.n37 7.62420712681227e-05f
CMODEL17206 en.t1 vdd.n38 4.39799774126108e-05f
CMODEL17207 en.t1 vdd.t19 3.79742490376147e-06f
CMODEL17208 en.t1 vdd.t18 3.00166763325216e-05f
CMODEL17209 en.t1 vdd.n39 3.71130082489844e-05f
CMODEL17210 en.t1 vdd.t21 3.79745968731513e-06f
CMODEL17211 en.t1 vdd.t20 3.00166763325216e-05f
CMODEL17212 en.t1 vdd.n40 3.71130082489844e-05f
CMODEL17213 en.t1 vdd.t11 3.79742490376147e-06f
CMODEL17214 en.t1 vdd.t10 3.00166763325216e-05f
CMODEL17215 en.t1 vdd.n41 0.000159666946367108f
CMODEL17216 en.t1 vdd.n42 0.000305841700104902f
CMODEL17217 en.t1 vdd.n43 3.71130082489844e-05f
CMODEL17218 en.t1 vdd.t13 3.79742490376147e-06f
CMODEL17219 en.t1 vdd.t12 3.00166763325216e-05f
CMODEL17220 en.t1 vdd.n44 3.71130082489844e-05f
CMODEL17221 en.t1 vdd.t23 3.79742490376147e-06f
CMODEL17222 en.t1 vdd.t22 3.00166763325216e-05f
CMODEL17223 en.t1 vdd.n45 4.58144620326577e-05f
CMODEL17224 en.t1 vdd.n46 0.000756215326708221f
CMODEL17225 en.n0 vdd 5.91945317872748e-05f
CMODEL17226 en.n0 vdd.n0 0.0198645833479099f
CMODEL17227 en.n0 vdd.n1 0.0018408659943276f
CMODEL17228 en.n0 vdd.t7 0.000151754368774193f
CMODEL17229 en.n0 vdd.t6 0.00119953965778996f
CMODEL17230 en.n0 vdd.n2 0.00165077861072661f
CMODEL17231 en.n0 vdd.t27 0.000151754368774193f
CMODEL17232 en.n0 vdd.t26 0.00119953965778996f
CMODEL17233 en.n0 vdd.n3 0.00309624894680704f
CMODEL17234 en.n0 vdd.n4 0.00165077861072661f
CMODEL17235 en.n0 vdd.t36 0.000151754368774193f
CMODEL17236 en.n0 vdd.t35 0.00119953965778996f
CMODEL17237 en.n0 vdd.n5 0.0023554016134409f
CMODEL17238 en.n0 vdd.t3 0.000241735550511984f
CMODEL17239 en.n0 vdd.n6 0.00231281091922858f
CMODEL17240 en.n0 vdd.t2 0.00303109797299074f
CMODEL17241 en.n0 vdd.n7 0.00310041905394271f
CMODEL17242 en.n0 vdd.t25 0.000241735550511984f
CMODEL17243 en.n0 vdd.n8 0.00139695808973546f
CMODEL17244 en.n0 vdd.t24 0.00303109797299074f
CMODEL17245 en.n0 vdd.n9 0.00310041905394271f
CMODEL17246 en.n0 vdd.t5 0.000241735550511984f
CMODEL17247 en.n0 vdd.n10 0.00413652387287146f
CMODEL17248 en.n0 vdd.t4 0.00303276601584501f
CMODEL17249 en.n0 vdd.n11 0.0100014181499072f
CMODEL17250 en.n0 vdd.n12 0.0246597895432176f
CMODEL17251 en.n0 vdd.n13 0.00186918102177881f
CMODEL17252 en.n0 vdd.t42 0.000151754368774193f
CMODEL17253 en.n0 vdd.t41 0.00119953965778996f
CMODEL17254 en.n0 vdd.n14 0.00168053927531818f
CMODEL17255 en.n0 vdd.t9 0.000151754368774193f
CMODEL17256 en.n0 vdd.t8 0.00119953965778996f
CMODEL17257 en.n0 vdd.n15 0.00322641189086844f
CMODEL17258 en.n0 vdd.t15 0.000255569185916716f
CMODEL17259 en.n0 vdd.n16 0.00201025574617855f
CMODEL17260 en.n0 vdd.t14 0.00344746927013035f
CMODEL17261 en.n0 vdd.n17 0.00281593434514725f
CMODEL17262 en.n0 vdd.t32 0.00344746927013035f
CMODEL17263 en.n0 vdd.n18 0.00277971001449539f
CMODEL17264 en.n0 vdd.t34 0.000255569185916716f
CMODEL17265 en.n0 vdd.n19 0.00279919831517609f
CMODEL17266 en.n0 vdd.t33 0.00344746927013035f
CMODEL17267 en.n0 vdd.n20 0.00558620601715891f
CMODEL17268 en.n0 vdd.t48 0.00345405803940471f
CMODEL17269 en.n0 vdd.n21 0.00991612555862566f
CMODEL17270 en.n0 vdd.n22 0.0434561304465399f
CMODEL17271 en.n0 vdd.t47 4.9130395226047e-05f
CMODEL17272 en.n0 vdd.t45 4.86259512662021e-05f
CMODEL17273 en.n0 vdd.n23 0.000555252545185981f
CMODEL17274 en.n0 vdd.t46 0.00132514050464493f
CMODEL17275 en.n0 vdd.n24 0.00142374407790358f
CMODEL17276 en.n0 vdd.t44 0.00132514050464493f
CMODEL17277 en.n0 vdd.n25 0.00224538028684478f
CMODEL17278 en.n0 vdd.t43 0.00132801092838999f
CMODEL17279 en.n0 vdd.n26 0.0120140508571531f
CMODEL17280 en.n0 vdd.n27 0.00803164024365894f
CMODEL17281 en.n0 vdd.n28 0.00181420510937355f
CMODEL17282 en.n0 vdd.t29 0.000151754368774193f
CMODEL17283 en.n0 vdd.t28 0.00119953965778996f
CMODEL17284 en.n0 vdd.n29 0.000270815097604728f
CMODEL17285 en.n0 vdd.n30 8.63960016296837e-05f
CMODEL17286 en.n0 vdd.t38 3.9778651967163e-05f
CMODEL17287 en.n0 vdd.t40 3.9778651967163e-05f
CMODEL17288 en.n0 vdd.t37 0.000803807610900499f
CMODEL17289 en.n0 vdd.t39 0.000803807610900499f
CMODEL17290 en.n0 vdd.n31 0.000260334228337076f
CMODEL17291 en.n0 vdd.n32 0.00314168921422873f
CMODEL17292 en.n0 vdd.n33 0.00159189669797094f
CMODEL17293 en.n0 vdd.t17 0.000151754368774193f
CMODEL17294 en.n0 vdd.t16 0.00119953965778996f
CMODEL17295 en.n0 vdd.n34 0.000270815097604728f
CMODEL17296 en.n0 vdd.n35 8.63960016296837e-05f
CMODEL17297 en.n0 vdd.t1 3.9778651967163e-05f
CMODEL17298 en.n0 vdd.t31 3.9778651967163e-05f
CMODEL17299 en.n0 vdd.t0 0.000803807610900499f
CMODEL17300 en.n0 vdd.t30 0.000803807610900499f
CMODEL17301 en.n0 vdd.n36 0.000260334228337076f
CMODEL17302 en.n0 vdd.n37 0.00304681927689222f
CMODEL17303 en.n0 vdd.n38 0.0017575472537569f
CMODEL17304 en.n0 vdd.t19 0.000151754368774193f
CMODEL17305 en.n0 vdd.t18 0.00119953965778996f
CMODEL17306 en.n0 vdd.n39 0.00148312640351553f
CMODEL17307 en.n0 vdd.t21 0.000151755758809905f
CMODEL17308 en.n0 vdd.t20 0.00119953965778996f
CMODEL17309 en.n0 vdd.n40 0.00148312640351553f
CMODEL17310 en.n0 vdd.t11 0.000151754368774193f
CMODEL17311 en.n0 vdd.t10 0.00119953965778996f
CMODEL17312 en.n0 vdd.n41 0.00638068092828978f
CMODEL17313 en.n0 vdd.n42 0.0122221809042944f
CMODEL17314 en.n0 vdd.n43 0.00148312640351553f
CMODEL17315 en.n0 vdd.t13 0.000151754368774193f
CMODEL17316 en.n0 vdd.t12 0.00119953965778996f
CMODEL17317 en.n0 vdd.n44 0.00148312640351553f
CMODEL17318 en.n0 vdd.t23 0.000151754368774193f
CMODEL17319 en.n0 vdd.t22 0.00119953965778996f
CMODEL17320 en.n0 vdd.n45 0.00183085773720199f
CMODEL17321 en.n0 vdd.n46 0.030220210397921f
CMODEL17322 en.t0 vdd 2.02574741378211e-06f
CMODEL17323 en.t0 vdd.n0 0.000679803135997406f
CMODEL17324 en.t0 vdd.n1 6.29978718394092e-05f
CMODEL17325 en.t0 vdd.t7 5.19331787569852e-06f
CMODEL17326 en.t0 vdd.t6 4.10504870319703e-05f
CMODEL17327 en.t0 vdd.n2 5.64927266157571e-05f
CMODEL17328 en.t0 vdd.t27 5.19331787569852e-06f
CMODEL17329 en.t0 vdd.t26 4.10504870319703e-05f
CMODEL17330 en.t0 vdd.n3 0.000105959420693793f
CMODEL17331 en.t0 vdd.n4 5.64927266157571e-05f
CMODEL17332 en.t0 vdd.t36 5.19331787569852e-06f
CMODEL17333 en.t0 vdd.t35 4.10504870319703e-05f
CMODEL17334 en.t0 vdd.n5 8.06062415358412e-05f
CMODEL17335 en.t0 vdd.t3 8.27264193977656e-06f
CMODEL17336 en.t0 vdd.n6 7.91487084488013e-05f
CMODEL17337 en.t0 vdd.t2 0.000103729832711105f
CMODEL17338 en.t0 vdd.n7 0.000106102129546962f
CMODEL17339 en.t0 vdd.t25 8.27264193977656e-06f
CMODEL17340 en.t0 vdd.n8 4.78065144194947e-05f
CMODEL17341 en.t0 vdd.t24 0.000103729832711105f
CMODEL17342 en.t0 vdd.n9 0.000106102129546962f
CMODEL17343 en.t0 vdd.t5 8.27264193977656e-06f
CMODEL17344 en.t0 vdd.n10 0.000141559571205506f
CMODEL17345 en.t0 vdd.t4 0.000103786916252373f
CMODEL17346 en.t0 vdd.n11 0.00034226720508808f
CMODEL17347 en.t0 vdd.n12 0.000843904046257243f
CMODEL17348 en.t0 vdd.n13 6.39668649524315e-05f
CMODEL17349 en.t0 vdd.t42 5.19331787569852e-06f
CMODEL17350 en.t0 vdd.t41 4.10504870319703e-05f
CMODEL17351 en.t0 vdd.n14 5.75111921312115e-05f
CMODEL17352 en.t0 vdd.t9 5.19331787569852e-06f
CMODEL17353 en.t0 vdd.t8 4.10504870319703e-05f
CMODEL17354 en.t0 vdd.n15 0.000110413839697396f
CMODEL17355 en.t0 vdd.t15 8.74605477535818e-06f
CMODEL17356 en.t0 vdd.n16 6.87947054551624e-05f
CMODEL17357 en.t0 vdd.t14 0.000117978836003922f
CMODEL17358 en.t0 vdd.n17 9.63665315837255e-05f
CMODEL17359 en.t0 vdd.t32 0.000117978836003922f
CMODEL17360 en.t0 vdd.n18 9.5126867345858e-05f
CMODEL17361 en.t0 vdd.t34 8.74605477535818e-06f
CMODEL17362 en.t0 vdd.n19 9.57937933863378e-05f
CMODEL17363 en.t0 vdd.t33 0.000117978836003922f
CMODEL17364 en.t0 vdd.n20 0.000191170401225243f
CMODEL17365 en.t0 vdd.t48 0.00011820431599193f
CMODEL17366 en.t0 vdd.n21 0.000339348333344582f
CMODEL17367 en.t0 vdd.n22 0.00148714993103434f
CMODEL17368 en.t0 vdd.t47 1.68133386754235e-06f
CMODEL17369 en.t0 vdd.t45 1.66407085327059e-06f
CMODEL17370 en.t0 vdd.n23 1.90017789387809e-05f
CMODEL17371 en.t0 vdd.t46 4.53487825502062e-05f
CMODEL17372 en.t0 vdd.n24 4.87231809530214e-05f
CMODEL17373 en.t0 vdd.t44 4.53487825502062e-05f
CMODEL17374 en.t0 vdd.n25 7.68411062930472e-05f
CMODEL17375 en.t0 vdd.t43 4.54470138108047e-05f
CMODEL17376 en.t0 vdd.n26 0.000411143254589549f
CMODEL17377 en.t0 vdd.n27 0.000274857726901018f
CMODEL17378 en.t0 vdd.n28 6.20854865714776e-05f
CMODEL17379 en.t0 vdd.t29 5.19331787569852e-06f
CMODEL17380 en.t0 vdd.t28 4.10504870319703e-05f
CMODEL17381 en.t0 vdd.n29 9.2677983425466e-06f
CMODEL17382 en.t0 vdd.n30 2.95663250604628e-06f
CMODEL17383 en.t0 vdd.t38 1.36129975038576e-06f
CMODEL17384 en.t0 vdd.t40 1.36129975038576e-06f
CMODEL17385 en.t0 vdd.t37 2.75077974231076e-05f
CMODEL17386 en.t0 vdd.t39 2.75077974231076e-05f
CMODEL17387 en.t0 vdd.n31 8.90912342491342e-06f
CMODEL17388 en.t0 vdd.n32 0.000107514471497165f
CMODEL17389 en.t0 vdd.n33 5.44776776090009e-05f
CMODEL17390 en.t0 vdd.t17 5.19331787569852e-06f
CMODEL17391 en.t0 vdd.t16 4.10504870319703e-05f
CMODEL17392 en.t0 vdd.n34 9.2677983425466e-06f
CMODEL17393 en.t0 vdd.n35 2.95663250604628e-06f
CMODEL17394 en.t0 vdd.t1 1.36129975038576e-06f
CMODEL17395 en.t0 vdd.t31 1.36129975038576e-06f
CMODEL17396 en.t0 vdd.t0 2.75077974231076e-05f
CMODEL17397 en.t0 vdd.t30 2.75077974231076e-05f
CMODEL17398 en.t0 vdd.n36 8.90912342491342e-06f
CMODEL17399 en.t0 vdd.n37 0.000104267845087554f
CMODEL17400 en.t0 vdd.n38 6.01465489530786e-05f
CMODEL17401 en.t0 vdd.t19 5.19331787569852e-06f
CMODEL17402 en.t0 vdd.t18 4.10504870319703e-05f
CMODEL17403 en.t0 vdd.n39 5.0755355022158e-05f
CMODEL17404 en.t0 vdd.t21 5.19336544531624e-06f
CMODEL17405 en.t0 vdd.t20 4.10504870319703e-05f
CMODEL17406 en.t0 vdd.n40 5.0755355022158e-05f
CMODEL17407 en.t0 vdd.t11 5.19331787569852e-06f
CMODEL17408 en.t0 vdd.t10 4.10504870319703e-05f
CMODEL17409 en.t0 vdd.n41 0.000218358816234957f
CMODEL17410 en.t0 vdd.n42 0.000418265853451248f
CMODEL17411 en.t0 vdd.n43 5.0755355022158e-05f
CMODEL17412 en.t0 vdd.t13 5.19331787569852e-06f
CMODEL17413 en.t0 vdd.t12 4.10504870319703e-05f
CMODEL17414 en.t0 vdd.n44 5.0755355022158e-05f
CMODEL17415 en.t0 vdd.t23 5.19331787569852e-06f
CMODEL17416 en.t0 vdd.t22 4.10504870319703e-05f
CMODEL17417 en.t0 vdd.n45 6.26553705918019e-05f
CMODEL17418 en.t0 vdd.n46 0.00103419203107372f
CMODEL17419 en.t2 vdd 1.48125415427067e-06f
CMODEL17420 en.t2 vdd.n0 0.000497081330293974f
CMODEL17421 en.t2 vdd.n1 4.60649036190123e-05f
CMODEL17422 en.t2 vdd.t7 3.79742490376147e-06f
CMODEL17423 en.t2 vdd.t6 3.00166763325216e-05f
CMODEL17424 en.t2 vdd.n2 4.13082526559593e-05f
CMODEL17425 en.t2 vdd.t27 3.79742490376147e-06f
CMODEL17426 en.t2 vdd.t26 3.00166763325216e-05f
CMODEL17427 en.t2 vdd.n3 7.74789744362848e-05f
CMODEL17428 en.t2 vdd.n4 4.13082526559593e-05f
CMODEL17429 en.t2 vdd.t36 3.79742490376147e-06f
CMODEL17430 en.t2 vdd.t35 3.00166763325216e-05f
CMODEL17431 en.t2 vdd.n5 5.89403838419277e-05f
CMODEL17432 en.t2 vdd.t3 6.04906868285695e-06f
CMODEL17433 en.t2 vdd.n6 5.78746157577745e-05f
CMODEL17434 en.t2 vdd.t2 7.58486692762242e-05f
CMODEL17435 en.t2 vdd.n7 7.75833250972658e-05f
CMODEL17436 en.t2 vdd.t25 6.04906868285695e-06f
CMODEL17437 en.t2 vdd.n8 3.49567757575793e-05f
CMODEL17438 en.t2 vdd.t24 7.58486692762242e-05f
CMODEL17439 en.t2 vdd.n9 7.75833250972658e-05f
CMODEL17440 en.t2 vdd.t5 6.04906868285695e-06f
CMODEL17441 en.t2 vdd.n10 0.000103510290324618f
CMODEL17442 en.t2 vdd.t4 7.58904095406166e-05f
CMODEL17443 en.t2 vdd.n11 0.000250270451270516f
CMODEL17444 en.t2 vdd.n12 0.000617074155356086f
CMODEL17445 en.t2 vdd.n13 4.67734446070736e-05f
CMODEL17446 en.t2 vdd.t42 3.79742490376147e-06f
CMODEL17447 en.t2 vdd.t41 3.00166763325216e-05f
CMODEL17448 en.t2 vdd.n14 4.20529685398274e-05f
CMODEL17449 en.t2 vdd.t9 3.79742490376147e-06f
CMODEL17450 en.t2 vdd.t8 3.00166763325216e-05f
CMODEL17451 en.t2 vdd.n15 8.073610640104e-05f
CMODEL17452 en.t2 vdd.t15 6.39523460888476e-06f
CMODEL17453 en.t2 vdd.n16 5.03036274680626e-05f
CMODEL17454 en.t2 vdd.t14 8.62677349396456e-05f
CMODEL17455 en.t2 vdd.n17 7.04645230051385e-05f
CMODEL17456 en.t2 vdd.t32 8.62677349396456e-05f
CMODEL17457 en.t2 vdd.n18 6.95580635967497e-05f
CMODEL17458 en.t2 vdd.t34 6.39523460888476e-06f
CMODEL17459 en.t2 vdd.n19 7.00457290190678e-05f
CMODEL17460 en.t2 vdd.t33 8.62677349396456e-05f
CMODEL17461 en.t2 vdd.n20 0.000139786406272534f
CMODEL17462 en.t2 vdd.t48 8.64326089839957e-05f
CMODEL17463 en.t2 vdd.n21 0.000248136132417917f
CMODEL17464 en.t2 vdd.n22 0.00108742432466208f
CMODEL17465 en.t2 vdd.t47 1.229414269059e-06f
CMODEL17466 en.t2 vdd.t45 1.21679131743566e-06f
CMODEL17467 en.t2 vdd.n23 1.38943600767344e-05f
CMODEL17468 en.t2 vdd.t46 3.31596486741636e-05f
CMODEL17469 en.t2 vdd.n24 3.56270548366142e-05f
CMODEL17470 en.t2 vdd.t44 3.31596486741636e-05f
CMODEL17471 en.t2 vdd.n25 5.61872655697109e-05f
CMODEL17472 en.t2 vdd.t43 3.32314767124722e-05f
CMODEL17473 en.t2 vdd.n26 0.000300633558615338f
CMODEL17474 en.t2 vdd.n27 0.000200979720885043f
CMODEL17475 en.t2 vdd.n28 4.53977550598067e-05f
CMODEL17476 en.t2 vdd.t29 3.79742490376147e-06f
CMODEL17477 en.t2 vdd.t28 3.00166763325216e-05f
CMODEL17478 en.t2 vdd.n29 6.77674062543149e-06f
CMODEL17479 en.t2 vdd.n30 2.16193003749471e-06f
CMODEL17480 en.t2 vdd.t38 9.95400955098256e-07f
CMODEL17481 en.t2 vdd.t40 9.95400955098256e-07f
CMODEL17482 en.t2 vdd.t37 2.0114076873849e-05f
CMODEL17483 en.t2 vdd.t39 2.0114076873849e-05f
CMODEL17484 en.t2 vdd.n31 6.51447263083244e-06f
CMODEL17485 en.t2 vdd.n32 7.86160488054417e-05f
CMODEL17486 en.t2 vdd.n33 3.98348213229068e-05f
CMODEL17487 en.t2 vdd.t17 3.79742490376147e-06f
CMODEL17488 en.t2 vdd.t16 3.00166763325216e-05f
CMODEL17489 en.t2 vdd.n34 6.77674062543149e-06f
CMODEL17490 en.t2 vdd.n35 2.16193003749471e-06f
CMODEL17491 en.t2 vdd.t1 9.95400955098256e-07f
CMODEL17492 en.t2 vdd.t31 9.95400955098256e-07f
CMODEL17493 en.t2 vdd.t0 2.0114076873849e-05f
CMODEL17494 en.t2 vdd.t30 2.0114076873849e-05f
CMODEL17495 en.t2 vdd.n36 6.51447263083244e-06f
CMODEL17496 en.t2 vdd.n37 7.62420712681227e-05f
CMODEL17497 en.t2 vdd.n38 4.39799774126108e-05f
CMODEL17498 en.t2 vdd.t19 3.79742490376147e-06f
CMODEL17499 en.t2 vdd.t18 3.00166763325216e-05f
CMODEL17500 en.t2 vdd.n39 3.71130082489844e-05f
CMODEL17501 en.t2 vdd.t21 3.79745968731513e-06f
CMODEL17502 en.t2 vdd.t20 3.00166763325216e-05f
CMODEL17503 en.t2 vdd.n40 3.71130082489844e-05f
CMODEL17504 en.t2 vdd.t11 3.79742490376147e-06f
CMODEL17505 en.t2 vdd.t10 3.00166763325216e-05f
CMODEL17506 en.t2 vdd.n41 0.000159666946367108f
CMODEL17507 en.t2 vdd.n42 0.000305841700104902f
CMODEL17508 en.t2 vdd.n43 3.71130082489844e-05f
CMODEL17509 en.t2 vdd.t13 3.79742490376147e-06f
CMODEL17510 en.t2 vdd.t12 3.00166763325216e-05f
CMODEL17511 en.t2 vdd.n44 3.71130082489844e-05f
CMODEL17512 en.t2 vdd.t23 3.79742490376147e-06f
CMODEL17513 en.t2 vdd.t22 3.00166763325216e-05f
CMODEL17514 en.t2 vdd.n45 4.58144620326577e-05f
CMODEL17515 en.t2 vdd.n46 0.000756215326708221f
CMODEL17516 vdd we 1.26204834395288e-07f
CMODEL17517 vdd we.t1 7.21557484429331e-07f
CMODEL17518 vdd we.t3 7.35144888760685e-07f
CMODEL17519 vdd we.n0 2.51192022898784e-05f
CMODEL17520 vdd we.t0 8.91026138036697e-07f
CMODEL17521 vdd we.n1 6.85969913739032e-05f
CMODEL17522 vdd we.t2 1.34084964529308e-06f
CMODEL17523 vdd.n0 we 4.23519939436924e-05f
CMODEL17524 vdd.n0 we.t1 0.00024214126469087f
CMODEL17525 vdd.n0 we.t3 0.000246700944743614f
CMODEL17526 vdd.n0 we.n0 0.00842953685846311f
CMODEL17527 vdd.n0 we.t0 0.000299011791288486f
CMODEL17528 vdd.n0 we.n1 0.0230198738197586f
CMODEL17529 vdd.n0 we.t2 0.000449964189794736f
CMODEL17530 vdd.n1 we 3.92479137757073e-06f
CMODEL17531 vdd.n1 we.t1 2.24394145190971e-05f
CMODEL17532 vdd.n1 we.t3 2.28619635253914e-05f
CMODEL17533 vdd.n1 we.n0 0.000781171569466048f
CMODEL17534 vdd.n1 we.t0 2.77096493213824e-05f
CMODEL17535 vdd.n1 we.n1 0.0021332691537658f
CMODEL17536 vdd.n1 we.t2 4.16985224986084e-05f
CMODEL17537 vdd.t7 we 3.23545678995061e-07f
CMODEL17538 vdd.t7 we.t1 1.8498245915243e-06f
CMODEL17539 vdd.t7 we.t3 1.88465801118871e-06f
CMODEL17540 vdd.t7 we.n0 6.43969733777207e-05f
CMODEL17541 vdd.t7 we.t0 2.28428378528258e-06f
CMODEL17542 vdd.t7 we.n1 0.000175859033114159f
CMODEL17543 vdd.t7 we.t2 3.43747615529405e-06f
CMODEL17544 vdd.t6 we 2.55746095612342e-06f
CMODEL17545 vdd.t6 we.t1 1.46219049600492e-05f
CMODEL17546 vdd.t6 we.t3 1.48972450945139e-05f
CMODEL17547 vdd.t6 we.n0 0.000509024709022783f
CMODEL17548 vdd.t6 we.t0 1.80560797835758e-05f
CMODEL17549 vdd.t6 we.n1 0.00139007454022571f
CMODEL17550 vdd.t6 we.t2 2.71714679734727e-05f
CMODEL17551 vdd.n2 we 3.51951835582933e-06f
CMODEL17552 vdd.n2 we.t1 2.01223259267624e-05f
CMODEL17553 vdd.n2 we.t3 2.05012426234279e-05f
CMODEL17554 vdd.n2 we.n0 0.000700507979481314f
CMODEL17555 vdd.n2 we.t0 2.48483575401051e-05f
CMODEL17556 vdd.n2 we.n1 0.00191298828964774f
CMODEL17557 vdd.n2 we.t2 3.73927430088402e-05f
CMODEL17558 vdd.t27 we 3.23545678995061e-07f
CMODEL17559 vdd.t27 we.t1 1.8498245915243e-06f
CMODEL17560 vdd.t27 we.t3 1.88465801118871e-06f
CMODEL17561 vdd.t27 we.n0 6.43969733777207e-05f
CMODEL17562 vdd.t27 we.t0 2.28428378528258e-06f
CMODEL17563 vdd.t27 we.n1 0.000175859033114159f
CMODEL17564 vdd.t27 we.t2 3.43747615529405e-06f
CMODEL17565 vdd.t26 we 2.55746095612342e-06f
CMODEL17566 vdd.t26 we.t1 1.46219049600492e-05f
CMODEL17567 vdd.t26 we.t3 1.48972450945139e-05f
CMODEL17568 vdd.t26 we.n0 0.000509024709022783f
CMODEL17569 vdd.t26 we.t0 1.80560797835758e-05f
CMODEL17570 vdd.t26 we.n1 0.00139007454022571f
CMODEL17571 vdd.t26 we.t2 2.71714679734727e-05f
CMODEL17572 vdd.n3 we 6.60131221212516e-06f
CMODEL17573 vdd.n3 we.t1 3.77420267340526e-05f
CMODEL17574 vdd.n3 we.t3 3.8452734042322e-05f
CMODEL17575 vdd.n3 we.n0 0.00131389338316193f
CMODEL17576 vdd.n3 we.t0 4.66063107211998e-05f
CMODEL17577 vdd.n3 we.n1 0.00358805713775809f
CMODEL17578 vdd.n3 we.t2 7.01349293036858e-05f
CMODEL17579 vdd.n4 we 3.51951835582933e-06f
CMODEL17580 vdd.n4 we.t1 2.01223259267624e-05f
CMODEL17581 vdd.n4 we.t3 2.05012426234279e-05f
CMODEL17582 vdd.n4 we.n0 0.000700507979481314f
CMODEL17583 vdd.n4 we.t0 2.48483575401051e-05f
CMODEL17584 vdd.n4 we.n1 0.00191298828964774f
CMODEL17585 vdd.n4 we.t2 3.73927430088402e-05f
CMODEL17586 vdd.t36 we 3.23545678995061e-07f
CMODEL17587 vdd.t36 we.t1 1.8498245915243e-06f
CMODEL17588 vdd.t36 we.t3 1.88465801118871e-06f
CMODEL17589 vdd.t36 we.n0 6.43969733777207e-05f
CMODEL17590 vdd.t36 we.t0 2.28428378528258e-06f
CMODEL17591 vdd.t36 we.n1 0.000175859033114159f
CMODEL17592 vdd.t36 we.t2 3.43747615529405e-06f
CMODEL17593 vdd.t35 we 2.55746095612342e-06f
CMODEL17594 vdd.t35 we.t1 1.46219049600492e-05f
CMODEL17595 vdd.t35 we.t3 1.48972450945139e-05f
CMODEL17596 vdd.t35 we.n0 0.000509024709022783f
CMODEL17597 vdd.t35 we.t0 1.80560797835758e-05f
CMODEL17598 vdd.t35 we.n1 0.00139007454022571f
CMODEL17599 vdd.t35 we.t2 2.71714679734727e-05f
CMODEL17600 vdd.n5 we 5.02179950720729e-06f
CMODEL17601 vdd.n5 we.t1 2.87113963351013e-05f
CMODEL17602 vdd.n5 we.t3 2.92520509043368e-05f
CMODEL17603 vdd.n5 we.n0 0.000999514783131488f
CMODEL17604 vdd.n5 we.t0 3.54547006249117e-05f
CMODEL17605 vdd.n5 we.n1 0.00272953361198841f
CMODEL17606 vdd.n5 we.t2 5.33535670026858e-05f
CMODEL17607 vdd.t3 we 5.15388739443958e-07f
CMODEL17608 vdd.t3 we.t1 2.94665893044641e-06f
CMODEL17609 vdd.t3 we.t3 3.0021464656443e-06f
CMODEL17610 vdd.t3 we.n0 0.000102580491991847f
CMODEL17611 vdd.t3 we.t0 3.63872620486158e-06f
CMODEL17612 vdd.t3 we.n1 0.000280132825998652f
CMODEL17613 vdd.t3 we.t2 5.4756920508053e-06f
CMODEL17614 vdd.n6 we 4.930994641495e-06f
CMODEL17615 vdd.n6 we.t1 2.81922329386177e-05f
CMODEL17616 vdd.n6 we.t3 2.87231113179664e-05f
CMODEL17617 vdd.n6 we.n0 0.00098144142008116f
CMODEL17618 vdd.n6 we.t0 3.48136038777209e-05f
CMODEL17619 vdd.n6 we.n1 0.00268017781179406f
CMODEL17620 vdd.n6 we.t2 5.23888205049417e-05f
CMODEL17621 vdd.t2 we 6.4624080327539e-06f
CMODEL17622 vdd.t2 we.t1 3.69478626220035e-05f
CMODEL17623 vdd.t2 we.t3 3.76436152951554e-05f
CMODEL17624 vdd.t2 we.n0 0.00128624656442274f
CMODEL17625 vdd.t2 we.t0 4.56256251944103e-05f
CMODEL17626 vdd.t2 we.n1 0.00351255758308742f
CMODEL17627 vdd.t2 we.t2 6.86591568379787e-05f
CMODEL17628 vdd.n7 we 6.61020302795861e-06f
CMODEL17629 vdd.n7 we.t1 3.77928586592958e-05f
CMODEL17630 vdd.n7 we.t3 3.85045231663138e-05f
CMODEL17631 vdd.n7 we.n0 0.00131566296831699f
CMODEL17632 vdd.n7 we.t0 4.66690812904417e-05f
CMODEL17633 vdd.n7 we.n1 0.00359288962472229f
CMODEL17634 vdd.n7 we.t2 7.02293888171725e-05f
CMODEL17635 vdd.t25 we 5.15388739443958e-07f
CMODEL17636 vdd.t25 we.t1 2.94665893044641e-06f
CMODEL17637 vdd.t25 we.t3 3.0021464656443e-06f
CMODEL17638 vdd.t25 we.n0 0.000102580491991847f
CMODEL17639 vdd.t25 we.t0 3.63872620486158e-06f
CMODEL17640 vdd.t25 we.n1 0.000280132825998652f
CMODEL17641 vdd.t25 we.t2 5.4756920508053e-06f
CMODEL17642 vdd.n8 we 2.97836403210003e-06f
CMODEL17643 vdd.n8 we.t1 1.70283560769613e-05f
CMODEL17644 vdd.n8 we.t3 1.73490112764551e-05f
CMODEL17645 vdd.n8 we.n0 0.000592799229710109f
CMODEL17646 vdd.n8 we.t0 2.10277222255804e-05f
CMODEL17647 vdd.n8 we.n1 0.00161885091642684f
CMODEL17648 vdd.n8 we.t2 3.16433072879504e-05f
CMODEL17649 vdd.t24 we 6.4624080327539e-06f
CMODEL17650 vdd.t24 we.t1 3.69478626220035e-05f
CMODEL17651 vdd.t24 we.t3 3.76436152951554e-05f
CMODEL17652 vdd.t24 we.n0 0.00128624656442274f
CMODEL17653 vdd.t24 we.t0 4.56256251944103e-05f
CMODEL17654 vdd.t24 we.n1 0.00351255758308742f
CMODEL17655 vdd.t24 we.t2 6.86591568379787e-05f
CMODEL17656 vdd.n9 we 6.61020302795861e-06f
CMODEL17657 vdd.n9 we.t1 3.77928586592958e-05f
CMODEL17658 vdd.n9 we.t3 3.85045231663138e-05f
CMODEL17659 vdd.n9 we.n0 0.00131566296831699f
CMODEL17660 vdd.n9 we.t0 4.66690812904417e-05f
CMODEL17661 vdd.n9 we.n1 0.00359288962472229f
CMODEL17662 vdd.n9 we.t2 7.02293888171725e-05f
CMODEL17663 vdd.t5 we 5.15388739443958e-07f
CMODEL17664 vdd.t5 we.t1 2.94665893044641e-06f
CMODEL17665 vdd.t5 we.t3 3.0021464656443e-06f
CMODEL17666 vdd.t5 we.n0 0.000102580491991847f
CMODEL17667 vdd.t5 we.t0 3.63872620486158e-06f
CMODEL17668 vdd.t5 we.n1 0.000280132825998652f
CMODEL17669 vdd.t5 we.t2 5.4756920508053e-06f
CMODEL17670 vdd.n10 we 8.81921512993748e-06f
CMODEL17671 vdd.n10 we.t1 5.04225588052145e-05f
CMODEL17672 vdd.n10 we.t3 5.13720489133378e-05f
CMODEL17673 vdd.n10 we.n0 0.00175533409594274f
CMODEL17674 vdd.n10 we.t0 6.22650569242883e-05f
CMODEL17675 vdd.n10 we.n1 0.00479356933584712f
CMODEL17676 vdd.n10 we.t2 9.36987995380749e-05f
CMODEL17677 vdd.t4 we 6.46596435908728e-06f
CMODEL17678 vdd.t4 we.t1 3.69681953921007e-05f
CMODEL17679 vdd.t4 we.t3 3.76643309447521e-05f
CMODEL17680 vdd.t4 we.n0 0.00128695439848476f
CMODEL17681 vdd.t4 we.t0 4.5650733422107e-05f
CMODEL17682 vdd.t4 we.n1 0.0035144905778731f
CMODEL17683 vdd.t4 we.t2 6.86969406433734e-05f
CMODEL17684 vdd.n11 we 2.1323377062312e-05f
CMODEL17685 vdd.n11 we.t1 0.000121913256226216f
CMODEL17686 vdd.n11 we.t3 0.000124208963417179f
CMODEL17687 vdd.n11 we.n0 0.00424410225248523f
CMODEL17688 vdd.n11 we.t0 0.000150546422447043f
CMODEL17689 vdd.n11 we.n1 0.0115900434354558f
CMODEL17690 vdd.n11 we.t2 0.000226547918765932f
CMODEL17691 vdd.n12 we 5.2575543070576e-05f
CMODEL17692 vdd.n12 we.t1 0.000300592895527995f
CMODEL17693 vdd.n12 we.t3 0.000306253258421883f
CMODEL17694 vdd.n12 we.n0 0.0104643828282645f
CMODEL17695 vdd.n12 we.t0 0.000371191668859765f
CMODEL17696 vdd.n12 we.n1 0.0285767505798908f
CMODEL17697 vdd.n12 we.t2 0.000558583184353078f
CMODEL17698 vdd.n13 we 3.98516001707986e-06f
CMODEL17699 vdd.n13 we.t1 2.27845632914982e-05f
CMODEL17700 vdd.n13 we.t3 2.32136116772963e-05f
CMODEL17701 vdd.n13 we.n0 0.000793187052668892f
CMODEL17702 vdd.n13 we.t0 2.81358614865351e-05f
CMODEL17703 vdd.n13 we.n1 0.00216608174025271f
CMODEL17704 vdd.n13 we.t2 4.2339902595183e-05f
CMODEL17705 vdd.t42 we 3.23545678995061e-07f
CMODEL17706 vdd.t42 we.t1 1.8498245915243e-06f
CMODEL17707 vdd.t42 we.t3 1.88465801118871e-06f
CMODEL17708 vdd.t42 we.n0 6.43969733777207e-05f
CMODEL17709 vdd.t42 we.t0 2.28428378528258e-06f
CMODEL17710 vdd.t42 we.n1 0.000175859033114159f
CMODEL17711 vdd.t42 we.t2 3.43747615529405e-06f
CMODEL17712 vdd.t41 we 2.55746095612342e-06f
CMODEL17713 vdd.t41 we.t1 1.46219049600492e-05f
CMODEL17714 vdd.t41 we.t3 1.48972450945139e-05f
CMODEL17715 vdd.t41 we.n0 0.000509024709022783f
CMODEL17716 vdd.t41 we.t0 1.80560797835758e-05f
CMODEL17717 vdd.t41 we.n1 0.00139007454022571f
CMODEL17718 vdd.t41 we.t2 2.71714679734727e-05f
CMODEL17719 vdd.n14 we 3.58296914482738e-06f
CMODEL17720 vdd.n14 we.t1 2.04850964332479e-05f
CMODEL17721 vdd.n14 we.t3 2.08708443383167e-05f
CMODEL17722 vdd.n14 we.n0 0.000713136918871246f
CMODEL17723 vdd.n14 we.t0 2.52963301692616e-05f
CMODEL17724 vdd.n14 we.n1 0.00194747613828224f
CMODEL17725 vdd.n14 we.t2 3.80668690700902e-05f
CMODEL17726 vdd.t9 we 3.23545678995061e-07f
CMODEL17727 vdd.t9 we.t1 1.8498245915243e-06f
CMODEL17728 vdd.t9 we.t3 1.88465801118871e-06f
CMODEL17729 vdd.t9 we.n0 6.43969733777207e-05f
CMODEL17730 vdd.t9 we.t0 2.28428378528258e-06f
CMODEL17731 vdd.t9 we.n1 0.000175859033114159f
CMODEL17732 vdd.t9 we.t2 3.43747615529405e-06f
CMODEL17733 vdd.t8 we 2.55746095612342e-06f
CMODEL17734 vdd.t8 we.t1 1.46219049600492e-05f
CMODEL17735 vdd.t8 we.t3 1.48972450945139e-05f
CMODEL17736 vdd.t8 we.n0 0.000509024709022783f
CMODEL17737 vdd.t8 we.t0 1.80560797835758e-05f
CMODEL17738 vdd.t8 we.n1 0.00139007454022571f
CMODEL17739 vdd.t8 we.t2 2.71714679734727e-05f
CMODEL17740 vdd.n15 we 6.87882421033989e-06f
CMODEL17741 vdd.n15 we.t1 3.93286605606429e-05f
CMODEL17742 vdd.n15 we.t3 4.0069245232522e-05f
CMODEL17743 vdd.n15 we.n0 0.00136912803446848f
CMODEL17744 vdd.n15 we.t0 4.85655894224708e-05f
CMODEL17745 vdd.n15 we.n1 0.00373889516420062f
CMODEL17746 vdd.n15 we.t2 7.30833255846502e-05f
CMODEL17747 vdd.t15 we 5.44882539168787e-07f
CMODEL17748 vdd.t15 we.t1 3.11528537045309e-06f
CMODEL17749 vdd.t15 we.t3 3.17394825296671e-06f
CMODEL17750 vdd.t15 we.n0 0.000108450795812893f
CMODEL17751 vdd.t15 we.t0 3.8469571065601e-06f
CMODEL17752 vdd.t15 we.n1 0.000296163796087888f
CMODEL17753 vdd.t15 we.t2 5.78904574354514e-06f
CMODEL17754 vdd.n16 we 4.28593631672545e-06f
CMODEL17755 vdd.n16 we.t1 2.45042073224747e-05f
CMODEL17756 vdd.n16 we.t3 2.49656377419418e-05f
CMODEL17757 vdd.n16 we.n0 0.000853052118464509f
CMODEL17758 vdd.n16 we.t0 3.02593898439891e-05f
CMODEL17759 vdd.n16 we.n1 0.00232956477425156f
CMODEL17760 vdd.n16 we.t2 4.55354679364376e-05f
CMODEL17761 vdd.t14 we 7.35012635767105e-06f
CMODEL17762 vdd.t14 we.t1 4.20232609177835e-05f
CMODEL17763 vdd.t14 we.t3 4.28145866953319e-05f
CMODEL17764 vdd.t14 we.n0 0.00146293374353811f
CMODEL17765 vdd.t14 we.t0 5.18930572979848e-05f
CMODEL17766 vdd.t14 we.n1 0.00399506529817279f
CMODEL17767 vdd.t14 we.t2 7.80906243945795e-05f
CMODEL17768 vdd.n17 we 6.00367157180068e-06f
CMODEL17769 vdd.n17 we.t1 3.43251047192065e-05f
CMODEL17770 vdd.n17 we.t3 3.49714691275874e-05f
CMODEL17771 vdd.n17 we.n0 0.00119494186903892f
CMODEL17772 vdd.n17 we.t0 4.23868730567582e-05f
CMODEL17773 vdd.n17 we.n1 0.00326321736402465f
CMODEL17774 vdd.n17 we.t2 6.37853608071106e-05f
CMODEL17775 vdd.t32 we 7.35012635767105e-06f
CMODEL17776 vdd.t32 we.t1 4.20232609177835e-05f
CMODEL17777 vdd.t32 we.t3 4.28145866953319e-05f
CMODEL17778 vdd.t32 we.n0 0.00146293374353811f
CMODEL17779 vdd.t32 we.t0 5.18930572979848e-05f
CMODEL17780 vdd.t32 we.n1 0.00399506529817279f
CMODEL17781 vdd.t32 we.t2 7.80906243945795e-05f
CMODEL17782 vdd.n18 we 5.92644001826078e-06f
CMODEL17783 vdd.n18 we.t1 3.38835447285942e-05f
CMODEL17784 vdd.n18 we.t3 3.45215942705112e-05f
CMODEL17785 vdd.n18 we.n0 0.00117957007265865f
CMODEL17786 vdd.n18 we.t0 4.18416060452767e-05f
CMODEL17787 vdd.n18 we.n1 0.00322123916059564f
CMODEL17788 vdd.n18 we.t2 6.29648224999562e-05f
CMODEL17789 vdd.t34 we 5.44882539168787e-07f
CMODEL17790 vdd.t34 we.t1 3.11528537045309e-06f
CMODEL17791 vdd.t34 we.t3 3.17394825296671e-06f
CMODEL17792 vdd.t34 we.n0 0.000108450795812893f
CMODEL17793 vdd.t34 we.t0 3.8469571065601e-06f
CMODEL17794 vdd.t34 we.n1 0.000296163796087888f
CMODEL17795 vdd.t34 we.t2 5.78904574354514e-06f
CMODEL17796 vdd.n19 we 5.96798976425577e-06f
CMODEL17797 vdd.n19 we.t1 3.41210992592306e-05f
CMODEL17798 vdd.n19 we.t3 3.47636221099666e-05f
CMODEL17799 vdd.n19 we.n0 0.00118783993394996f
CMODEL17800 vdd.n19 we.t0 4.21349538388673e-05f
CMODEL17801 vdd.n19 we.n1 0.00324382298300833f
CMODEL17802 vdd.n19 we.t2 6.3406263292984e-05f
CMODEL17803 vdd.t33 we 7.35012635767105e-06f
CMODEL17804 vdd.t33 we.t1 4.20232609177835e-05f
CMODEL17805 vdd.t33 we.t3 4.28145866953319e-05f
CMODEL17806 vdd.t33 we.n0 0.00146293374353811f
CMODEL17807 vdd.t33 we.t0 5.18930572979848e-05f
CMODEL17808 vdd.t33 we.n1 0.00399506529817279f
CMODEL17809 vdd.t33 we.t2 7.80906243945795e-05f
CMODEL17810 vdd.n20 we 1.19099887102251e-05f
CMODEL17811 vdd.n20 we.t1 6.80935998570003e-05f
CMODEL17812 vdd.n20 we.t3 6.93758473474636e-05f
CMODEL17813 vdd.n20 we.n0 0.00237050678062996f
CMODEL17814 vdd.n20 we.t0 8.40864083803173e-05f
CMODEL17815 vdd.n20 we.n1 0.00647351899579132f
CMODEL17816 vdd.n20 we.t2 0.000126536389941542f
CMODEL17817 vdd.t48 we 7.36417384668791e-06f
CMODEL17818 vdd.t48 we.t1 4.21035753596677e-05f
CMODEL17819 vdd.t48 we.t3 4.28964135112391e-05f
CMODEL17820 vdd.t48 we.n0 0.0014657296880831f
CMODEL17821 vdd.t48 we.t0 5.19922347973871e-05f
CMODEL17822 vdd.t48 we.n1 0.00400270062757623f
CMODEL17823 vdd.t48 we.t2 7.82398704258885e-05f
CMODEL17824 vdd.n21 we 2.11415302424652e-05f
CMODEL17825 vdd.n21 we.t1 0.000120873573915242f
CMODEL17826 vdd.n21 we.t3 0.000123149703201132f
CMODEL17827 vdd.n21 we.n0 0.00420790833744711f
CMODEL17828 vdd.n21 we.t0 0.000149262555070815f
CMODEL17829 vdd.n21 we.n1 0.0114912029687481f
CMODEL17830 vdd.n21 we.t2 0.000224615906850084f
CMODEL17831 vdd.n22 we 9.26500063582663e-05f
CMODEL17832 vdd.n22 we.t1 0.000529712715369072f
CMODEL17833 vdd.n22 we.t3 0.000539687555902909f
CMODEL17834 vdd.n22 we.n0 0.0184406109561735f
CMODEL17835 vdd.n22 we.t0 0.00065412373266078f
CMODEL17836 vdd.n22 we.n1 0.0503587023223205f
CMODEL17837 vdd.n22 we.t2 0.000984349995442974f
CMODEL17838 vdd.t47 we 1.04747739462841e-07f
CMODEL17839 vdd.t47 we.t1 5.98879716047458e-07f
CMODEL17840 vdd.t47 we.t3 6.10157016918668e-07f
CMODEL17841 vdd.t47 we.n0 2.08484854766611e-05f
CMODEL17842 vdd.t47 we.t0 7.39535646228256e-07f
CMODEL17843 vdd.t47 we.n1 5.69342673345058e-05f
CMODEL17844 vdd.t47 we.t2 1.11288105544431e-06f
CMODEL17845 vdd.t45 we 1.03672247107521e-07f
CMODEL17846 vdd.t45 we.t1 5.92730747490542e-07f
CMODEL17847 vdd.t45 we.t3 6.03892259219783e-07f
CMODEL17848 vdd.t45 we.n0 2.06344246590709e-05f
CMODEL17849 vdd.t45 we.t0 7.31942499702292e-07f
CMODEL17850 vdd.t45 we.n1 5.63496974947366e-05f
CMODEL17851 vdd.t45 we.t2 1.10145460296287e-06f
CMODEL17852 vdd.n23 we 1.18381805543436e-06f
CMODEL17853 vdd.n23 we.t1 6.76830473407863e-06f
CMODEL17854 vdd.n23 we.t3 6.89575638560225e-06f
CMODEL17855 vdd.n23 we.n0 0.000235621443119428f
CMODEL17856 vdd.n23 we.t0 8.35794314160735e-06f
CMODEL17857 vdd.n23 we.n1 0.000643448860941047f
CMODEL17858 vdd.n23 we.t2 1.25773471937615e-05f
CMODEL17859 vdd.t46 we 2.82524640181637e-06f
CMODEL17860 vdd.t46 we.t1 1.61529286604234e-05f
CMODEL17861 vdd.t46 we.t3 1.64570989830669e-05f
CMODEL17862 vdd.t46 we.n0 0.000562323434169697f
CMODEL17863 vdd.t46 we.t0 1.99466874820961e-05f
CMODEL17864 vdd.t46 we.n1 0.00153562582592941f
CMODEL17865 vdd.t46 we.t2 3.00165255466827e-05f
CMODEL17866 vdd.n24 we 3.03547270580356e-06f
CMODEL17867 vdd.n24 we.t1 1.73548664767733e-05f
CMODEL17868 vdd.n24 we.t3 1.76816700828963e-05f
CMODEL17869 vdd.n24 we.n0 0.000604165865022766f
CMODEL17870 vdd.n24 we.t0 2.14309185153443e-05f
CMODEL17871 vdd.n24 we.n1 0.00164989159102688f
CMODEL17872 vdd.n24 we.t2 3.22500522295799e-05f
CMODEL17873 vdd.t44 we 2.82524640181637e-06f
CMODEL17874 vdd.t44 we.t1 1.61529286604234e-05f
CMODEL17875 vdd.t44 we.t3 1.64570989830669e-05f
CMODEL17876 vdd.t44 we.n0 0.000562323434169697f
CMODEL17877 vdd.t44 we.t0 1.99466874820961e-05f
CMODEL17878 vdd.t44 we.n1 0.00153562582592941f
CMODEL17879 vdd.t44 we.t2 3.00165255466827e-05f
CMODEL17880 vdd.n25 we 4.78723014946812e-06f
CMODEL17881 vdd.n25 we.t1 2.73702807074356e-05f
CMODEL17882 vdd.n25 we.t3 2.78856811830176e-05f
CMODEL17883 vdd.n25 we.n0 0.00095282722812387f
CMODEL17884 vdd.n25 we.t0 3.37986037730792e-05f
CMODEL17885 vdd.n25 we.n1 0.00260203649758297f
CMODEL17886 vdd.n25 we.t2 5.0861410171862e-05f
CMODEL17887 vdd.t43 we 2.83136624671506e-06f
CMODEL17888 vdd.t43 we.t1 1.61879179689658e-05f
CMODEL17889 vdd.t43 we.t3 1.64927471634146e-05f
CMODEL17890 vdd.t43 we.n0 0.000563541498618096f
CMODEL17891 vdd.t43 we.t0 1.99898945572577e-05f
CMODEL17892 vdd.t43 we.n1 0.00153895218778976f
CMODEL17893 vdd.t43 we.t2 3.00815451784661e-05f
CMODEL17894 vdd.n26 we 2.56143811440625e-05f
CMODEL17895 vdd.n26 we.t1 0.000146446437746079f
CMODEL17896 vdd.n26 we.t3 0.000149204120959796f
CMODEL17897 vdd.n26 we.n0 0.00509816303448813f
CMODEL17898 vdd.n26 we.t0 0.0001808415915155f
CMODEL17899 vdd.n26 we.n1 0.013922362727277f
CMODEL17900 vdd.n26 we.t2 0.000272137228625057f
CMODEL17901 vdd.n27 we 1.71237409312766e-05f
CMODEL17902 vdd.n27 we.t1 9.79024574581018e-05f
CMODEL17903 vdd.n27 we.t3 9.97460254387853e-05f
CMODEL17904 vdd.n27 we.n0 0.00340822690725916f
CMODEL17905 vdd.n27 we.t0 0.000120896325595162f
CMODEL17906 vdd.n27 we.n1 0.00930738600133678f
CMODEL17907 vdd.n27 we.t2 0.000181929337840405f
CMODEL17908 vdd.n28 we 3.86794942834221e-06f
CMODEL17909 vdd.n28 we.t1 2.21144290770424e-05f
CMODEL17910 vdd.n28 we.t3 2.25308583926699e-05f
CMODEL17911 vdd.n28 we.n0 0.000769858021708043f
CMODEL17912 vdd.n28 we.t0 2.73083361486958e-05f
CMODEL17913 vdd.n28 we.n1 0.00210237345377469f
CMODEL17914 vdd.n28 we.t2 4.10946113423835e-05f
CMODEL17915 vdd.t29 we 3.23545678995061e-07f
CMODEL17916 vdd.t29 we.t1 1.8498245915243e-06f
CMODEL17917 vdd.t29 we.t3 1.88465801118871e-06f
CMODEL17918 vdd.t29 we.n0 6.43969733777207e-05f
CMODEL17919 vdd.t29 we.t0 2.28428378528258e-06f
CMODEL17920 vdd.t29 we.n1 0.000175859033114159f
CMODEL17921 vdd.t29 we.t2 3.43747615529405e-06f
CMODEL17922 vdd.t28 we 2.55746095612342e-06f
CMODEL17923 vdd.t28 we.t1 1.46219049600492e-05f
CMODEL17924 vdd.t28 we.t3 1.48972450945139e-05f
CMODEL17925 vdd.t28 we.n0 0.000509024709022783f
CMODEL17926 vdd.t28 we.t0 1.80560797835758e-05f
CMODEL17927 vdd.t28 we.n1 0.00139007454022571f
CMODEL17928 vdd.t28 we.t2 2.71714679734727e-05f
CMODEL17929 vdd.n29 we 5.77387361855879e-07f
CMODEL17930 vdd.n29 we.t1 3.30112688914213e-06f
CMODEL17931 vdd.n29 we.t3 3.36328929028104e-06f
CMODEL17932 vdd.n29 we.n0 0.000114920399139786f
CMODEL17933 vdd.n29 we.t0 4.07644630770854e-06f
CMODEL17934 vdd.n29 we.n1 0.000313831368428999f
CMODEL17935 vdd.n29 we.t2 6.13438972485247e-06f
CMODEL17936 vdd.n30 we 1.84199329716352e-07f
CMODEL17937 vdd.n30 we.t1 1.05313243839304e-06f
CMODEL17938 vdd.n30 we.t3 1.07296361825562e-06f
CMODEL17939 vdd.n30 we.n0 3.66621472701508e-05f
CMODEL17940 vdd.n30 we.t0 1.30047646884941e-06f
CMODEL17941 vdd.n30 we.n1 0.000100119142758473f
CMODEL17942 vdd.n30 we.t2 1.9570059031163e-06f
CMODEL17943 vdd.t38 we 8.4809492235275e-08f
CMODEL17944 vdd.t38 we.t1 4.84885734894626e-07f
CMODEL17945 vdd.t38 we.t3 4.94016453758598e-07f
CMODEL17946 vdd.t38 we.n0 1.68800727940996e-05f
CMODEL17947 vdd.t38 we.t0 5.98768459998642e-07f
CMODEL17948 vdd.t38 we.n1 4.60970931514924e-05f
CMODEL17949 vdd.t38 we.t2 9.01049299149513e-07f
CMODEL17950 vdd.t40 we 8.4809492235275e-08f
CMODEL17951 vdd.t40 we.t1 4.84885734894626e-07f
CMODEL17952 vdd.t40 we.t3 4.94016453758598e-07f
CMODEL17953 vdd.t40 we.n0 1.68800727940996e-05f
CMODEL17954 vdd.t40 we.t0 5.98768459998642e-07f
CMODEL17955 vdd.t40 we.n1 4.60970931514924e-05f
CMODEL17956 vdd.t40 we.t2 9.01049299149513e-07f
CMODEL17957 vdd.t37 we 1.71374624237128e-06f
CMODEL17958 vdd.t37 we.t1 9.79809080627271e-06f
CMODEL17959 vdd.t37 we.t3 9.98259533201461e-06f
CMODEL17960 vdd.t37 we.n0 0.000341095796701513f
CMODEL17961 vdd.t37 we.t0 1.20993201507025e-05f
CMODEL17962 vdd.t37 we.n1 0.000931484413955153f
CMODEL17963 vdd.t37 we.t2 1.8207512035622e-05f
CMODEL17964 vdd.t39 we 1.71374624237128e-06f
CMODEL17965 vdd.t39 we.t1 9.79809080627271e-06f
CMODEL17966 vdd.t39 we.t3 9.98259533201461e-06f
CMODEL17967 vdd.t39 we.n0 0.000341095796701513f
CMODEL17968 vdd.t39 we.t0 1.20993201507025e-05f
CMODEL17969 vdd.t39 we.n1 0.000931484413955153f
CMODEL17970 vdd.t39 we.t2 1.8207512035622e-05f
CMODEL17971 vdd.n31 we 5.55041778061142e-07f
CMODEL17972 vdd.n31 we.t1 3.17336931703096e-06f
CMODEL17973 vdd.n31 we.t3 3.23312595864811e-06f
CMODEL17974 vdd.n31 we.n0 0.000110472841783406f
CMODEL17975 vdd.n31 we.t0 3.91868294368053e-06f
CMODEL17976 vdd.n31 we.n1 0.000301685717858979f
CMODEL17977 vdd.n31 we.t2 5.89698148095593e-06f
CMODEL17978 vdd.n32 we 6.69819246865698e-06f
CMODEL17979 vdd.n32 we.t1 3.82959252794524e-05f
CMODEL17980 vdd.n32 we.t3 3.90170628634202e-05f
CMODEL17981 vdd.n32 we.n0 0.00133317596273488f
CMODEL17982 vdd.n32 we.t0 4.72903006907059e-05f
CMODEL17983 vdd.n32 we.n1 0.00364071513737798f
CMODEL17984 vdd.n32 we.t2 7.11642231356457e-05f
CMODEL17985 vdd.n33 we 3.39398003626102e-06f
CMODEL17986 vdd.n33 we.t1 1.94045791423288e-05f
CMODEL17987 vdd.n33 we.t3 1.97699801926625e-05f
CMODEL17988 vdd.n33 we.n0 0.000675521437091893f
CMODEL17989 vdd.n33 we.t0 2.39620371024092e-05f
CMODEL17990 vdd.n33 we.n1 0.00184475357371325f
CMODEL17991 vdd.n33 we.t2 3.60589746784081e-05f
CMODEL17992 vdd.t17 we 3.23545678995061e-07f
CMODEL17993 vdd.t17 we.t1 1.8498245915243e-06f
CMODEL17994 vdd.t17 we.t3 1.88465801118871e-06f
CMODEL17995 vdd.t17 we.n0 6.43969733777207e-05f
CMODEL17996 vdd.t17 we.t0 2.28428378528258e-06f
CMODEL17997 vdd.t17 we.n1 0.000175859033114159f
CMODEL17998 vdd.t17 we.t2 3.43747615529405e-06f
CMODEL17999 vdd.t16 we 2.55746095612342e-06f
CMODEL18000 vdd.t16 we.t1 1.46219049600492e-05f
CMODEL18001 vdd.t16 we.t3 1.48972450945139e-05f
CMODEL18002 vdd.t16 we.n0 0.000509024709022783f
CMODEL18003 vdd.t16 we.t0 1.80560797835758e-05f
CMODEL18004 vdd.t16 we.n1 0.00139007454022571f
CMODEL18005 vdd.t16 we.t2 2.71714679734727e-05f
CMODEL18006 vdd.n34 we 5.77387361855879e-07f
CMODEL18007 vdd.n34 we.t1 3.30112688914213e-06f
CMODEL18008 vdd.n34 we.t3 3.36328929028104e-06f
CMODEL18009 vdd.n34 we.n0 0.000114920399139786f
CMODEL18010 vdd.n34 we.t0 4.07644630770854e-06f
CMODEL18011 vdd.n34 we.n1 0.000313831368428999f
CMODEL18012 vdd.n34 we.t2 6.13438972485247e-06f
CMODEL18013 vdd.n35 we 1.84199329716352e-07f
CMODEL18014 vdd.n35 we.t1 1.05313243839304e-06f
CMODEL18015 vdd.n35 we.t3 1.07296361825562e-06f
CMODEL18016 vdd.n35 we.n0 3.66621472701508e-05f
CMODEL18017 vdd.n35 we.t0 1.30047646884941e-06f
CMODEL18018 vdd.n35 we.n1 0.000100119142758473f
CMODEL18019 vdd.n35 we.t2 1.9570059031163e-06f
CMODEL18020 vdd.t1 we 8.4809492235275e-08f
CMODEL18021 vdd.t1 we.t1 4.84885734894626e-07f
CMODEL18022 vdd.t1 we.t3 4.94016453758598e-07f
CMODEL18023 vdd.t1 we.n0 1.68800727940996e-05f
CMODEL18024 vdd.t1 we.t0 5.98768459998642e-07f
CMODEL18025 vdd.t1 we.n1 4.60970931514924e-05f
CMODEL18026 vdd.t1 we.t2 9.01049299149513e-07f
CMODEL18027 vdd.t31 we 8.4809492235275e-08f
CMODEL18028 vdd.t31 we.t1 4.84885734894626e-07f
CMODEL18029 vdd.t31 we.t3 4.94016453758598e-07f
CMODEL18030 vdd.t31 we.n0 1.68800727940996e-05f
CMODEL18031 vdd.t31 we.t0 5.98768459998642e-07f
CMODEL18032 vdd.t31 we.n1 4.60970931514924e-05f
CMODEL18033 vdd.t31 we.t2 9.01049299149513e-07f
CMODEL18034 vdd.t0 we 1.71374624237128e-06f
CMODEL18035 vdd.t0 we.t1 9.79809080627271e-06f
CMODEL18036 vdd.t0 we.t3 9.98259533201461e-06f
CMODEL18037 vdd.t0 we.n0 0.000341095796701513f
CMODEL18038 vdd.t0 we.t0 1.20993201507025e-05f
CMODEL18039 vdd.t0 we.n1 0.000931484413955153f
CMODEL18040 vdd.t0 we.t2 1.8207512035622e-05f
CMODEL18041 vdd.t30 we 1.71374624237128e-06f
CMODEL18042 vdd.t30 we.t1 9.79809080627271e-06f
CMODEL18043 vdd.t30 we.t3 9.98259533201461e-06f
CMODEL18044 vdd.t30 we.n0 0.000341095796701513f
CMODEL18045 vdd.t30 we.t0 1.20993201507025e-05f
CMODEL18046 vdd.t30 we.n1 0.000931484413955153f
CMODEL18047 vdd.t30 we.t2 1.8207512035622e-05f
CMODEL18048 vdd.n36 we 5.55041778061142e-07f
CMODEL18049 vdd.n36 we.t1 3.17336931703096e-06f
CMODEL18050 vdd.n36 we.t3 3.23312595864811e-06f
CMODEL18051 vdd.n36 we.n0 0.000110472841783406f
CMODEL18052 vdd.n36 we.t0 3.91868294368053e-06f
CMODEL18053 vdd.n36 we.n1 0.000301685717858979f
CMODEL18054 vdd.n36 we.t2 5.89698148095593e-06f
CMODEL18055 vdd.n37 we 6.495926408446e-06f
CMODEL18056 vdd.n37 we.t1 3.71394989801702e-05f
CMODEL18057 vdd.n37 we.t3 3.78388602926048e-05f
CMODEL18058 vdd.n37 we.n0 0.00129291790045731f
CMODEL18059 vdd.n37 we.t0 4.58622702404523e-05f
CMODEL18060 vdd.n37 we.n1 0.00353077605894245f
CMODEL18061 vdd.n37 we.t2 6.90152692038236e-05f
CMODEL18062 vdd.n38 we 3.74715287721841e-06f
CMODEL18063 vdd.n38 we.t1 2.14237926527385e-05f
CMODEL18064 vdd.n38 we.t3 2.18272168280335e-05f
CMODEL18065 vdd.n38 we.n0 0.000745815258067986f
CMODEL18066 vdd.n38 we.t0 2.6455493347929e-05f
CMODEL18067 vdd.n38 we.n1 0.00203671606422111f
CMODEL18068 vdd.n38 we.t2 3.98112214191443e-05f
CMODEL18069 vdd.t19 we 3.23545678995061e-07f
CMODEL18070 vdd.t19 we.t1 1.8498245915243e-06f
CMODEL18071 vdd.t19 we.t3 1.88465801118871e-06f
CMODEL18072 vdd.t19 we.n0 6.43969733777207e-05f
CMODEL18073 vdd.t19 we.t0 2.28428378528258e-06f
CMODEL18074 vdd.t19 we.n1 0.000175859033114159f
CMODEL18075 vdd.t19 we.t2 3.43747615529405e-06f
CMODEL18076 vdd.t18 we 2.55746095612342e-06f
CMODEL18077 vdd.t18 we.t1 1.46219049600492e-05f
CMODEL18078 vdd.t18 we.t3 1.48972450945139e-05f
CMODEL18079 vdd.t18 we.n0 0.000509024709022783f
CMODEL18080 vdd.t18 we.t0 1.80560797835758e-05f
CMODEL18081 vdd.t18 we.n1 0.00139007454022571f
CMODEL18082 vdd.t18 we.t2 2.71714679734727e-05f
CMODEL18083 vdd.n39 we 3.16207792327188e-06f
CMODEL18084 vdd.n39 we.t1 1.80787130922361e-05f
CMODEL18085 vdd.n39 we.t3 1.84191472085408e-05f
CMODEL18086 vdd.n39 we.n0 0.000629364757630793f
CMODEL18087 vdd.n39 we.t0 2.23247714213492e-05f
CMODEL18088 vdd.n39 we.n1 0.00171870620539707f
CMODEL18089 vdd.n39 we.t2 3.35951557016304e-05f
CMODEL18090 vdd.t21 we 3.23548642600339e-07f
CMODEL18091 vdd.t21 we.t1 1.84984153549939e-06f
CMODEL18092 vdd.t21 we.t3 1.88467527423005e-06f
CMODEL18093 vdd.t21 we.n0 6.4397563239439e-05f
CMODEL18094 vdd.t21 we.t0 2.28430470880567e-06f
CMODEL18095 vdd.t21 we.n1 0.000175860643943147f
CMODEL18096 vdd.t21 we.t2 3.43750764179855e-06f
CMODEL18097 vdd.t20 we 2.55746095612342e-06f
CMODEL18098 vdd.t20 we.t1 1.46219049600492e-05f
CMODEL18099 vdd.t20 we.t3 1.48972450945139e-05f
CMODEL18100 vdd.t20 we.n0 0.000509024709022783f
CMODEL18101 vdd.t20 we.t0 1.80560797835758e-05f
CMODEL18102 vdd.t20 we.n1 0.00139007454022571f
CMODEL18103 vdd.t20 we.t2 2.71714679734727e-05f
CMODEL18104 vdd.n40 we 3.16207792327188e-06f
CMODEL18105 vdd.n40 we.t1 1.80787130922361e-05f
CMODEL18106 vdd.n40 we.t3 1.84191472085408e-05f
CMODEL18107 vdd.n40 we.n0 0.000629364757630793f
CMODEL18108 vdd.n40 we.t0 2.23247714213492e-05f
CMODEL18109 vdd.n40 we.n1 0.00171870620539707f
CMODEL18110 vdd.n40 we.t2 3.35951557016304e-05f
CMODEL18111 vdd.t11 we 3.23545678995061e-07f
CMODEL18112 vdd.t11 we.t1 1.8498245915243e-06f
CMODEL18113 vdd.t11 we.t3 1.88465801118871e-06f
CMODEL18114 vdd.t11 we.n0 6.43969733777207e-05f
CMODEL18115 vdd.t11 we.t0 2.28428378528258e-06f
CMODEL18116 vdd.t11 we.n1 0.000175859033114159f
CMODEL18117 vdd.t11 we.t2 3.43747615529405e-06f
CMODEL18118 vdd.t10 we 2.55746095612342e-06f
CMODEL18119 vdd.t10 we.t1 1.46219049600492e-05f
CMODEL18120 vdd.t10 we.t3 1.48972450945139e-05f
CMODEL18121 vdd.t10 we.n0 0.000509024709022783f
CMODEL18122 vdd.t10 we.t0 1.80560797835758e-05f
CMODEL18123 vdd.t10 we.n1 0.00139007454022571f
CMODEL18124 vdd.t10 we.t2 2.71714679734727e-05f
CMODEL18125 vdd.n41 we 1.36038373067611e-05f
CMODEL18126 vdd.n41 we.t1 7.77779288145789e-05f
CMODEL18127 vdd.n41 we.t3 7.92425386199844e-05f
CMODEL18128 vdd.n41 we.n0 0.00270764224575446f
CMODEL18129 vdd.n41 we.t0 9.60452479970565e-05f
CMODEL18130 vdd.n41 we.n1 0.00739418830392059f
CMODEL18131 vdd.n41 we.t2 0.000144532501585981f
CMODEL18132 vdd.n42 we 2.605812176231e-05f
CMODEL18133 vdd.n42 we.t1 0.000148983459134966f
CMODEL18134 vdd.n42 we.t3 0.000151788916138231f
CMODEL18135 vdd.n42 we.n0 0.00518648302957708f
CMODEL18136 vdd.n42 we.t0 0.000183974470626364f
CMODEL18137 vdd.n42 we.n1 0.0141635521516602f
CMODEL18138 vdd.n42 we.t2 0.000276851702943178f
CMODEL18139 vdd.n43 we 3.16207792327188e-06f
CMODEL18140 vdd.n43 we.t1 1.80787130922361e-05f
CMODEL18141 vdd.n43 we.t3 1.84191472085408e-05f
CMODEL18142 vdd.n43 we.n0 0.000629364757630793f
CMODEL18143 vdd.n43 we.t0 2.23247714213492e-05f
CMODEL18144 vdd.n43 we.n1 0.00171870620539707f
CMODEL18145 vdd.n43 we.t2 3.35951557016304e-05f
CMODEL18146 vdd.t13 we 3.23545678995061e-07f
CMODEL18147 vdd.t13 we.t1 1.8498245915243e-06f
CMODEL18148 vdd.t13 we.t3 1.88465801118871e-06f
CMODEL18149 vdd.t13 we.n0 6.43969733777207e-05f
CMODEL18150 vdd.t13 we.t0 2.28428378528258e-06f
CMODEL18151 vdd.t13 we.n1 0.000175859033114159f
CMODEL18152 vdd.t13 we.t2 3.43747615529405e-06f
CMODEL18153 vdd.t12 we 2.55746095612342e-06f
CMODEL18154 vdd.t12 we.t1 1.46219049600492e-05f
CMODEL18155 vdd.t12 we.t3 1.48972450945139e-05f
CMODEL18156 vdd.t12 we.n0 0.000509024709022783f
CMODEL18157 vdd.t12 we.t0 1.80560797835758e-05f
CMODEL18158 vdd.t12 we.n1 0.00139007454022571f
CMODEL18159 vdd.t12 we.t2 2.71714679734727e-05f
CMODEL18160 vdd.n44 we 3.16207792327188e-06f
CMODEL18161 vdd.n44 we.t1 1.80787130922361e-05f
CMODEL18162 vdd.n44 we.t3 1.84191472085408e-05f
CMODEL18163 vdd.n44 we.n0 0.000629364757630793f
CMODEL18164 vdd.n44 we.t0 2.23247714213492e-05f
CMODEL18165 vdd.n44 we.n1 0.00171870620539707f
CMODEL18166 vdd.n44 we.t2 3.35951557016304e-05f
CMODEL18167 vdd.t23 we 3.23545678995061e-07f
CMODEL18168 vdd.t23 we.t1 1.8498245915243e-06f
CMODEL18169 vdd.t23 we.t3 1.88465801118871e-06f
CMODEL18170 vdd.t23 we.n0 6.43969733777207e-05f
CMODEL18171 vdd.t23 we.t0 2.28428378528258e-06f
CMODEL18172 vdd.t23 we.n1 0.000175859033114159f
CMODEL18173 vdd.t23 we.t2 3.43747615529405e-06f
CMODEL18174 vdd.t22 we 2.55746095612342e-06f
CMODEL18175 vdd.t22 we.t1 1.46219049600492e-05f
CMODEL18176 vdd.t22 we.t3 1.48972450945139e-05f
CMODEL18177 vdd.t22 we.n0 0.000509024709022783f
CMODEL18178 vdd.t22 we.t0 1.80560797835758e-05f
CMODEL18179 vdd.t22 we.n1 0.00139007454022571f
CMODEL18180 vdd.t22 we.t2 2.71714679734727e-05f
CMODEL18181 vdd.n45 we 3.90345341957046e-06f
CMODEL18182 vdd.n45 we.t1 2.23174178985134e-05f
CMODEL18183 vdd.n45 we.t3 2.27376696278108e-05f
CMODEL18184 vdd.n45 we.n0 0.000776924565093908f
CMODEL18185 vdd.n45 we.t0 2.75589999552018e-05f
CMODEL18186 vdd.n45 we.n1 0.00212167118505172f
CMODEL18187 vdd.n45 we.t2 4.14718196662403e-05f
CMODEL18188 vdd.n46 we 6.44305569028976e-05f
CMODEL18189 vdd.n46 we.t1 0.000368372184647242f
CMODEL18190 vdd.n46 we.t3 0.000375308876352664f
CMODEL18191 vdd.n46 we.n0 0.012823947674019f
CMODEL18192 vdd.n46 we.t0 0.000454889945886937f
CMODEL18193 vdd.n46 we.n1 0.0350203886979535f
CMODEL18194 vdd.n46 we.t2 0.000684535499636227f
CMODEL18195 a_6400_n24000.t0 vdd 0.00010532804080564f
CMODEL18196 a_6400_n24000.t0 vdd.n0 0.0353461305002748f
CMODEL18197 a_6400_n24000.t0 vdd.n1 0.00327555270248686f
CMODEL18198 a_6400_n24000.t0 vdd.t7 0.000270024778709686f
CMODEL18199 a_6400_n24000.t0 vdd.t6 0.00213440596975622f
CMODEL18200 a_6400_n24000.t0 vdd.n2 0.00293731991151703f
CMODEL18201 a_6400_n24000.t0 vdd.t27 0.000270024778709686f
CMODEL18202 a_6400_n24000.t0 vdd.t26 0.00213440596975622f
CMODEL18203 a_6400_n24000.t0 vdd.n3 0.00550932367512733f
CMODEL18204 a_6400_n24000.t0 vdd.n4 0.00293731991151703f
CMODEL18205 a_6400_n24000.t0 vdd.t36 0.000270024778709686f
CMODEL18206 a_6400_n24000.t0 vdd.t35 0.00213440596975622f
CMODEL18207 a_6400_n24000.t0 vdd.n5 0.00419109383525025f
CMODEL18208 a_6400_n24000.t0 vdd.t3 0.000430133175476414f
CMODEL18209 a_6400_n24000.t0 vdd.n6 0.00411530990314556f
CMODEL18210 a_6400_n24000.t0 vdd.t2 0.00539339701397372f
CMODEL18211 a_6400_n24000.t0 vdd.n7 0.00551674377291826f
CMODEL18212 a_6400_n24000.t0 vdd.t25 0.000430133175476414f
CMODEL18213 a_6400_n24000.t0 vdd.n8 0.0024856832926425f
CMODEL18214 a_6400_n24000.t0 vdd.t24 0.00539339701397372f
CMODEL18215 a_6400_n24000.t0 vdd.n9 0.00551674377291826f
CMODEL18216 a_6400_n24000.t0 vdd.t5 0.000430133175476414f
CMODEL18217 a_6400_n24000.t0 vdd.n10 0.0073603412700524f
CMODEL18218 a_6400_n24000.t0 vdd.t4 0.0053963650530901f
CMODEL18219 a_6400_n24000.t0 vdd.n11 0.0177960657378517f
CMODEL18220 a_6400_n24000.t0 vdd.n12 0.0438785009500637f
CMODEL18221 a_6400_n24000.t0 vdd.n13 0.00332593516648727f
CMODEL18222 a_6400_n24000.t0 vdd.t42 0.000270024778709686f
CMODEL18223 a_6400_n24000.t0 vdd.t41 0.00213440596975622f
CMODEL18224 a_6400_n24000.t0 vdd.n14 0.00299027467608495f
CMODEL18225 a_6400_n24000.t0 vdd.t9 0.000270024778709686f
CMODEL18226 a_6400_n24000.t0 vdd.t8 0.00213440596975622f
CMODEL18227 a_6400_n24000.t0 vdd.n15 0.00574092966084152f
CMODEL18228 a_6400_n24000.t0 vdd.t15 0.000454748113214855f
CMODEL18229 a_6400_n24000.t0 vdd.n16 0.00357695707475438f
CMODEL18230 a_6400_n24000.t0 vdd.t14 0.00613426904473865f
CMODEL18231 a_6400_n24000.t0 vdd.n17 0.00501054470162111f
CMODEL18232 a_6400_n24000.t0 vdd.t32 0.00613426904473865f
CMODEL18233 a_6400_n24000.t0 vdd.n18 0.00494608878547724f
CMODEL18234 a_6400_n24000.t0 vdd.t34 0.000454748113214855f
CMODEL18235 a_6400_n24000.t0 vdd.n19 0.00498076537582018f
CMODEL18236 a_6400_n24000.t0 vdd.t33 0.00613426904473865f
CMODEL18237 a_6400_n24000.t0 vdd.n20 0.00993983933243154f
CMODEL18238 a_6400_n24000.t0 vdd.t48 0.00614599279924832f
CMODEL18239 a_6400_n24000.t0 vdd.n21 0.0176443000043679f
CMODEL18240 a_6400_n24000.t0 vdd.n22 0.0773238497328956f
CMODEL18241 a_6400_n24000.t0 vdd.t47 8.74203767970123e-05f
CMODEL18242 a_6400_n24000.t0 vdd.t45 8.6522792300903e-05f
CMODEL18243 a_6400_n24000.t0 vdd.n23 0.000987990967594014f
CMODEL18244 a_6400_n24000.t0 vdd.t46 0.00235789436848713f
CMODEL18245 a_6400_n24000.t0 vdd.n24 0.00253334505411957f
CMODEL18246 a_6400_n24000.t0 vdd.t44 0.00235789436848713f
CMODEL18247 a_6400_n24000.t0 vdd.n25 0.00399532692186624f
CMODEL18248 a_6400_n24000.t0 vdd.t43 0.00236300186913322f
CMODEL18249 a_6400_n24000.t0 vdd.n26 0.0213772522683469f
CMODEL18250 a_6400_n24000.t0 vdd.n27 0.0142911330789879f
CMODEL18251 a_6400_n24000.t0 vdd.n28 0.00322811354394352f
CMODEL18252 a_6400_n24000.t0 vdd.t29 0.000270024778709686f
CMODEL18253 a_6400_n24000.t0 vdd.t28 0.00213440596975622f
CMODEL18254 a_6400_n24000.t0 vdd.n29 0.00048187599073849f
CMODEL18255 a_6400_n24000.t0 vdd.n30 0.000153729091359274f
CMODEL18256 a_6400_n24000.t0 vdd.t38 7.07803128276687e-05f
CMODEL18257 a_6400_n24000.t0 vdd.t40 7.07803128276687e-05f
CMODEL18258 a_6400_n24000.t0 vdd.t37 0.00143025847632453f
CMODEL18259 a_6400_n24000.t0 vdd.t39 0.00143025847632453f
CMODEL18260 a_6400_n24000.t0 vdd.n31 0.000463226811623956f
CMODEL18261 a_6400_n24000.t0 vdd.n32 0.00559017800738915f
CMODEL18262 a_6400_n24000.t0 vdd.n33 0.00283254813070911f
CMODEL18263 a_6400_n24000.t0 vdd.t17 0.000270024778709686f
CMODEL18264 a_6400_n24000.t0 vdd.t16 0.00213440596975622f
CMODEL18265 a_6400_n24000.t0 vdd.n34 0.00048187599073849f
CMODEL18266 a_6400_n24000.t0 vdd.n35 0.000153729091359274f
CMODEL18267 a_6400_n24000.t0 vdd.t1 7.07803128276687e-05f
CMODEL18268 a_6400_n24000.t0 vdd.t31 7.07803128276687e-05f
CMODEL18269 a_6400_n24000.t0 vdd.t0 0.00143025847632453f
CMODEL18270 a_6400_n24000.t0 vdd.t30 0.00143025847632453f
CMODEL18271 a_6400_n24000.t0 vdd.n36 0.000463226811623956f
CMODEL18272 a_6400_n24000.t0 vdd.n37 0.00542137078264552f
CMODEL18273 a_6400_n24000.t0 vdd.n38 0.0031272991486241f
CMODEL18274 a_6400_n24000.t0 vdd.t19 0.000270024778709686f
CMODEL18275 a_6400_n24000.t0 vdd.t18 0.00213440596975622f
CMODEL18276 a_6400_n24000.t0 vdd.n39 0.00263900724666239f
CMODEL18277 a_6400_n24000.t0 vdd.t21 0.000270027252075616f
CMODEL18278 a_6400_n24000.t0 vdd.t20 0.00213440596975622f
CMODEL18279 a_6400_n24000.t0 vdd.n40 0.00263900724666239f
CMODEL18280 a_6400_n24000.t0 vdd.t11 0.000270024778709686f
CMODEL18281 a_6400_n24000.t0 vdd.t10 0.00213440596975622f
CMODEL18282 a_6400_n24000.t0 vdd.n41 0.0113534916299f
CMODEL18283 a_6400_n24000.t0 vdd.n42 0.0217475893490922f
CMODEL18284 a_6400_n24000.t0 vdd.n43 0.00263900724666239f
CMODEL18285 a_6400_n24000.t0 vdd.t13 0.000270024778709686f
CMODEL18286 a_6400_n24000.t0 vdd.t12 0.00213440596975622f
CMODEL18287 a_6400_n24000.t0 vdd.n44 0.00263900724666239f
CMODEL18288 a_6400_n24000.t0 vdd.t23 0.000270024778709686f
CMODEL18289 a_6400_n24000.t0 vdd.t22 0.00213440596975622f
CMODEL18290 a_6400_n24000.t0 vdd.n45 0.00325774446778863f
CMODEL18291 a_6400_n24000.t0 vdd.n46 0.053772459344488f
CMODEL18292 a_6400_n24000.t1 vdd 0.000105305132654918f
CMODEL18293 a_6400_n24000.t1 vdd.n0 0.0353384429511782f
CMODEL18294 a_6400_n24000.t1 vdd.n1 0.00327484029148564f
CMODEL18295 a_6400_n24000.t1 vdd.t7 0.00026996605011014f
CMODEL18296 a_6400_n24000.t1 vdd.t6 0.00213394175060543f
CMODEL18297 a_6400_n24000.t1 vdd.n2 0.00293668106390591f
CMODEL18298 a_6400_n24000.t1 vdd.t27 0.00026996605011014f
CMODEL18299 a_6400_n24000.t1 vdd.t26 0.00213394175060543f
CMODEL18300 a_6400_n24000.t1 vdd.n3 0.00550812543374583f
CMODEL18301 a_6400_n24000.t1 vdd.n4 0.00293668106390591f
CMODEL18302 a_6400_n24000.t1 vdd.t36 0.00026996605011014f
CMODEL18303 a_6400_n24000.t1 vdd.t35 0.00213394175060543f
CMODEL18304 a_6400_n24000.t1 vdd.n5 0.0041901823001212f
CMODEL18305 a_6400_n24000.t1 vdd.t3 0.00043003962436183f
CMODEL18306 a_6400_n24000.t1 vdd.n6 0.00411441485051942f
CMODEL18307 a_6400_n24000.t1 vdd.t2 0.00539222398587261f
CMODEL18308 a_6400_n24000.t1 vdd.n7 0.00551554391771467f
CMODEL18309 a_6400_n24000.t1 vdd.t25 0.00043003962436183f
CMODEL18310 a_6400_n24000.t1 vdd.n8 0.00248514267300238f
CMODEL18311 a_6400_n24000.t1 vdd.t24 0.00539222398587261f
CMODEL18312 a_6400_n24000.t1 vdd.n9 0.00551554391771467f
CMODEL18313 a_6400_n24000.t1 vdd.t5 0.00043003962436183f
CMODEL18314 a_6400_n24000.t1 vdd.n10 0.00735874044461323f
CMODEL18315 a_6400_n24000.t1 vdd.t4 0.00539519137946015f
CMODEL18316 a_6400_n24000.t1 vdd.n11 0.0177921952115126f
CMODEL18317 a_6400_n24000.t1 vdd.n12 0.04386895766695f
CMODEL18318 a_6400_n24000.t1 vdd.n13 0.00332521179763408f
CMODEL18319 a_6400_n24000.t1 vdd.t42 0.00026996605011014f
CMODEL18320 a_6400_n24000.t1 vdd.t41 0.00213394175060543f
CMODEL18321 a_6400_n24000.t1 vdd.n14 0.00298962431116355f
CMODEL18322 a_6400_n24000.t1 vdd.t9 0.00026996605011014f
CMODEL18323 a_6400_n24000.t1 vdd.t8 0.00213394175060543f
CMODEL18324 a_6400_n24000.t1 vdd.n15 0.00573968104669329f
CMODEL18325 a_6400_n24000.t1 vdd.t15 0.000454649208514469f
CMODEL18326 a_6400_n24000.t1 vdd.n16 0.00357617911030002f
CMODEL18327 a_6400_n24000.t1 vdd.t14 0.00613293488188162f
CMODEL18328 a_6400_n24000.t1 vdd.n17 0.00500945494136024f
CMODEL18329 a_6400_n24000.t1 vdd.t32 0.00613293488188162f
CMODEL18330 a_6400_n24000.t1 vdd.n18 0.0049450130439509f
CMODEL18331 a_6400_n24000.t1 vdd.t34 0.000454649208514469f
CMODEL18332 a_6400_n24000.t1 vdd.n19 0.00497968209236529f
CMODEL18333 a_6400_n24000.t1 vdd.t33 0.00613293488188162f
CMODEL18334 a_6400_n24000.t1 vdd.n20 0.00993767748326167f
CMODEL18335 a_6400_n24000.t1 vdd.t48 0.00614465608655239f
CMODEL18336 a_6400_n24000.t1 vdd.n21 0.0176404624860699f
CMODEL18337 a_6400_n24000.t1 vdd.n22 0.0773070323081098f
CMODEL18338 a_6400_n24000.t1 vdd.t47 8.74013634445135e-05f
CMODEL18339 a_6400_n24000.t1 vdd.t45 8.65039741670826e-05f
CMODEL18340 a_6400_n24000.t1 vdd.n23 0.000987776086107332f
CMODEL18341 a_6400_n24000.t1 vdd.t46 0.00235738154209098f
CMODEL18342 a_6400_n24000.t1 vdd.n24 0.00253279406836224f
CMODEL18343 a_6400_n24000.t1 vdd.t44 0.00235738154209098f
CMODEL18344 a_6400_n24000.t1 vdd.n25 0.00399445796474324f
CMODEL18345 a_6400_n24000.t1 vdd.t43 0.00236248793188953f
CMODEL18346 a_6400_n24000.t1 vdd.n26 0.0213726028576749f
CMODEL18347 a_6400_n24000.t1 vdd.n27 0.0142880248522702f
CMODEL18348 a_6400_n24000.t1 vdd.n28 0.00322741145064484f
CMODEL18349 a_6400_n24000.t1 vdd.t29 0.00026996605011014f
CMODEL18350 a_6400_n24000.t1 vdd.t28 0.00213394175060543f
CMODEL18351 a_6400_n24000.t1 vdd.n29 0.000481771185904557f
CMODEL18352 a_6400_n24000.t1 vdd.n30 0.000153695656300877f
CMODEL18353 a_6400_n24000.t1 vdd.t38 7.07649185787867e-05f
CMODEL18354 a_6400_n24000.t1 vdd.t40 7.07649185787867e-05f
CMODEL18355 a_6400_n24000.t1 vdd.t37 0.00142994740458621f
CMODEL18356 a_6400_n24000.t1 vdd.t39 0.00142994740458621f
CMODEL18357 a_6400_n24000.t1 vdd.n31 0.000463126062862867f
CMODEL18358 a_6400_n24000.t1 vdd.n32 0.00558896218072631f
CMODEL18359 a_6400_n24000.t1 vdd.n33 0.00283193207026586f
CMODEL18360 a_6400_n24000.t1 vdd.t17 0.00026996605011014f
CMODEL18361 a_6400_n24000.t1 vdd.t16 0.00213394175060543f
CMODEL18362 a_6400_n24000.t1 vdd.n34 0.000481771185904557f
CMODEL18363 a_6400_n24000.t1 vdd.n35 0.000153695656300877f
CMODEL18364 a_6400_n24000.t1 vdd.t1 7.07649185787867e-05f
CMODEL18365 a_6400_n24000.t1 vdd.t31 7.07649185787867e-05f
CMODEL18366 a_6400_n24000.t1 vdd.t0 0.00142994740458621f
CMODEL18367 a_6400_n24000.t1 vdd.t30 0.00142994740458621f
CMODEL18368 a_6400_n24000.t1 vdd.n36 0.000463126062862867f
CMODEL18369 a_6400_n24000.t1 vdd.n37 0.00542019167043515f
CMODEL18370 a_6400_n24000.t1 vdd.n38 0.00312661898178817f
CMODEL18371 a_6400_n24000.t1 vdd.t19 0.00026996605011014f
CMODEL18372 a_6400_n24000.t1 vdd.t18 0.00213394175060543f
CMODEL18373 a_6400_n24000.t1 vdd.n39 0.00263843328007856f
CMODEL18374 a_6400_n24000.t1 vdd.t21 0.00026996852293813f
CMODEL18375 a_6400_n24000.t1 vdd.t20 0.00213394175060543f
CMODEL18376 a_6400_n24000.t1 vdd.n40 0.00263843328007856f
CMODEL18377 a_6400_n24000.t1 vdd.t11 0.00026996605011014f
CMODEL18378 a_6400_n24000.t1 vdd.t10 0.00213394175060543f
CMODEL18379 a_6400_n24000.t1 vdd.n41 0.0113510223207256f
CMODEL18380 a_6400_n24000.t1 vdd.n42 0.0217428593925598f
CMODEL18381 a_6400_n24000.t1 vdd.n43 0.00263843328007856f
CMODEL18382 a_6400_n24000.t1 vdd.t13 0.00026996605011014f
CMODEL18383 a_6400_n24000.t1 vdd.t12 0.00213394175060543f
CMODEL18384 a_6400_n24000.t1 vdd.n44 0.00263843328007856f
CMODEL18385 a_6400_n24000.t1 vdd.t23 0.00026996605011014f
CMODEL18386 a_6400_n24000.t1 vdd.t22 0.00213394175060543f
CMODEL18387 a_6400_n24000.t1 vdd.n45 0.00325703592996042f
CMODEL18388 a_6400_n24000.t1 vdd.n46 0.0537607641910043f
CMODEL18389 a_0_n11917.t2 a_6400_83.t1 1.56684156208479e-05f
CMODEL18390 a_0_n11917.t2 a_6400_83.n0 0.000176754462311432f
CMODEL18391 a_0_n11917.t2 a_6400_83.t0 3.55710909874126e-06f
CMODEL18392 a_0_n11917.t2 a_6400_83.t3 3.5081529818197e-06f
CMODEL18393 a_0_n11917.t2 a_6400_83.t2 3.5081529818197e-06f
CMODEL18394 a_0_n11917.t2 a_6400_83.n1 0.00129189122678237f
CMODEL18395 a_0_n11917.t1 a_6400_83.t1 2.45110645288289e-05f
CMODEL18396 a_0_n11917.t1 a_6400_83.n0 0.000276507857355364f
CMODEL18397 a_0_n11917.t1 a_6400_83.t0 5.56460415431672e-06f
CMODEL18398 a_0_n11917.t1 a_6400_83.t3 5.48801909492191e-06f
CMODEL18399 a_0_n11917.t1 a_6400_83.t2 5.48801909492191e-06f
CMODEL18400 a_0_n11917.t1 a_6400_83.n1 0.00202098476260467f
CMODEL18401 a_0_n11917.n0 a_6400_83.t1 0.000668372349658621f
CMODEL18402 a_0_n11917.n0 a_6400_83.n0 0.00753986862146723f
CMODEL18403 a_0_n11917.n0 a_6400_83.t0 0.000151736679945761f
CMODEL18404 a_0_n11917.n0 a_6400_83.t3 0.000149648344041938f
CMODEL18405 a_0_n11917.n0 a_6400_83.t2 0.000149648344041938f
CMODEL18406 a_0_n11917.n0 a_6400_83.n1 0.0551085952557317f
CMODEL18407 a_0_n11917.t6 a_6400_83.t1 4.17606270933556e-05f
CMODEL18408 a_0_n11917.t6 a_6400_83.n0 0.000471099144054672f
CMODEL18409 a_0_n11917.t6 a_6400_83.t0 9.48067183035813e-06f
CMODEL18410 a_0_n11917.t6 a_6400_83.t3 9.35019034504574e-06f
CMODEL18411 a_0_n11917.t6 a_6400_83.t2 9.35019034504574e-06f
CMODEL18412 a_0_n11917.t6 a_6400_83.n1 0.00344324461849556f
CMODEL18413 a_0_n11917.n1 a_6400_83.t1 0.0025911480931381f
CMODEL18414 a_0_n11917.n1 a_6400_83.n0 0.0292305871285749f
CMODEL18415 a_0_n11917.n1 a_6400_83.t0 0.000588253252997946f
CMODEL18416 a_0_n11917.n1 a_6400_83.t3 0.000580157185592128f
CMODEL18417 a_0_n11917.n1 a_6400_83.t2 0.000580157185592128f
CMODEL18418 a_0_n11917.n1 a_6400_83.n1 0.213645180841701f
CMODEL18419 a_0_n11917.t4 a_6400_83.t1 3.31526727860126e-06f
CMODEL18420 a_0_n11917.t4 a_6400_83.n0 3.73993324805702e-05f
CMODEL18421 a_0_n11917.t4 a_6400_83.t0 7.52645812240301e-07f
CMODEL18422 a_0_n11917.t4 a_6400_83.t3 7.4228722740027e-07f
CMODEL18423 a_0_n11917.t4 a_6400_83.t2 7.4228722740027e-07f
CMODEL18424 a_0_n11917.t4 a_6400_83.n1 0.000273350210723594f
CMODEL18425 a_0_n11917.t5 a_6400_83.t1 3.34719437853753e-06f
CMODEL18426 a_0_n11917.t5 a_6400_83.n0 3.77595001911389e-05f
CMODEL18427 a_0_n11917.t5 a_6400_83.t0 7.59894035700026e-07f
CMODEL18428 a_0_n11917.t5 a_6400_83.t3 7.49435694325877e-07f
CMODEL18429 a_0_n11917.t5 a_6400_83.t2 7.49435694325877e-07f
CMODEL18430 a_0_n11917.t5 a_6400_83.n1 0.000275982661974721f
CMODEL18431 a_0_n11917.n2 a_6400_83.t1 0.000841775552668396f
CMODEL18432 a_0_n11917.n2 a_6400_83.n0 0.00949601981459049f
CMODEL18433 a_0_n11917.n2 a_6400_83.t0 0.000191103398706797f
CMODEL18434 a_0_n11917.n2 a_6400_83.t3 0.000188473262809501f
CMODEL18435 a_0_n11917.n2 a_6400_83.t2 0.000188473262809501f
CMODEL18436 a_0_n11917.n2 a_6400_83.n1 0.0694060253268499f
CMODEL18437 a_0_n11917.t0 a_6400_83.t1 6.63460639078381e-06f
CMODEL18438 a_0_n11917.t0 a_6400_83.n0 7.48445990729676e-05f
CMODEL18439 a_0_n11917.t0 a_6400_83.t0 1.50621602913204e-06f
CMODEL18440 a_0_n11917.t0 a_6400_83.t3 1.48548613696837e-06f
CMODEL18441 a_0_n11917.t0 a_6400_83.t2 1.48548613696837e-06f
CMODEL18442 a_0_n11917.t0 a_6400_83.n1 0.000547036152015478f
CMODEL18443 a_0_n11917.t3 a_6400_83.t1 1.19148718741909e-05f
CMODEL18444 a_0_n11917.t3 a_6400_83.n0 0.000134410959129143f
CMODEL18445 a_0_n11917.t3 a_6400_83.t0 2.70496393378969e-06f
CMODEL18446 a_0_n11917.t3 a_6400_83.t3 2.66773580079313e-06f
CMODEL18447 a_0_n11917.t3 a_6400_83.t2 2.66773580079313e-06f
CMODEL18448 a_0_n11917.t3 a_6400_83.n1 0.000982404272070885f
CMODEL18449 a_0_n11917.n3 a_6400_83.t1 0.00184732712012976f
CMODEL18450 a_0_n11917.n3 a_6400_83.n0 0.0208395870860996f
CMODEL18451 a_0_n11917.n3 a_6400_83.t0 0.000419387911731273f
CMODEL18452 a_0_n11917.n3 a_6400_83.t3 0.000413615920186378f
CMODEL18453 a_0_n11917.n3 a_6400_83.t2 0.000413615920186378f
CMODEL18454 a_0_n11917.n3 a_6400_83.n1 0.152315700402874f
CMODEL18455 a_0_n11917.n4 a_6400_83.t1 0.0033649632715875f
CMODEL18456 a_0_n11917.n4 a_6400_83.n0 0.0379599500140768f
CMODEL18457 a_0_n11917.n4 a_6400_83.t0 0.000763928003950045f
CMODEL18458 a_0_n11917.n4 a_6400_83.t3 0.000753414143496828f
CMODEL18459 a_0_n11917.n4 a_6400_83.t2 0.000753414143496828f
CMODEL18460 a_0_n11917.n4 a_6400_83.n1 0.277447741635382f
CMODEL18461 a_1600_n11917.t5 sa_en 2.73797206354539e-06f
CMODEL18462 a_1600_n11917.t5 sa_en.t1 1.85520251395251e-05f
CMODEL18463 a_1600_n11917.t5 sa_en.n0 0.000812876881264355f
CMODEL18464 a_1600_n11917.t5 sa_en.t0 2.27279593059505e-05f
CMODEL18465 a_1600_n11917.t4 sa_en 4.35207919490298e-06f
CMODEL18466 a_1600_n11917.t4 sa_en.t1 2.94889358836243e-05f
CMODEL18467 a_1600_n11917.t4 sa_en.n0 0.00129208935696271f
CMODEL18468 a_1600_n11917.t4 sa_en.t0 3.6126693969969e-05f
CMODEL18469 a_1600_n11917.n0 sa_en 7.57647625749873e-05f
CMODEL18470 a_1600_n11917.n0 sa_en.t1 0.00051336892684041f
CMODEL18471 a_1600_n11917.n0 sa_en.n0 0.0224938101932058f
CMODEL18472 a_1600_n11917.n0 sa_en.t0 0.000628924766456357f
CMODEL18473 a_1600_n11917.t6 sa_en 8.03452402842711e-06f
CMODEL18474 a_1600_n11917.t6 sa_en.t1 5.44405451553387e-05f
CMODEL18475 a_1600_n11917.t6 sa_en.n0 0.00238537088147433f
CMODEL18476 a_1600_n11917.t6 sa_en.t0 6.66947400932623e-05f
CMODEL18477 a_1600_n11917.n1 sa_en 0.000446352519498595f
CMODEL18478 a_1600_n11917.n1 sa_en.t1 0.00302440747043475f
CMODEL18479 a_1600_n11917.n1 sa_en.n0 0.132517657439017f
CMODEL18480 a_1600_n11917.n1 sa_en.t0 0.00370518093823654f
CMODEL18481 a_1600_n11917.t2 sa_en 5.61188518155723e-07f
CMODEL18482 a_1600_n11917.t2 sa_en.t1 3.80251633515809e-06f
CMODEL18483 a_1600_n11917.t2 sa_en.n0 0.000166611331983091f
CMODEL18484 a_1600_n11917.t2 sa_en.t0 4.65843679467421e-06f
CMODEL18485 a_1600_n11917.t3 sa_en 5.61188518155723e-07f
CMODEL18486 a_1600_n11917.t3 sa_en.t1 3.80251633515809e-06f
CMODEL18487 a_1600_n11917.t3 sa_en.n0 0.000166611331983091f
CMODEL18488 a_1600_n11917.t3 sa_en.t0 4.65843679467421e-06f
CMODEL18489 a_1600_n11917.n2 sa_en 0.000136133051510761f
CMODEL18490 a_1600_n11917.n2 sa_en.t1 0.00092241401129477f
CMODEL18491 a_1600_n11917.n2 sa_en.n0 0.0404165593295993f
CMODEL18492 a_1600_n11917.n2 sa_en.t0 0.00113004310603703f
CMODEL18493 a_1600_n11917.t1 sa_en 1.98262125522908e-06f
CMODEL18494 a_1600_n11917.t1 sa_en.t1 1.34338987087905e-05f
CMODEL18495 a_1600_n11917.t1 sa_en.n0 0.000588620681758217f
CMODEL18496 a_1600_n11917.t1 sa_en.t0 1.64577775675366e-05f
CMODEL18497 a_1600_n11917.t0 sa_en 2.72502606994881e-06f
CMODEL18498 a_1600_n11917.t0 sa_en.t1 1.84643053260699e-05f
CMODEL18499 a_1600_n11917.t0 sa_en.n0 0.000809033343545409f
CMODEL18500 a_1600_n11917.t0 sa_en.t0 2.26204943615284e-05f
CMODEL18501 a_1600_n11917.n3 sa_en 0.000377737129096253f
CMODEL18502 a_1600_n11917.n3 sa_en.t1 0.00255948145287187f
CMODEL18503 a_1600_n11917.n3 sa_en.n0 0.112146425277952f
CMODEL18504 a_1600_n11917.n3 sa_en.t0 0.00313560324911762f
CMODEL18505 a_1600_n11917.n4 sa_en 0.000553822134095436f
CMODEL18506 a_1600_n11917.n4 sa_en.t1 0.00375260299086455f
CMODEL18507 a_1600_n11917.n4 sa_en.n0 0.164424325263465f
CMODEL18508 a_1600_n11917.n4 sa_en.t0 0.00459728829744032f
CMODEL18509 a_3200_83.t0 vdd 5.81236475452374e-08f
CMODEL18510 a_3200_83.t0 vdd.n0 1.95052145238036e-05f
CMODEL18511 a_3200_83.t0 vdd.n1 1.80756301303007e-06f
CMODEL18512 a_3200_83.t0 vdd.t7 1.49008990826706e-07f
CMODEL18513 a_3200_83.t0 vdd.t6 1.17783886755746e-06f
CMODEL18514 a_3200_83.t0 vdd.n2 1.62091448733643e-06f
CMODEL18515 a_3200_83.t0 vdd.t27 1.49008990826706e-07f
CMODEL18516 a_3200_83.t0 vdd.t26 1.17783886755746e-06f
CMODEL18517 a_3200_83.t0 vdd.n3 3.04023491803701e-06f
CMODEL18518 a_3200_83.t0 vdd.n4 1.62091448733643e-06f
CMODEL18519 a_3200_83.t0 vdd.t36 1.49008990826706e-07f
CMODEL18520 a_3200_83.t0 vdd.t35 1.17783886755746e-06f
CMODEL18521 a_3200_83.t0 vdd.n5 2.31279020330984e-06f
CMODEL18522 a_3200_83.t0 vdd.t3 2.37362329135493e-07f
CMODEL18523 a_3200_83.t0 vdd.n6 2.2709700144451e-06f
CMODEL18524 a_3200_83.t0 vdd.t2 2.97626258604973e-06f
CMODEL18525 a_3200_83.t0 vdd.n7 3.04432958404858e-06f
CMODEL18526 a_3200_83.t0 vdd.t25 2.37362329135493e-07f
CMODEL18527 a_3200_83.t0 vdd.n8 1.37168581609943e-06f
CMODEL18528 a_3200_83.t0 vdd.t24 2.97626258604973e-06f
CMODEL18529 a_3200_83.t0 vdd.n9 3.04432958404858e-06f
CMODEL18530 a_3200_83.t0 vdd.t5 2.37362329135493e-07f
CMODEL18531 a_3200_83.t0 vdd.n10 4.06169030128095e-06f
CMODEL18532 a_3200_83.t0 vdd.t4 2.97790045245436e-06f
CMODEL18533 a_3200_83.t0 vdd.n11 9.82048317548677e-06f
CMODEL18534 a_3200_83.t0 vdd.n12 2.42136709704973e-05f
CMODEL18535 a_3200_83.t0 vdd.n13 1.83536579524857e-06f
CMODEL18536 a_3200_83.t0 vdd.t42 1.49008990826706e-07f
CMODEL18537 a_3200_83.t0 vdd.t41 1.17783886755746e-06f
CMODEL18538 a_3200_83.t0 vdd.n14 1.65013675377227e-06f
CMODEL18539 a_3200_83.t0 vdd.t9 1.49008990826706e-07f
CMODEL18540 a_3200_83.t0 vdd.t8 1.17783886755746e-06f
CMODEL18541 a_3200_83.t0 vdd.n15 3.16804309314453e-06f
CMODEL18542 a_3200_83.t0 vdd.t15 2.5094570118451e-07f
CMODEL18543 a_3200_83.t0 vdd.n16 1.97388834641967e-06f
CMODEL18544 a_3200_83.t0 vdd.t14 3.38510133841736e-06f
CMODEL18545 a_3200_83.t0 vdd.n17 2.7649914687399e-06f
CMODEL18546 a_3200_83.t0 vdd.t32 3.38510133841736e-06f
CMODEL18547 a_3200_83.t0 vdd.n18 2.72942246998615e-06f
CMODEL18548 a_3200_83.t0 vdd.t34 2.5094570118451e-07f
CMODEL18549 a_3200_83.t0 vdd.n19 2.74855820914684e-06f
CMODEL18550 a_3200_83.t0 vdd.t33 3.38510133841736e-06f
CMODEL18551 a_3200_83.t0 vdd.n20 5.48514634465322e-06f
CMODEL18552 a_3200_83.t0 vdd.t48 3.39157091071563e-06f
CMODEL18553 a_3200_83.t0 vdd.n21 9.73673360666365e-06f
CMODEL18554 a_3200_83.t0 vdd.n22 4.26699685510061e-05f
CMODEL18555 a_3200_83.t0 vdd.t47 4.82415805929367e-08f
CMODEL18556 a_3200_83.t0 vdd.t45 4.77462624944049e-08f
CMODEL18557 a_3200_83.t0 vdd.n23 5.45207509216651e-07f
CMODEL18558 a_3200_83.t0 vdd.t46 1.30116747804833e-06f
CMODEL18559 a_3200_83.t0 vdd.n24 1.39798722078036e-06f
CMODEL18560 a_3200_83.t0 vdd.t44 1.30116747804833e-06f
CMODEL18561 a_3200_83.t0 vdd.n25 2.20475926503816e-06f
CMODEL18562 a_3200_83.t0 vdd.t43 1.30398597315296e-06f
CMODEL18563 a_3200_83.t0 vdd.n26 1.1796705481533e-05f
CMODEL18564 a_3200_83.t0 vdd.n27 7.88634038715265e-06f
CMODEL18565 a_3200_83.t0 vdd.n28 1.78138444832949e-06f
CMODEL18566 a_3200_83.t0 vdd.t29 1.49008990826706e-07f
CMODEL18567 a_3200_83.t0 vdd.t28 1.17783886755746e-06f
CMODEL18568 a_3200_83.t0 vdd.n29 2.65915800122776e-07f
CMODEL18569 a_3200_83.t0 vdd.n30 8.48330174497809e-08f
CMODEL18570 a_3200_83.t0 vdd.t38 3.90590190842777e-08f
CMODEL18571 a_3200_83.t0 vdd.t40 3.90590190842777e-08f
CMODEL18572 a_3200_83.t0 vdd.t37 7.89265982169716e-07f
CMODEL18573 a_3200_83.t0 vdd.t39 7.89265982169716e-07f
CMODEL18574 a_3200_83.t0 vdd.n31 2.55624539547054e-07f
CMODEL18575 a_3200_83.t0 vdd.n32 3.08485312867632e-06f
CMODEL18576 a_3200_83.t0 vdd.n33 1.56309780325319e-06f
CMODEL18577 a_3200_83.t0 vdd.t17 1.49008990826706e-07f
CMODEL18578 a_3200_83.t0 vdd.t16 1.17783886755746e-06f
CMODEL18579 a_3200_83.t0 vdd.n34 2.65915800122776e-07f
CMODEL18580 a_3200_83.t0 vdd.n35 8.48330174497809e-08f
CMODEL18581 a_3200_83.t0 vdd.t1 3.90590190842777e-08f
CMODEL18582 a_3200_83.t0 vdd.t31 3.90590190842777e-08f
CMODEL18583 a_3200_83.t0 vdd.t0 7.89265982169716e-07f
CMODEL18584 a_3200_83.t0 vdd.t30 7.89265982169716e-07f
CMODEL18585 a_3200_83.t0 vdd.n36 2.55624539547054e-07f
CMODEL18586 a_3200_83.t0 vdd.n37 2.99169947691331e-06f
CMODEL18587 a_3200_83.t0 vdd.n38 1.72575158611909e-06f
CMODEL18588 a_3200_83.t0 vdd.t19 1.49008990826706e-07f
CMODEL18589 a_3200_83.t0 vdd.t18 1.17783886755746e-06f
CMODEL18590 a_3200_83.t0 vdd.n39 1.45629526478498e-06f
CMODEL18591 a_3200_83.t0 vdd.t21 1.49010355715377e-07f
CMODEL18592 a_3200_83.t0 vdd.t20 1.17783886755746e-06f
CMODEL18593 a_3200_83.t0 vdd.n40 1.45629526478498e-06f
CMODEL18594 a_3200_83.t0 vdd.t11 1.49008990826706e-07f
CMODEL18595 a_3200_83.t0 vdd.t10 1.17783886755746e-06f
CMODEL18596 a_3200_83.t0 vdd.n41 6.26524846428906e-06f
CMODEL18597 a_3200_83.t0 vdd.n42 1.200107026217e-05f
CMODEL18598 a_3200_83.t0 vdd.n43 1.45629526478498e-06f
CMODEL18599 a_3200_83.t0 vdd.t13 1.49008990826706e-07f
CMODEL18600 a_3200_83.t0 vdd.t12 1.17783886755746e-06f
CMODEL18601 a_3200_83.t0 vdd.n44 1.45629526478498e-06f
CMODEL18602 a_3200_83.t0 vdd.t23 1.49008990826706e-07f
CMODEL18603 a_3200_83.t0 vdd.t22 1.17783886755746e-06f
CMODEL18604 a_3200_83.t0 vdd.n45 1.79773581460232e-06f
CMODEL18605 a_3200_83.t0 vdd.n46 2.96734986303123e-05f
CMODEL18606 a_3200_83.t1 vdd 5.81236475452374e-08f
CMODEL18607 a_3200_83.t1 vdd.n0 1.95052145238036e-05f
CMODEL18608 a_3200_83.t1 vdd.n1 1.80756301303007e-06f
CMODEL18609 a_3200_83.t1 vdd.t7 1.49008990826706e-07f
CMODEL18610 a_3200_83.t1 vdd.t6 1.17783886755746e-06f
CMODEL18611 a_3200_83.t1 vdd.n2 1.62091448733643e-06f
CMODEL18612 a_3200_83.t1 vdd.t27 1.49008990826706e-07f
CMODEL18613 a_3200_83.t1 vdd.t26 1.17783886755746e-06f
CMODEL18614 a_3200_83.t1 vdd.n3 3.04023491803701e-06f
CMODEL18615 a_3200_83.t1 vdd.n4 1.62091448733643e-06f
CMODEL18616 a_3200_83.t1 vdd.t36 1.49008990826706e-07f
CMODEL18617 a_3200_83.t1 vdd.t35 1.17783886755746e-06f
CMODEL18618 a_3200_83.t1 vdd.n5 2.31279020330984e-06f
CMODEL18619 a_3200_83.t1 vdd.t3 2.37362329135493e-07f
CMODEL18620 a_3200_83.t1 vdd.n6 2.2709700144451e-06f
CMODEL18621 a_3200_83.t1 vdd.t2 2.97626258604973e-06f
CMODEL18622 a_3200_83.t1 vdd.n7 3.04432958404858e-06f
CMODEL18623 a_3200_83.t1 vdd.t25 2.37362329135493e-07f
CMODEL18624 a_3200_83.t1 vdd.n8 1.37168581609943e-06f
CMODEL18625 a_3200_83.t1 vdd.t24 2.97626258604973e-06f
CMODEL18626 a_3200_83.t1 vdd.n9 3.04432958404858e-06f
CMODEL18627 a_3200_83.t1 vdd.t5 2.37362329135493e-07f
CMODEL18628 a_3200_83.t1 vdd.n10 4.06169030128095e-06f
CMODEL18629 a_3200_83.t1 vdd.t4 2.97790045245436e-06f
CMODEL18630 a_3200_83.t1 vdd.n11 9.82048317548677e-06f
CMODEL18631 a_3200_83.t1 vdd.n12 2.42136709704973e-05f
CMODEL18632 a_3200_83.t1 vdd.n13 1.83536579524857e-06f
CMODEL18633 a_3200_83.t1 vdd.t42 1.49008990826706e-07f
CMODEL18634 a_3200_83.t1 vdd.t41 1.17783886755746e-06f
CMODEL18635 a_3200_83.t1 vdd.n14 1.65013675377227e-06f
CMODEL18636 a_3200_83.t1 vdd.t9 1.49008990826706e-07f
CMODEL18637 a_3200_83.t1 vdd.t8 1.17783886755746e-06f
CMODEL18638 a_3200_83.t1 vdd.n15 3.16804309314453e-06f
CMODEL18639 a_3200_83.t1 vdd.t15 2.5094570118451e-07f
CMODEL18640 a_3200_83.t1 vdd.n16 1.97388834641967e-06f
CMODEL18641 a_3200_83.t1 vdd.t14 3.38510133841736e-06f
CMODEL18642 a_3200_83.t1 vdd.n17 2.7649914687399e-06f
CMODEL18643 a_3200_83.t1 vdd.t32 3.38510133841736e-06f
CMODEL18644 a_3200_83.t1 vdd.n18 2.72942246998615e-06f
CMODEL18645 a_3200_83.t1 vdd.t34 2.5094570118451e-07f
CMODEL18646 a_3200_83.t1 vdd.n19 2.74855820914684e-06f
CMODEL18647 a_3200_83.t1 vdd.t33 3.38510133841736e-06f
CMODEL18648 a_3200_83.t1 vdd.n20 5.48514634465322e-06f
CMODEL18649 a_3200_83.t1 vdd.t48 3.39157091071563e-06f
CMODEL18650 a_3200_83.t1 vdd.n21 9.73673360666365e-06f
CMODEL18651 a_3200_83.t1 vdd.n22 4.26699685510061e-05f
CMODEL18652 a_3200_83.t1 vdd.t47 4.82415805929367e-08f
CMODEL18653 a_3200_83.t1 vdd.t45 4.77462624944049e-08f
CMODEL18654 a_3200_83.t1 vdd.n23 5.45207509216651e-07f
CMODEL18655 a_3200_83.t1 vdd.t46 1.30116747804833e-06f
CMODEL18656 a_3200_83.t1 vdd.n24 1.39798722078036e-06f
CMODEL18657 a_3200_83.t1 vdd.t44 1.30116747804833e-06f
CMODEL18658 a_3200_83.t1 vdd.n25 2.20475926503816e-06f
CMODEL18659 a_3200_83.t1 vdd.t43 1.30398597315296e-06f
CMODEL18660 a_3200_83.t1 vdd.n26 1.1796705481533e-05f
CMODEL18661 a_3200_83.t1 vdd.n27 7.88634038715265e-06f
CMODEL18662 a_3200_83.t1 vdd.n28 1.78138444832949e-06f
CMODEL18663 a_3200_83.t1 vdd.t29 1.49008990826706e-07f
CMODEL18664 a_3200_83.t1 vdd.t28 1.17783886755746e-06f
CMODEL18665 a_3200_83.t1 vdd.n29 2.65915800122776e-07f
CMODEL18666 a_3200_83.t1 vdd.n30 8.48330174497809e-08f
CMODEL18667 a_3200_83.t1 vdd.t38 3.90590190842777e-08f
CMODEL18668 a_3200_83.t1 vdd.t40 3.90590190842777e-08f
CMODEL18669 a_3200_83.t1 vdd.t37 7.89265982169716e-07f
CMODEL18670 a_3200_83.t1 vdd.t39 7.89265982169716e-07f
CMODEL18671 a_3200_83.t1 vdd.n31 2.55624539547054e-07f
CMODEL18672 a_3200_83.t1 vdd.n32 3.08485312867632e-06f
CMODEL18673 a_3200_83.t1 vdd.n33 1.56309780325319e-06f
CMODEL18674 a_3200_83.t1 vdd.t17 1.49008990826706e-07f
CMODEL18675 a_3200_83.t1 vdd.t16 1.17783886755746e-06f
CMODEL18676 a_3200_83.t1 vdd.n34 2.65915800122776e-07f
CMODEL18677 a_3200_83.t1 vdd.n35 8.48330174497809e-08f
CMODEL18678 a_3200_83.t1 vdd.t1 3.90590190842777e-08f
CMODEL18679 a_3200_83.t1 vdd.t31 3.90590190842777e-08f
CMODEL18680 a_3200_83.t1 vdd.t0 7.89265982169716e-07f
CMODEL18681 a_3200_83.t1 vdd.t30 7.89265982169716e-07f
CMODEL18682 a_3200_83.t1 vdd.n36 2.55624539547054e-07f
CMODEL18683 a_3200_83.t1 vdd.n37 2.99169947691331e-06f
CMODEL18684 a_3200_83.t1 vdd.n38 1.72575158611909e-06f
CMODEL18685 a_3200_83.t1 vdd.t19 1.49008990826706e-07f
CMODEL18686 a_3200_83.t1 vdd.t18 1.17783886755746e-06f
CMODEL18687 a_3200_83.t1 vdd.n39 1.45629526478498e-06f
CMODEL18688 a_3200_83.t1 vdd.t21 1.49010355715377e-07f
CMODEL18689 a_3200_83.t1 vdd.t20 1.17783886755746e-06f
CMODEL18690 a_3200_83.t1 vdd.n40 1.45629526478498e-06f
CMODEL18691 a_3200_83.t1 vdd.t11 1.49008990826706e-07f
CMODEL18692 a_3200_83.t1 vdd.t10 1.17783886755746e-06f
CMODEL18693 a_3200_83.t1 vdd.n41 6.26524846428906e-06f
CMODEL18694 a_3200_83.t1 vdd.n42 1.200107026217e-05f
CMODEL18695 a_3200_83.t1 vdd.n43 1.45629526478498e-06f
CMODEL18696 a_3200_83.t1 vdd.t13 1.49008990826706e-07f
CMODEL18697 a_3200_83.t1 vdd.t12 1.17783886755746e-06f
CMODEL18698 a_3200_83.t1 vdd.n44 1.45629526478498e-06f
CMODEL18699 a_3200_83.t1 vdd.t23 1.49008990826706e-07f
CMODEL18700 a_3200_83.t1 vdd.t22 1.17783886755746e-06f
CMODEL18701 a_3200_83.t1 vdd.n45 1.79773581460232e-06f
CMODEL18702 a_3200_83.t1 vdd.n46 2.96734986303123e-05f
CMODEL18703 a_6400_83.t1 en 2.76183459371185e-06f
CMODEL18704 a_6400_83.t1 en.t3 2.094154763625e-05f
CMODEL18705 a_6400_83.t1 en.t1 1.88495800996546e-05f
CMODEL18706 a_6400_83.t1 en.n0 0.000753275233131866f
CMODEL18707 a_6400_83.t1 en.t0 2.57784850949869e-05f
CMODEL18708 a_6400_83.t1 en.t2 1.88495800996546e-05f
CMODEL18709 a_6400_83.n0 en 3.11560913635142e-05f
CMODEL18710 a_6400_83.n0 en.t3 0.000236240350140412f
CMODEL18711 a_6400_83.n0 en.t1 0.000212640989104067f
CMODEL18712 a_6400_83.n0 en.n0 0.00849765298717143f
CMODEL18713 a_6400_83.n0 en.t0 0.000290805553185926f
CMODEL18714 a_6400_83.n0 en.t2 0.000212640989104067f
CMODEL18715 a_6400_83.t0 en 6.27003214635121e-07f
CMODEL18716 a_6400_83.t0 en.t3 4.75423753372436e-06f
CMODEL18717 a_6400_83.t0 en.t1 4.27931033375951e-06f
CMODEL18718 a_6400_83.t0 en.n0 0.000171011686852662f
CMODEL18719 a_6400_83.t0 en.t0 5.85233926020796e-06f
CMODEL18720 a_6400_83.t0 en.t2 4.27931033375951e-06f
CMODEL18721 a_6400_83.t3 en 6.18373835599e-07f
CMODEL18722 a_6400_83.t3 en.t3 4.68880546456004e-06f
CMODEL18723 a_6400_83.t3 en.t1 4.2204146374995e-06f
CMODEL18724 a_6400_83.t3 en.n0 0.000168658071064078f
CMODEL18725 a_6400_83.t3 en.t0 5.77179413293346e-06f
CMODEL18726 a_6400_83.t3 en.t2 4.2204146374995e-06f
CMODEL18727 a_6400_83.t2 en 6.18373835599e-07f
CMODEL18728 a_6400_83.t2 en.t3 4.68880546456004e-06f
CMODEL18729 a_6400_83.t2 en.t1 4.2204146374995e-06f
CMODEL18730 a_6400_83.t2 en.n0 0.000168658071064078f
CMODEL18731 a_6400_83.t2 en.t0 5.77179413293346e-06f
CMODEL18732 a_6400_83.t2 en.t2 4.2204146374995e-06f
CMODEL18733 a_6400_83.n1 en 0.000227718613533134f
CMODEL18734 a_6400_83.n1 en.t3 0.00172667117857908f
CMODEL18735 a_6400_83.n1 en.t1 0.0015541844018277f
CMODEL18736 a_6400_83.n1 en.n0 0.0621090025044178f
CMODEL18737 a_6400_83.n1 en.t0 0.00212548604401595f
CMODEL18738 a_6400_83.n1 en.t2 0.0015541844018277f
CMODEL18739 sa_en vdd 2.50812204869314e-07f
CMODEL18740 sa_en vdd.n0 8.41679087217749e-05f
CMODEL18741 sa_en vdd.n1 7.79990389256706e-06f
CMODEL18742 sa_en vdd.t7 6.42996011313815e-07f
CMODEL18743 sa_en vdd.t6 5.08255031866235e-06f
CMODEL18744 sa_en vdd.n2 6.99448767658725e-06f
CMODEL18745 sa_en vdd.t27 6.42996011313815e-07f
CMODEL18746 sa_en vdd.t26 5.08255031866235e-06f
CMODEL18747 sa_en vdd.n3 1.31190669429352e-05f
CMODEL18748 sa_en vdd.n4 6.99448767658725e-06f
CMODEL18749 sa_en vdd.t36 6.42996011313815e-07f
CMODEL18750 sa_en vdd.t35 5.08255031866235e-06f
CMODEL18751 sa_en vdd.n5 9.98003454344156e-06f
CMODEL18752 sa_en vdd.t3 1.02425383880209e-06f
CMODEL18753 sa_en vdd.n6 9.79957419347724e-06f
CMODEL18754 sa_en vdd.t2 1.28430167927124e-05f
CMODEL18755 sa_en vdd.n7 1.31367360372529e-05f
CMODEL18756 sa_en vdd.t25 1.02425383880209e-06f
CMODEL18757 sa_en vdd.n8 5.9190288024526e-06f
CMODEL18758 sa_en vdd.t24 1.28430167927124e-05f
CMODEL18759 sa_en vdd.n9 1.31367360372529e-05f
CMODEL18760 sa_en vdd.t5 1.02425383880209e-06f
CMODEL18761 sa_en vdd.n10 1.75267992114177e-05f
CMODEL18762 sa_en vdd.t4 1.28500844304395e-05f
CMODEL18763 sa_en vdd.n11 4.23768490476931e-05f
CMODEL18764 sa_en vdd.n12 0.000104485600277647f
CMODEL18765 sa_en vdd.n13 7.91987704298395e-06f
CMODEL18766 sa_en vdd.t42 6.42996011313815e-07f
CMODEL18767 sa_en vdd.t41 5.08255031866235e-06f
CMODEL18768 sa_en vdd.n14 7.12058611303425e-06f
CMODEL18769 sa_en vdd.t9 6.42996011313815e-07f
CMODEL18770 sa_en vdd.t8 5.08255031866235e-06f
CMODEL18771 sa_en vdd.n15 1.36705782735703e-05f
CMODEL18772 sa_en vdd.t15 1.08286811435186e-06f
CMODEL18773 sa_en vdd.n16 8.51762250375025e-06f
CMODEL18774 sa_en vdd.t14 1.46072169633493e-05f
CMODEL18775 sa_en vdd.n17 1.19313504229024e-05f
CMODEL18776 sa_en vdd.t32 1.46072169633493e-05f
CMODEL18777 sa_en vdd.n18 1.1777864890263e-05f
CMODEL18778 sa_en vdd.t34 1.08286811435186e-06f
CMODEL18779 sa_en vdd.n19 1.18604384577076e-05f
CMODEL18780 sa_en vdd.t33 1.46072169633493e-05f
CMODEL18781 sa_en vdd.n20 2.36692242630265e-05f
CMODEL18782 sa_en vdd.t48 1.46351341323712e-05f
CMODEL18783 sa_en vdd.n21 4.2015457171916e-05f
CMODEL18784 sa_en vdd.n22 0.000184127276005049f
CMODEL18785 sa_en vdd.t47 2.08169612643084e-07f
CMODEL18786 sa_en vdd.t45 2.06032241200458e-07f
CMODEL18787 sa_en vdd.n23 2.35265168779209e-06f
CMODEL18788 sa_en vdd.t46 5.61473166011393e-06f
CMODEL18789 sa_en vdd.n24 6.03252328495301e-06f
CMODEL18790 sa_en vdd.t44 5.61473166011393e-06f
CMODEL18791 sa_en vdd.n25 9.51386493836074e-06f
CMODEL18792 sa_en vdd.t43 5.62689388670258e-06f
CMODEL18793 sa_en vdd.n26 5.09045429352044e-05f
CMODEL18794 sa_en vdd.n27 3.40307345527863e-05f
CMODEL18795 sa_en vdd.n28 7.68693948289618e-06f
CMODEL18796 sa_en vdd.t29 6.42996011313815e-07f
CMODEL18797 sa_en vdd.t28 5.08255031866235e-06f
CMODEL18798 sa_en vdd.n29 1.14746632317721e-06f
CMODEL18799 sa_en vdd.n30 3.66067118133573e-07f
CMODEL18800 sa_en vdd.t38 1.68545490696119e-07f
CMODEL18801 sa_en vdd.t40 1.68545490696119e-07f
CMODEL18802 sa_en vdd.t37 3.40580038550165e-06f
CMODEL18803 sa_en vdd.t39 3.40580038550165e-06f
CMODEL18804 sa_en vdd.n31 1.10305799945883e-06f
CMODEL18805 sa_en vdd.n32 1.33116011740166e-05f
CMODEL18806 sa_en vdd.n33 6.74500006482195e-06f
CMODEL18807 sa_en vdd.t17 6.42996011313815e-07f
CMODEL18808 sa_en vdd.t16 5.08255031866235e-06f
CMODEL18809 sa_en vdd.n34 1.14746632317721e-06f
CMODEL18810 sa_en vdd.n35 3.66067118133573e-07f
CMODEL18811 sa_en vdd.t1 1.68545490696119e-07f
CMODEL18812 sa_en vdd.t31 1.68545490696119e-07f
CMODEL18813 sa_en vdd.t0 3.40580038550165e-06f
CMODEL18814 sa_en vdd.t30 3.40580038550165e-06f
CMODEL18815 sa_en vdd.n36 1.10305799945883e-06f
CMODEL18816 sa_en vdd.n37 1.290962927829e-05f
CMODEL18817 sa_en vdd.n38 7.4468753881003e-06f
CMODEL18818 sa_en vdd.t19 6.42996011313815e-07f
CMODEL18819 sa_en vdd.t18 5.08255031866235e-06f
CMODEL18820 sa_en vdd.n39 6.28413118803643e-06f
CMODEL18821 sa_en vdd.t21 6.43001901011921e-07f
CMODEL18822 sa_en vdd.t20 5.08255031866235e-06f
CMODEL18823 sa_en vdd.n40 6.28413118803643e-06f
CMODEL18824 sa_en vdd.t11 6.42996011313815e-07f
CMODEL18825 sa_en vdd.t10 5.08255031866235e-06f
CMODEL18826 sa_en vdd.n41 2.70354812154452e-05f
CMODEL18827 sa_en vdd.n42 5.17864074325986e-05f
CMODEL18828 sa_en vdd.n43 6.28413118803643e-06f
CMODEL18829 sa_en vdd.t13 6.42996011313815e-07f
CMODEL18830 sa_en vdd.t12 5.08255031866235e-06f
CMODEL18831 sa_en vdd.n44 6.28413118803643e-06f
CMODEL18832 sa_en vdd.t23 6.42996011313815e-07f
CMODEL18833 sa_en vdd.t22 5.08255031866235e-06f
CMODEL18834 sa_en vdd.n45 7.75749806620469e-06f
CMODEL18835 sa_en vdd.n46 0.00012804557064081f
CMODEL18836 sa_en.t1 vdd 1.69946011940312e-06f
CMODEL18837 sa_en.t1 vdd.n0 0.000570307191712419f
CMODEL18838 sa_en.t1 vdd.n1 5.2850799694942e-05f
CMODEL18839 sa_en.t1 vdd.t7 4.35682975927141e-06f
CMODEL18840 sa_en.t1 vdd.t6 3.44384818750224e-05f
CMODEL18841 sa_en.t1 vdd.n2 4.73934387212547e-05f
CMODEL18842 sa_en.t1 vdd.t27 4.35682975927141e-06f
CMODEL18843 sa_en.t1 vdd.t26 3.44384818750224e-05f
CMODEL18844 sa_en.t1 vdd.n3 8.88925285151703e-05f
CMODEL18845 sa_en.t1 vdd.n4 4.73934387212547e-05f
CMODEL18846 sa_en.t1 vdd.t36 4.35682975927141e-06f
CMODEL18847 sa_en.t1 vdd.t35 3.44384818750224e-05f
CMODEL18848 sa_en.t1 vdd.n5 6.76229879071548e-05f
CMODEL18849 sa_en.t1 vdd.t3 6.94016685550322e-06f
CMODEL18850 sa_en.t1 vdd.n6 6.64002197884434e-05f
CMODEL18851 sa_en.t1 vdd.t2 8.70220604432382e-05f
CMODEL18852 sa_en.t1 vdd.n7 8.90122512421982e-05f
CMODEL18853 sa_en.t1 vdd.t25 6.94016685550322e-06f
CMODEL18854 sa_en.t1 vdd.n8 4.01063154028247e-05f
CMODEL18855 sa_en.t1 vdd.t24 8.70220604432382e-05f
CMODEL18856 sa_en.t1 vdd.n9 8.90122512421982e-05f
CMODEL18857 sa_en.t1 vdd.t5 6.94016685550322e-06f
CMODEL18858 sa_en.t1 vdd.n10 0.000118758559999544f
CMODEL18859 sa_en.t1 vdd.t4 8.70699495340493e-05f
CMODEL18860 sa_en.t1 vdd.n11 0.000287138199594575f
CMODEL18861 sa_en.t1 vdd.n12 0.000707976355521773f
CMODEL18862 sa_en.t1 vdd.n13 5.36637170114613e-05f
CMODEL18863 sa_en.t1 vdd.t42 4.35682975927141e-06f
CMODEL18864 sa_en.t1 vdd.t41 3.44384818750224e-05f
CMODEL18865 sa_en.t1 vdd.n14 4.8247859916477e-05f
CMODEL18866 sa_en.t1 vdd.t9 4.35682975927141e-06f
CMODEL18867 sa_en.t1 vdd.t8 3.44384818750224e-05f
CMODEL18868 sa_en.t1 vdd.n15 9.26294739014671e-05f
CMODEL18869 sa_en.t1 vdd.t15 7.33732704863036e-06f
CMODEL18870 sa_en.t1 vdd.n16 5.77139368668143e-05f
CMODEL18871 sa_en.t1 vdd.t14 9.89759756612148e-05f
CMODEL18872 sa_en.t1 vdd.n17 8.08447668043566e-05f
CMODEL18873 sa_en.t1 vdd.t32 9.89759756612148e-05f
CMODEL18874 sa_en.t1 vdd.n18 7.98047753822411e-05f
CMODEL18875 sa_en.t1 vdd.t34 7.33732704863036e-06f
CMODEL18876 sa_en.t1 vdd.n19 8.0364279593218e-05f
CMODEL18877 sa_en.t1 vdd.t33 9.89759756612148e-05f
CMODEL18878 sa_en.t1 vdd.n20 0.000160378569747758f
CMODEL18879 sa_en.t1 vdd.t48 9.91651375699188e-05f
CMODEL18880 sa_en.t1 vdd.n21 0.000284689470751098f
CMODEL18881 sa_en.t1 vdd.n22 0.00124761457532722f
CMODEL18882 sa_en.t1 vdd.t47 1.41052128999405e-06f
CMODEL18883 sa_en.t1 vdd.t45 1.39603883078124e-06f
CMODEL18884 sa_en.t1 vdd.n23 1.59411609189129e-05f
CMODEL18885 sa_en.t1 vdd.t46 3.80444505979506e-05f
CMODEL18886 sa_en.t1 vdd.n24 4.08753343861004e-05f
CMODEL18887 sa_en.t1 vdd.t44 3.80444505979506e-05f
CMODEL18888 sa_en.t1 vdd.n25 6.44643032924027e-05f
CMODEL18889 sa_en.t1 vdd.t43 3.81268597417215e-05f
CMODEL18890 sa_en.t1 vdd.n26 0.000344920378415795f
CMODEL18891 sa_en.t1 vdd.n27 0.000230586371331445f
CMODEL18892 sa_en.t1 vdd.n28 5.20853723934771e-05f
CMODEL18893 sa_en.t1 vdd.t29 4.35682975927141e-06f
CMODEL18894 sa_en.t1 vdd.t28 3.44384818750224e-05f
CMODEL18895 sa_en.t1 vdd.n29 7.77503333864427e-06f
CMODEL18896 sa_en.t1 vdd.n30 2.48040747704838e-06f
CMODEL18897 sa_en.t1 vdd.t38 1.1420350931189e-06f
CMODEL18898 sa_en.t1 vdd.t40 1.1420350931189e-06f
CMODEL18899 sa_en.t1 vdd.t37 2.30771143406824e-05f
CMODEL18900 sa_en.t1 vdd.t39 2.30771143406824e-05f
CMODEL18901 sa_en.t1 vdd.n31 7.47413021804755e-06f
CMODEL18902 sa_en.t1 vdd.n32 9.01971071640174e-05f
CMODEL18903 sa_en.t1 vdd.n33 4.57029538156211e-05f
CMODEL18904 sa_en.t1 vdd.t17 4.35682975927141e-06f
CMODEL18905 sa_en.t1 vdd.t16 3.44384818750224e-05f
CMODEL18906 sa_en.t1 vdd.n34 7.77503333864427e-06f
CMODEL18907 sa_en.t1 vdd.n35 2.48040747704838e-06f
CMODEL18908 sa_en.t1 vdd.t1 1.1420350931189e-06f
CMODEL18909 sa_en.t1 vdd.t31 1.1420350931189e-06f
CMODEL18910 sa_en.t1 vdd.t0 2.30771143406824e-05f
CMODEL18911 sa_en.t1 vdd.t30 2.30771143406824e-05f
CMODEL18912 sa_en.t1 vdd.n36 7.47413021804755e-06f
CMODEL18913 sa_en.t1 vdd.n37 8.74734151241333e-05f
CMODEL18914 sa_en.t1 vdd.n38 5.04587396089251e-05f
CMODEL18915 sa_en.t1 vdd.t19 4.35682975927141e-06f
CMODEL18916 sa_en.t1 vdd.t18 3.44384818750224e-05f
CMODEL18917 sa_en.t1 vdd.n39 4.25801860189774e-05f
CMODEL18918 sa_en.t1 vdd.t21 4.35686966684709e-06f
CMODEL18919 sa_en.t1 vdd.t20 3.44384818750224e-05f
CMODEL18920 sa_en.t1 vdd.n40 4.25801860189774e-05f
CMODEL18921 sa_en.t1 vdd.t11 4.35682975927141e-06f
CMODEL18922 sa_en.t1 vdd.t10 3.44384818750224e-05f
CMODEL18923 sa_en.t1 vdd.n41 0.000183187744625352f
CMODEL18924 sa_en.t1 vdd.n42 0.000350895739721756f
CMODEL18925 sa_en.t1 vdd.n43 4.25801860189774e-05f
CMODEL18926 sa_en.t1 vdd.t13 4.35682975927141e-06f
CMODEL18927 sa_en.t1 vdd.t12 3.44384818750224e-05f
CMODEL18928 sa_en.t1 vdd.n44 4.25801860189774e-05f
CMODEL18929 sa_en.t1 vdd.t23 4.35682975927141e-06f
CMODEL18930 sa_en.t1 vdd.t22 3.44384818750224e-05f
CMODEL18931 sa_en.t1 vdd.n45 5.25634651500751e-05f
CMODEL18932 sa_en.t1 vdd.n46 0.000867614639740742f
CMODEL18933 sa_en.n0 vdd 7.44636680526251e-05f
CMODEL18934 sa_en.n0 vdd.n0 0.0249886213432379f
CMODEL18935 sa_en.n0 vdd.n1 0.00231571447889118f
CMODEL18936 sa_en.n0 vdd.t7 0.000190899169243306f
CMODEL18937 sa_en.n0 vdd.t6 0.00150895902369199f
CMODEL18938 sa_en.n0 vdd.n2 0.00207659435400662f
CMODEL18939 sa_en.n0 vdd.t27 0.000190899169243306f
CMODEL18940 sa_en.n0 vdd.t26 0.00150895902369199f
CMODEL18941 sa_en.n0 vdd.n3 0.00389492148720557f
CMODEL18942 sa_en.n0 vdd.n4 0.00207659435400662f
CMODEL18943 sa_en.n0 vdd.t36 0.000190899169243306f
CMODEL18944 sa_en.n0 vdd.t35 0.00150895902369199f
CMODEL18945 sa_en.n0 vdd.n5 0.00296297375075421f
CMODEL18946 sa_en.n0 vdd.t3 0.000304090855123761f
CMODEL18947 sa_en.n0 vdd.n6 0.00290939685403418f
CMODEL18948 sa_en.n0 vdd.t2 0.0038129649222817f
CMODEL18949 sa_en.n0 vdd.n7 0.00390016726691053f
CMODEL18950 sa_en.n0 vdd.t25 0.000304090855123761f
CMODEL18951 sa_en.n0 vdd.n8 0.00175730122929788f
CMODEL18952 sa_en.n0 vdd.t24 0.0038129649222817f
CMODEL18953 sa_en.n0 vdd.n9 0.00390016726691053f
CMODEL18954 sa_en.n0 vdd.t5 0.000304090855123761f
CMODEL18955 sa_en.n0 vdd.n10 0.00520353369240562f
CMODEL18956 sa_en.n0 vdd.t4 0.00381506323416368f
CMODEL18957 sa_en.n0 vdd.n11 0.0125812682131949f
CMODEL18958 sa_en.n0 vdd.n12 0.0310207434259747f
CMODEL18959 sa_en.n0 vdd.n13 0.00235133332308788f
CMODEL18960 sa_en.n0 vdd.t42 0.000190899169243306f
CMODEL18961 sa_en.n0 vdd.t41 0.00150895902369199f
CMODEL18962 sa_en.n0 vdd.n14 0.00211403173516771f
CMODEL18963 sa_en.n0 vdd.t9 0.000190899169243306f
CMODEL18964 sa_en.n0 vdd.t8 0.00150895902369199f
CMODEL18965 sa_en.n0 vdd.n15 0.00405865975772981f
CMODEL18966 sa_en.n0 vdd.t15 0.000321492854998358f
CMODEL18967 sa_en.n0 vdd.n16 0.00252879805050678f
CMODEL18968 sa_en.n0 vdd.t14 0.0043367385398899f
CMODEL18969 sa_en.n0 vdd.n17 0.00354230017543796f
CMODEL18970 sa_en.n0 vdd.t32 0.0043367385398899f
CMODEL18971 sa_en.n0 vdd.n18 0.00349673183573418f
CMODEL18972 sa_en.n0 vdd.t34 0.000321492854998358f
CMODEL18973 sa_en.n0 vdd.n19 0.00352124711288871f
CMODEL18974 sa_en.n0 vdd.t33 0.0043367385398899f
CMODEL18975 sa_en.n0 vdd.n20 0.00702715906310658f
CMODEL18976 sa_en.n0 vdd.t48 0.00434502687182374f
CMODEL18977 sa_en.n0 vdd.n21 0.012473974532296f
CMODEL18978 sa_en.n0 vdd.n22 0.0546655708681246f
CMODEL18979 sa_en.n0 vdd.t47 6.18035033126676e-05f
CMODEL18980 sa_en.n0 vdd.t45 6.11689388276906e-05f
CMODEL18981 sa_en.n0 vdd.n23 0.000698479064902283f
CMODEL18982 sa_en.n0 vdd.t46 0.00166695841121901f
CMODEL18983 sa_en.n0 vdd.n24 0.00179099662093609f
CMODEL18984 sa_en.n0 vdd.t44 0.00166695841121901f
CMODEL18985 sa_en.n0 vdd.n25 0.00282457259620493f
CMODEL18986 sa_en.n0 vdd.t43 0.00167056925624926f
CMODEL18987 sa_en.n0 vdd.n26 0.0151130563581335f
CMODEL18988 sa_en.n0 vdd.n27 0.0101033891976909f
CMODEL18989 sa_en.n0 vdd.n28 0.00228217646064412f
CMODEL18990 sa_en.n0 vdd.t29 0.000190899169243306f
CMODEL18991 sa_en.n0 vdd.t28 0.00150895902369199f
CMODEL18992 sa_en.n0 vdd.n29 0.000340671425599702f
CMODEL18993 sa_en.n0 vdd.n30 0.000108681714208775f
CMODEL18994 sa_en.n0 vdd.t38 5.00394926056413e-05f
CMODEL18995 sa_en.n0 vdd.t40 5.00394926056413e-05f
CMODEL18996 sa_en.n0 vdd.t37 0.00101114851843689f
CMODEL18997 sa_en.n0 vdd.t39 0.00101114851843689f
CMODEL18998 sa_en.n0 vdd.n31 0.000327487032607895f
CMODEL18999 sa_en.n0 vdd.n32 0.00395208300005731f
CMODEL19000 sa_en.n0 vdd.n33 0.00200252394457255f
CMODEL19001 sa_en.n0 vdd.t17 0.000190899169243306f
CMODEL19002 sa_en.n0 vdd.t16 0.00150895902369199f
CMODEL19003 sa_en.n0 vdd.n34 0.000340671425599702f
CMODEL19004 sa_en.n0 vdd.n35 0.000108681714208775f
CMODEL19005 sa_en.n0 vdd.t1 5.00394926056413e-05f
CMODEL19006 sa_en.n0 vdd.t31 5.00394926056413e-05f
CMODEL19007 sa_en.n0 vdd.t0 0.00101114851843689f
CMODEL19008 sa_en.n0 vdd.t30 0.00101114851843689f
CMODEL19009 sa_en.n0 vdd.n36 0.000327487032607895f
CMODEL19010 sa_en.n0 vdd.n37 0.00383274151176941f
CMODEL19011 sa_en.n0 vdd.n38 0.00221090380038602f
CMODEL19012 sa_en.n0 vdd.t19 0.000190899169243306f
CMODEL19013 sa_en.n0 vdd.t18 0.00150895902369199f
CMODEL19014 sa_en.n0 vdd.n39 0.00186569652393476f
CMODEL19015 sa_en.n0 vdd.t21 0.000190900917836541f
CMODEL19016 sa_en.n0 vdd.t20 0.00150895902369199f
CMODEL19017 sa_en.n0 vdd.n40 0.00186569652393476f
CMODEL19018 sa_en.n0 vdd.t11 0.000190899169243306f
CMODEL19019 sa_en.n0 vdd.t10 0.00150895902369199f
CMODEL19020 sa_en.n0 vdd.n41 0.00802656752656376f
CMODEL19021 sa_en.n0 vdd.n42 0.0153748732232082f
CMODEL19022 sa_en.n0 vdd.n43 0.00186569652393476f
CMODEL19023 sa_en.n0 vdd.t13 0.000190899169243306f
CMODEL19024 sa_en.n0 vdd.t12 0.00150895902369199f
CMODEL19025 sa_en.n0 vdd.n44 0.00186569652393476f
CMODEL19026 sa_en.n0 vdd.t23 0.000190899169243306f
CMODEL19027 sa_en.n0 vdd.t22 0.00150895902369199f
CMODEL19028 sa_en.n0 vdd.n45 0.00230312460759927f
CMODEL19029 sa_en.n0 vdd.n46 0.0380154660845723f
CMODEL19030 sa_en.t0 vdd 2.08199698660329e-06f
CMODEL19031 sa_en.t0 vdd.n0 0.000698679445917489f
CMODEL19032 sa_en.t0 vdd.n1 6.47471537861622e-05f
CMODEL19033 sa_en.t0 vdd.t7 5.33752238512809e-06f
CMODEL19034 sa_en.t0 vdd.t6 4.21903489633938e-05f
CMODEL19035 sa_en.t0 vdd.n2 5.80613781258225e-05f
CMODEL19036 sa_en.t0 vdd.t27 5.33752238512809e-06f
CMODEL19037 sa_en.t0 vdd.t26 4.21903489633938e-05f
CMODEL19038 sa_en.t0 vdd.n3 0.000108901629633494f
CMODEL19039 sa_en.t0 vdd.n4 5.80613781258225e-05f
CMODEL19040 sa_en.t0 vdd.t36 5.33752238512809e-06f
CMODEL19041 sa_en.t0 vdd.t35 4.21903489633938e-05f
CMODEL19042 sa_en.t0 vdd.n5 8.28444606851117e-05f
CMODEL19043 sa_en.t0 vdd.t3 8.50235102001489e-06f
CMODEL19044 sa_en.t0 vdd.n6 8.13464558132081e-05f
CMODEL19045 sa_en.t0 vdd.t2 0.000106610131972067f
CMODEL19046 sa_en.t0 vdd.n7 0.000109048301128785f
CMODEL19047 sa_en.t0 vdd.t25 8.50235102001489e-06f
CMODEL19048 sa_en.t0 vdd.n8 4.91339731124548e-05f
CMODEL19049 sa_en.t0 vdd.t24 0.000106610131972067f
CMODEL19050 sa_en.t0 vdd.n9 0.000109048301128785f
CMODEL19051 sa_en.t0 vdd.t5 8.50235102001489e-06f
CMODEL19052 sa_en.t0 vdd.n10 0.000145490300848741f
CMODEL19053 sa_en.t0 vdd.t4 0.000106668800570183f
CMODEL19054 sa_en.t0 vdd.n11 0.000351771047445682f
CMODEL19055 sa_en.t0 vdd.n12 0.000867336998352398f
CMODEL19056 sa_en.t0 vdd.n13 6.57430532391868e-05f
CMODEL19057 sa_en.t0 vdd.t42 5.33752238512809e-06f
CMODEL19058 sa_en.t0 vdd.t41 4.21903489633938e-05f
CMODEL19059 sa_en.t0 vdd.n14 5.91081236972146e-05f
CMODEL19060 sa_en.t0 vdd.t9 5.33752238512809e-06f
CMODEL19061 sa_en.t0 vdd.t8 4.21903489633938e-05f
CMODEL19062 sa_en.t0 vdd.n15 0.000113479735906504f
CMODEL19063 sa_en.t0 vdd.t15 8.98890926039296e-06f
CMODEL19064 sa_en.t0 vdd.n16 7.07049499248751e-05f
CMODEL19065 sa_en.t0 vdd.t14 0.000121254791871871f
CMODEL19066 sa_en.t0 vdd.n17 9.90423717200451e-05f
CMODEL19067 sa_en.t0 vdd.t32 0.000121254791871871f
CMODEL19068 sa_en.t0 vdd.n18 9.77682853309522e-05f
CMODEL19069 sa_en.t0 vdd.t34 8.98890926039296e-06f
CMODEL19070 sa_en.t0 vdd.n19 9.84537301189446e-05f
CMODEL19071 sa_en.t0 vdd.t33 0.000121254791871871f
CMODEL19072 sa_en.t0 vdd.n20 0.000196478690566656f
CMODEL19073 sa_en.t0 vdd.t48 0.00012148653283443f
CMODEL19074 sa_en.t0 vdd.n21 0.000348771126462f
CMODEL19075 sa_en.t0 vdd.n22 0.00152844409622622f
CMODEL19076 sa_en.t0 vdd.t47 1.72801999986844e-06f
CMODEL19077 sa_en.t0 vdd.t45 1.71027763798809e-06f
CMODEL19078 sa_en.t0 vdd.n23 1.9529407378969e-05f
CMODEL19079 sa_en.t0 vdd.t46 4.66079966205564e-05f
CMODEL19080 sa_en.t0 vdd.n24 5.00760930172061e-05f
CMODEL19081 sa_en.t0 vdd.t44 4.66079966205564e-05f
CMODEL19082 sa_en.t0 vdd.n25 7.89747777343556e-05f
CMODEL19083 sa_en.t0 vdd.t43 4.67089554998149e-05f
CMODEL19084 sa_en.t0 vdd.n26 0.000422559600122873f
CMODEL19085 sa_en.t0 vdd.n27 0.000282489788835096f
CMODEL19086 sa_en.t0 vdd.n28 6.38094340262696e-05f
CMODEL19087 sa_en.t0 vdd.t29 5.33752238512809e-06f
CMODEL19088 sa_en.t0 vdd.t28 4.21903489633938e-05f
CMODEL19089 sa_en.t0 vdd.n29 9.52514024717618e-06f
CMODEL19090 sa_en.t0 vdd.n30 3.03873026133544e-06f
CMODEL19091 sa_en.t0 vdd.t38 1.39909939357909e-06f
CMODEL19092 sa_en.t0 vdd.t40 1.39909939357909e-06f
CMODEL19093 sa_en.t0 vdd.t37 2.82716151842828e-05f
CMODEL19094 sa_en.t0 vdd.t39 2.82716151842828e-05f
CMODEL19095 sa_en.t0 vdd.n31 9.15650588901193e-06f
CMODEL19096 sa_en.t0 vdd.n32 0.000110499860027179f
CMODEL19097 sa_en.t0 vdd.n33 5.59903766123162e-05f
CMODEL19098 sa_en.t0 vdd.t17 5.33752238512809e-06f
CMODEL19099 sa_en.t0 vdd.t16 4.21903489633938e-05f
CMODEL19100 sa_en.t0 vdd.n34 9.52514024717618e-06f
CMODEL19101 sa_en.t0 vdd.n35 3.03873026133544e-06f
CMODEL19102 sa_en.t0 vdd.t1 1.39909939357909e-06f
CMODEL19103 sa_en.t0 vdd.t31 1.39909939357909e-06f
CMODEL19104 sa_en.t0 vdd.t0 2.82716151842828e-05f
CMODEL19105 sa_en.t0 vdd.t30 2.82716151842828e-05f
CMODEL19106 sa_en.t0 vdd.n36 9.15650588901193e-06f
CMODEL19107 sa_en.t0 vdd.n37 0.000107163083509313f
CMODEL19108 sa_en.t0 vdd.n38 6.18166573102517e-05f
CMODEL19109 sa_en.t0 vdd.t19 5.33752238512809e-06f
CMODEL19110 sa_en.t0 vdd.t18 4.21903489633938e-05f
CMODEL19111 sa_en.t0 vdd.n39 5.21646951101474e-05f
CMODEL19112 sa_en.t0 vdd.t21 5.33757127562652e-06f
CMODEL19113 sa_en.t0 vdd.t20 4.21903489633938e-05f
CMODEL19114 sa_en.t0 vdd.n40 5.21646951101474e-05f
CMODEL19115 sa_en.t0 vdd.t11 5.33752238512809e-06f
CMODEL19116 sa_en.t0 vdd.t10 4.21903489633938e-05f
CMODEL19117 sa_en.t0 vdd.n41 0.000224422054944478f
CMODEL19118 sa_en.t0 vdd.n42 0.000429879974452837f
CMODEL19119 sa_en.t0 vdd.n43 5.21646951101474e-05f
CMODEL19120 sa_en.t0 vdd.t13 5.33752238512809e-06f
CMODEL19121 sa_en.t0 vdd.t12 4.21903489633938e-05f
CMODEL19122 sa_en.t0 vdd.n44 5.21646951101474e-05f
CMODEL19123 sa_en.t0 vdd.t23 5.33752238512809e-06f
CMODEL19124 sa_en.t0 vdd.t22 4.21903489633938e-05f
CMODEL19125 sa_en.t0 vdd.n45 6.43951421974642e-05f
CMODEL19126 sa_en.t0 vdd.n46 0.00106290877017317f
CMODEL19127 a_3200_169.t2 vdd 4.61288344722611e-06f
CMODEL19128 a_3200_169.t2 vdd.n0 0.00154799784616787f
CMODEL19129 a_3200_169.t2 vdd.n1 0.000143454133640444f
CMODEL19130 a_3200_169.t2 vdd.t7 1.18258426011102e-05f
CMODEL19131 a_3200_169.t2 vdd.t6 9.34771585253096e-05f
CMODEL19132 a_3200_169.t2 vdd.n2 0.000128641094008834f
CMODEL19133 a_3200_169.t2 vdd.t27 1.18258426011102e-05f
CMODEL19134 a_3200_169.t2 vdd.t26 9.34771585253096e-05f
CMODEL19135 a_3200_169.t2 vdd.n3 0.00024128302199508f
CMODEL19136 a_3200_169.t2 vdd.n4 0.000128641094008834f
CMODEL19137 a_3200_169.t2 vdd.t36 1.18258426011102e-05f
CMODEL19138 a_3200_169.t2 vdd.t35 9.34771585253096e-05f
CMODEL19139 a_3200_169.t2 vdd.n5 0.000183550621757716f
CMODEL19140 a_3200_169.t2 vdd.t3 1.88378535296151e-05f
CMODEL19141 a_3200_169.t2 vdd.n6 0.000180231634303877f
CMODEL19142 a_3200_169.t2 vdd.t2 0.000236205967753518f
CMODEL19143 a_3200_169.t2 vdd.n7 0.000241607988129594f
CMODEL19144 a_3200_169.t2 vdd.t25 1.88378535296151e-05f
CMODEL19145 a_3200_169.t2 vdd.n8 0.000108861488621396f
CMODEL19146 a_3200_169.t2 vdd.t24 0.000236205967753518f
CMODEL19147 a_3200_169.t2 vdd.n9 0.000241607988129594f
CMODEL19148 a_3200_169.t2 vdd.t5 1.88378535296151e-05f
CMODEL19149 a_3200_169.t2 vdd.n10 0.000322349073911019f
CMODEL19150 a_3200_169.t2 vdd.t4 0.000236335954207324f
CMODEL19151 a_3200_169.t2 vdd.n11 0.000779385778373735f
CMODEL19152 a_3200_169.t2 vdd.n12 0.00192167640424587f
CMODEL19153 a_3200_169.t2 vdd.n13 0.000145660653693796f
CMODEL19154 a_3200_169.t2 vdd.t42 1.18258426011102e-05f
CMODEL19155 a_3200_169.t2 vdd.t41 9.34771585253096e-05f
CMODEL19156 a_3200_169.t2 vdd.n14 0.000130960268988818f
CMODEL19157 a_3200_169.t2 vdd.t9 1.18258426011102e-05f
CMODEL19158 a_3200_169.t2 vdd.t8 9.34771585253096e-05f
CMODEL19159 a_3200_169.t2 vdd.n15 0.00025142629827372f
CMODEL19160 a_3200_169.t2 vdd.t15 1.99158745198439e-05f
CMODEL19161 a_3200_169.t2 vdd.n16 0.000156654258024415f
CMODEL19162 a_3200_169.t2 vdd.t14 0.000268652753064323f
CMODEL19163 a_3200_169.t2 vdd.n17 0.000219438798433028f
CMODEL19164 a_3200_169.t2 vdd.t32 0.000268652753064323f
CMODEL19165 a_3200_169.t2 vdd.n18 0.000216615925944547f
CMODEL19166 a_3200_169.t2 vdd.t34 1.99158745198439e-05f
CMODEL19167 a_3200_169.t2 vdd.n19 0.000218134601013177f
CMODEL19168 a_3200_169.t2 vdd.t33 0.000268652753064323f
CMODEL19169 a_3200_169.t2 vdd.n20 0.000435319217693124f
CMODEL19170 a_3200_169.t2 vdd.t48 0.000269166199556856f
CMODEL19171 a_3200_169.t2 vdd.n21 0.000772739137702469f
CMODEL19172 a_3200_169.t2 vdd.n22 0.00338642875895566f
CMODEL19173 a_3200_169.t2 vdd.t47 3.82861017818928e-06f
CMODEL19174 a_3200_169.t2 vdd.t45 3.78930010811753e-06f
CMODEL19175 a_3200_169.t2 vdd.n23 4.32694574546697e-05f
CMODEL19176 a_3200_169.t2 vdd.t46 0.000103264921852791f
CMODEL19177 a_3200_169.t2 vdd.n24 0.000110948854425426f
CMODEL19178 a_3200_169.t2 vdd.t44 0.000103264921852791f
CMODEL19179 a_3200_169.t2 vdd.n25 0.00017497693190878f
CMODEL19180 a_3200_169.t2 vdd.t43 0.000103488606875382f
CMODEL19181 a_3200_169.t2 vdd.n26 0.000936225267094823f
CMODEL19182 a_3200_169.t2 vdd.n27 0.000625885858295005f
CMODEL19183 a_3200_169.t2 vdd.n28 0.000141376516820449f
CMODEL19184 a_3200_169.t2 vdd.t29 1.18258426011102e-05f
CMODEL19185 a_3200_169.t2 vdd.t28 9.34771585253096e-05f
CMODEL19186 a_3200_169.t2 vdd.n29 2.11039507076282e-05f
CMODEL19187 a_3200_169.t2 vdd.n30 6.73262671045846e-06f
CMODEL19188 a_3200_169.t2 vdd.t38 3.09985195713198e-06f
CMODEL19189 a_3200_169.t2 vdd.t40 3.09985195713198e-06f
CMODEL19190 a_3200_169.t2 vdd.t37 6.26387389362605e-05f
CMODEL19191 a_3200_169.t2 vdd.t39 6.26387389362605e-05f
CMODEL19192 a_3200_169.t2 vdd.n31 2.02872024895489e-05f
CMODEL19193 a_3200_169.t2 vdd.n32 0.000244824069640837f
CMODEL19194 a_3200_169.t2 vdd.n33 0.000124052572189492f
CMODEL19195 a_3200_169.t2 vdd.t17 1.18258426011102e-05f
CMODEL19196 a_3200_169.t2 vdd.t16 9.34771585253096e-05f
CMODEL19197 a_3200_169.t2 vdd.n34 2.11039507076282e-05f
CMODEL19198 a_3200_169.t2 vdd.n35 6.73262671045846e-06f
CMODEL19199 a_3200_169.t2 vdd.t1 3.09985195713198e-06f
CMODEL19200 a_3200_169.t2 vdd.t31 3.09985195713198e-06f
CMODEL19201 a_3200_169.t2 vdd.t0 6.26387389362605e-05f
CMODEL19202 a_3200_169.t2 vdd.t30 6.26387389362605e-05f
CMODEL19203 a_3200_169.t2 vdd.n36 2.02872024895489e-05f
CMODEL19204 a_3200_169.t2 vdd.n37 0.000237431090080637f
CMODEL19205 a_3200_169.t2 vdd.n38 0.000136961310272848f
CMODEL19206 a_3200_169.t2 vdd.t19 1.18258426011102e-05f
CMODEL19207 a_3200_169.t2 vdd.t18 9.34771585253096e-05f
CMODEL19208 a_3200_169.t2 vdd.n39 0.00011557637218091f
CMODEL19209 a_3200_169.t2 vdd.t21 1.1825950923155e-05f
CMODEL19210 a_3200_169.t2 vdd.t20 9.34771585253096e-05f
CMODEL19211 a_3200_169.t2 vdd.n40 0.00011557637218091f
CMODEL19212 a_3200_169.t2 vdd.t11 1.18258426011102e-05f
CMODEL19213 a_3200_169.t2 vdd.t10 9.34771585253096e-05f
CMODEL19214 a_3200_169.t2 vdd.n41 0.000497230682420342f
CMODEL19215 a_3200_169.t2 vdd.n42 0.000952444326868432f
CMODEL19216 a_3200_169.t2 vdd.n43 0.00011557637218091f
CMODEL19217 a_3200_169.t2 vdd.t13 1.18258426011102e-05f
CMODEL19218 a_3200_169.t2 vdd.t12 9.34771585253096e-05f
CMODEL19219 a_3200_169.t2 vdd.n44 0.00011557637218091f
CMODEL19220 a_3200_169.t2 vdd.t23 1.18258426011102e-05f
CMODEL19221 a_3200_169.t2 vdd.t22 9.34771585253096e-05f
CMODEL19222 a_3200_169.t2 vdd.n45 0.00014267421491761f
CMODEL19223 a_3200_169.t2 vdd.n46 0.00235498624800725f
CMODEL19224 a_3200_169.n0 vdd 8.28935728122352e-05f
CMODEL19225 a_3200_169.n0 vdd.n0 0.0278175405129003f
CMODEL19226 a_3200_169.n0 vdd.n1 0.00257787256239717f
CMODEL19227 a_3200_169.n0 vdd.t7 0.000212510538351156f
CMODEL19228 a_3200_169.n0 vdd.t6 0.00167978569915053f
CMODEL19229 a_3200_169.n0 vdd.n2 0.00231168205632406f
CMODEL19230 a_3200_169.n0 vdd.t27 0.000212510538351156f
CMODEL19231 a_3200_169.n0 vdd.t26 0.00167978569915053f
CMODEL19232 a_3200_169.n0 vdd.n3 0.00433585890060424f
CMODEL19233 a_3200_169.n0 vdd.n4 0.00231168205632406f
CMODEL19234 a_3200_169.n0 vdd.t36 0.000212510538351156f
CMODEL19235 a_3200_169.n0 vdd.t35 0.00167978569915053f
CMODEL19236 a_3200_169.n0 vdd.n5 0.0032984069516332f
CMODEL19237 a_3200_169.n0 vdd.t3 0.000338516461785388f
CMODEL19238 a_3200_169.n0 vdd.n6 0.00323876470588489f
CMODEL19239 a_3200_169.n0 vdd.t2 0.00424462417285545f
CMODEL19240 a_3200_169.n0 vdd.n7 0.00434169854607568f
CMODEL19241 a_3200_169.n0 vdd.t25 0.000338516461785388f
CMODEL19242 a_3200_169.n0 vdd.n8 0.00195624230196244f
CMODEL19243 a_3200_169.n0 vdd.t24 0.00424462417285545f
CMODEL19244 a_3200_169.n0 vdd.n9 0.00434169854607568f
CMODEL19245 a_3200_169.n0 vdd.t5 0.000338516461785388f
CMODEL19246 a_3200_169.n0 vdd.n10 0.00579261685990955f
CMODEL19247 a_3200_169.n0 vdd.t4 0.00424696003104402f
CMODEL19248 a_3200_169.n0 vdd.n11 0.0140055721128817f
CMODEL19249 a_3200_169.n0 vdd.n12 0.0345325488405087f
CMODEL19250 a_3200_169.n0 vdd.n13 0.00261752375514825f
CMODEL19251 a_3200_169.n0 vdd.t42 0.000212510538351156f
CMODEL19252 a_3200_169.n0 vdd.t41 0.00167978569915053f
CMODEL19253 a_3200_169.n0 vdd.n14 0.00235335765950523f
CMODEL19254 a_3200_169.n0 vdd.t9 0.000212510538351156f
CMODEL19255 a_3200_169.n0 vdd.t8 0.00167978569915053f
CMODEL19256 a_3200_169.n0 vdd.n15 0.00451813370125277f
CMODEL19257 a_3200_169.n0 vdd.t15 0.000357888512362644f
CMODEL19258 a_3200_169.n0 vdd.n16 0.00281507896144705f
CMODEL19259 a_3200_169.n0 vdd.t14 0.00482769330769378f
CMODEL19260 a_3200_169.n0 vdd.n17 0.00394331793201407f
CMODEL19261 a_3200_169.n0 vdd.t32 0.00482769330769378f
CMODEL19262 a_3200_169.n0 vdd.n18 0.00389259087835217f
CMODEL19263 a_3200_169.n0 vdd.t34 0.000357888512362644f
CMODEL19264 a_3200_169.n0 vdd.n19 0.0039198814881887f
CMODEL19265 a_3200_169.n0 vdd.t33 0.00482769330769378f
CMODEL19266 a_3200_169.n0 vdd.n20 0.00782269174611588f
CMODEL19267 a_3200_169.n0 vdd.t48 0.00483691994753866f
CMODEL19268 a_3200_169.n0 vdd.n21 0.0138861318975059f
CMODEL19269 a_3200_169.n0 vdd.n22 0.0608541668384752f
CMODEL19270 a_3200_169.n0 vdd.t47 6.8800172431463e-05f
CMODEL19271 a_3200_169.n0 vdd.t45 6.80937699842679e-05f
CMODEL19272 a_3200_169.n0 vdd.n23 0.000777552687619156f
CMODEL19273 a_3200_169.n0 vdd.t46 0.0018556719276533f
CMODEL19274 a_3200_169.n0 vdd.n24 0.00199375229137398f
CMODEL19275 a_3200_169.n0 vdd.t44 0.0018556719276533f
CMODEL19276 a_3200_169.n0 vdd.n25 0.00314433763861171f
CMODEL19277 a_3200_169.n0 vdd.t43 0.00185969155028615f
CMODEL19278 a_3200_169.n0 vdd.n26 0.0168239796722475f
CMODEL19279 a_3200_169.n0 vdd.n27 0.0112471766434775f
CMODEL19280 a_3200_169.n0 vdd.n28 0.00254053776234977f
CMODEL19281 a_3200_169.n0 vdd.t29 0.000212510538351156f
CMODEL19282 a_3200_169.n0 vdd.t28 0.00167978569915053f
CMODEL19283 a_3200_169.n0 vdd.n29 0.000379238256206227f
CMODEL19284 a_3200_169.n0 vdd.n30 0.000120985385567586f
CMODEL19285 a_3200_169.n0 vdd.t38 5.57043781520618e-05f
CMODEL19286 a_3200_169.n0 vdd.t40 5.57043781520618e-05f
CMODEL19287 a_3200_169.n0 vdd.t37 0.00112561891629884f
CMODEL19288 a_3200_169.n0 vdd.t39 0.00112561891629884f
CMODEL19289 a_3200_169.n0 vdd.n31 0.000364561280588009f
CMODEL19290 a_3200_169.n0 vdd.n32 0.00439949157075803f
CMODEL19291 a_3200_169.n0 vdd.n33 0.00222922626226733f
CMODEL19292 a_3200_169.n0 vdd.t17 0.000212510538351156f
CMODEL19293 a_3200_169.n0 vdd.t16 0.00167978569915053f
CMODEL19294 a_3200_169.n0 vdd.n34 0.000379238256206227f
CMODEL19295 a_3200_169.n0 vdd.n35 0.000120985385567586f
CMODEL19296 a_3200_169.n0 vdd.t1 5.57043781520618e-05f
CMODEL19297 a_3200_169.n0 vdd.t31 5.57043781520618e-05f
CMODEL19298 a_3200_169.n0 vdd.t0 0.00112561891629884f
CMODEL19299 a_3200_169.n0 vdd.t30 0.00112561891629884f
CMODEL19300 a_3200_169.n0 vdd.n36 0.000364561280588009f
CMODEL19301 a_3200_169.n0 vdd.n37 0.00426663963628278f
CMODEL19302 a_3200_169.n0 vdd.n38 0.00246119644587781f
CMODEL19303 a_3200_169.n0 vdd.t19 0.000212510538351156f
CMODEL19304 a_3200_169.n0 vdd.t18 0.00167978569915053f
CMODEL19305 a_3200_169.n0 vdd.n39 0.00207690884288728f
CMODEL19306 a_3200_169.n0 vdd.t21 0.000212512484899647f
CMODEL19307 a_3200_169.n0 vdd.t20 0.00167978569915053f
CMODEL19308 a_3200_169.n0 vdd.n40 0.00207690884288728f
CMODEL19309 a_3200_169.n0 vdd.t11 0.000212510538351156f
CMODEL19310 a_3200_169.n0 vdd.t10 0.00167978569915053f
CMODEL19311 a_3200_169.n0 vdd.n41 0.00893524153584964f
CMODEL19312 a_3200_169.n0 vdd.n42 0.017115436377727f
CMODEL19313 a_3200_169.n0 vdd.n43 0.00207690884288728f
CMODEL19314 a_3200_169.n0 vdd.t13 0.000212510538351156f
CMODEL19315 a_3200_169.n0 vdd.t12 0.00167978569915053f
CMODEL19316 a_3200_169.n0 vdd.n44 0.00207690884288728f
CMODEL19317 a_3200_169.n0 vdd.t23 0.000212510538351156f
CMODEL19318 a_3200_169.n0 vdd.t22 0.00167978569915053f
CMODEL19319 a_3200_169.n0 vdd.n45 0.00256385741326572f
CMODEL19320 a_3200_169.n0 vdd.n46 0.0423191321121261f
CMODEL19321 a_3200_169.t1 vdd 6.73436203487447e-06f
CMODEL19322 a_3200_169.t1 vdd.n0 0.00225992658270374f
CMODEL19323 a_3200_169.t1 vdd.n1 0.000209429109229922f
CMODEL19324 a_3200_169.t1 vdd.t7 1.72645821977591e-05f
CMODEL19325 a_3200_169.t1 vdd.t6 0.000136467577102849f
CMODEL19326 a_3200_169.t1 vdd.n2 0.000187803509351348f
CMODEL19327 a_3200_169.t1 vdd.t27 1.72645821977591e-05f
CMODEL19328 a_3200_169.t1 vdd.t26 0.000136467577102849f
CMODEL19329 a_3200_169.t1 vdd.n3 0.000352249789437136f
CMODEL19330 a_3200_169.t1 vdd.n4 0.000187803509351348f
CMODEL19331 a_3200_169.t1 vdd.t36 1.72645821977591e-05f
CMODEL19332 a_3200_169.t1 vdd.t35 0.000136467577102849f
CMODEL19333 a_3200_169.t1 vdd.n5 0.000267966089493563f
CMODEL19334 a_3200_169.t1 vdd.t3 2.75014374587443e-05f
CMODEL19335 a_3200_169.t1 vdd.n6 0.000263120690003402f
CMODEL19336 a_3200_169.t1 vdd.t2 0.000344837783102154f
CMODEL19337 a_3200_169.t1 vdd.n7 0.000352724208447269f
CMODEL19338 a_3200_169.t1 vdd.t25 2.75014374587443e-05f
CMODEL19339 a_3200_169.t1 vdd.n8 0.000158927205601238f
CMODEL19340 a_3200_169.t1 vdd.t24 0.000344837783102154f
CMODEL19341 a_3200_169.t1 vdd.n9 0.000352724208447269f
CMODEL19342 a_3200_169.t1 vdd.t5 2.75014374587443e-05f
CMODEL19343 a_3200_169.t1 vdd.n10 0.000470598355704976f
CMODEL19344 a_3200_169.t1 vdd.t4 0.000345027550706207f
CMODEL19345 a_3200_169.t1 vdd.n11 0.00113782757714318f
CMODEL19346 a_3200_169.t1 vdd.n12 0.00280546100245597f
CMODEL19347 a_3200_169.t1 vdd.n13 0.000212650414308727f
CMODEL19348 a_3200_169.t1 vdd.t42 1.72645821977591e-05f
CMODEL19349 a_3200_169.t1 vdd.t41 0.000136467577102849f
CMODEL19350 a_3200_169.t1 vdd.n14 0.000191189279686999f
CMODEL19351 a_3200_169.t1 vdd.t9 1.72645821977591e-05f
CMODEL19352 a_3200_169.t1 vdd.t8 0.000136467577102849f
CMODEL19353 a_3200_169.t1 vdd.n15 0.000367057988140095f
CMODEL19354 a_3200_169.t1 vdd.t15 2.90752434550263e-05f
CMODEL19355 a_3200_169.t1 vdd.n16 0.000228700009421535f
CMODEL19356 a_3200_169.t1 vdd.t14 0.000392206939867259f
CMODEL19357 a_3200_169.t1 vdd.n17 0.000320359343575979f
CMODEL19358 a_3200_169.t1 vdd.t32 0.000392206939867259f
CMODEL19359 a_3200_169.t1 vdd.n18 0.000316238223774621f
CMODEL19360 a_3200_169.t1 vdd.t34 2.90752434550263e-05f
CMODEL19361 a_3200_169.t1 vdd.n19 0.000318455341948644f
CMODEL19362 a_3200_169.t1 vdd.t33 0.000392206939867259f
CMODEL19363 a_3200_169.t1 vdd.n20 0.000635523798990999f
CMODEL19364 a_3200_169.t1 vdd.t48 0.000392956521903269f
CMODEL19365 a_3200_169.t1 vdd.n21 0.00112812412698925f
CMODEL19366 a_3200_169.t1 vdd.n22 0.00494385724873057f
CMODEL19367 a_3200_169.t1 vdd.t47 5.58939919581889e-06f
CMODEL19368 a_3200_169.t1 vdd.t45 5.53201030955977e-06f
CMODEL19369 a_3200_169.t1 vdd.n23 6.31692074785822e-05f
CMODEL19370 a_3200_169.t1 vdd.t46 0.000150756761408723f
CMODEL19371 a_3200_169.t1 vdd.n24 0.000161974557042994f
CMODEL19372 a_3200_169.t1 vdd.t44 0.000150756761408723f
CMODEL19373 a_3200_169.t1 vdd.n25 0.000255449334609548f
CMODEL19374 a_3200_169.t1 vdd.t43 0.000151083319827365f
CMODEL19375 a_3200_169.t1 vdd.n26 0.00136679800540049f
CMODEL19376 a_3200_169.t1 vdd.n27 0.000913732594913339f
CMODEL19377 a_3200_169.t1 vdd.n28 0.00020639599035847f
CMODEL19378 a_3200_169.t1 vdd.t29 1.72645821977591e-05f
CMODEL19379 a_3200_169.t1 vdd.t28 0.000136467577102849f
CMODEL19380 a_3200_169.t1 vdd.n29 3.08097193560735e-05f
CMODEL19381 a_3200_169.t1 vdd.n30 9.82898142400665e-06f
CMODEL19382 a_3200_169.t1 vdd.t38 4.52548293766107e-06f
CMODEL19383 a_3200_169.t1 vdd.t40 4.52548293766107e-06f
CMODEL19384 a_3200_169.t1 vdd.t37 9.14464781585644e-05f
CMODEL19385 a_3200_169.t1 vdd.t39 9.14464781585644e-05f
CMODEL19386 a_3200_169.t1 vdd.n31 2.96173462439386e-05f
CMODEL19387 a_3200_169.t1 vdd.n32 0.000357419375250888f
CMODEL19388 a_3200_169.t1 vdd.n33 0.000181104712928267f
CMODEL19389 a_3200_169.t1 vdd.t17 1.72645821977591e-05f
CMODEL19390 a_3200_169.t1 vdd.t16 0.000136467577102849f
CMODEL19391 a_3200_169.t1 vdd.n34 3.08097193560735e-05f
CMODEL19392 a_3200_169.t1 vdd.n35 9.82898142400665e-06f
CMODEL19393 a_3200_169.t1 vdd.t1 4.52548293766107e-06f
CMODEL19394 a_3200_169.t1 vdd.t31 4.52548293766107e-06f
CMODEL19395 a_3200_169.t1 vdd.t0 9.14464781585644e-05f
CMODEL19396 a_3200_169.t1 vdd.t30 9.14464781585644e-05f
CMODEL19397 a_3200_169.t1 vdd.n36 2.96173462439386e-05f
CMODEL19398 a_3200_169.t1 vdd.n37 0.000346626342770356f
CMODEL19399 a_3200_169.t1 vdd.n38 0.00019995021740746f
CMODEL19400 a_3200_169.t1 vdd.t19 1.72645821977591e-05f
CMODEL19401 a_3200_169.t1 vdd.t18 0.000136467577102849f
CMODEL19402 a_3200_169.t1 vdd.n39 0.000168730283747291f
CMODEL19403 a_3200_169.t1 vdd.t21 1.72647403374291e-05f
CMODEL19404 a_3200_169.t1 vdd.t20 0.000136467577102849f
CMODEL19405 a_3200_169.t1 vdd.n40 0.000168730283747291f
CMODEL19406 a_3200_169.t1 vdd.t11 1.72645821977591e-05f
CMODEL19407 a_3200_169.t1 vdd.t10 0.000136467577102849f
CMODEL19408 a_3200_169.t1 vdd.n41 0.000725908527404885f
CMODEL19409 a_3200_169.t1 vdd.n42 0.00139047625819624f
CMODEL19410 a_3200_169.t1 vdd.n43 0.000168730283747291f
CMODEL19411 a_3200_169.t1 vdd.t13 1.72645821977591e-05f
CMODEL19412 a_3200_169.t1 vdd.t12 0.000136467577102849f
CMODEL19413 a_3200_169.t1 vdd.n44 0.000168730283747291f
CMODEL19414 a_3200_169.t1 vdd.t23 1.72645821977591e-05f
CMODEL19415 a_3200_169.t1 vdd.t22 0.000136467577102849f
CMODEL19416 a_3200_169.t1 vdd.n45 0.000208290503605602f
CMODEL19417 a_3200_169.t1 vdd.n46 0.00343805131056764f
CMODEL19418 a_3200_169.t3 vdd 1.33575490443632e-05f
CMODEL19419 a_3200_169.t3 vdd.n0 0.0044825448956856f
CMODEL19420 a_3200_169.t3 vdd.n1 0.000415400832828574f
CMODEL19421 a_3200_169.t3 vdd.t7 3.42441499644303e-05f
CMODEL19422 a_3200_169.t3 vdd.t6 0.000270682262800371f
CMODEL19423 a_3200_169.t3 vdd.n2 0.000372506641887263f
CMODEL19424 a_3200_169.t3 vdd.t27 3.42441499644303e-05f
CMODEL19425 a_3200_169.t3 vdd.t26 0.000270682262800371f
CMODEL19426 a_3200_169.t3 vdd.n3 0.000698684420871185f
CMODEL19427 a_3200_169.t3 vdd.n4 0.000372506641887263f
CMODEL19428 a_3200_169.t3 vdd.t36 3.42441499644303e-05f
CMODEL19429 a_3200_169.t3 vdd.t35 0.000270682262800371f
CMODEL19430 a_3200_169.t3 vdd.n5 0.000531508428578746f
CMODEL19431 a_3200_169.t3 vdd.t3 5.45488641304555e-05f
CMODEL19432 a_3200_169.t3 vdd.n6 0.000521897620458514f
CMODEL19433 a_3200_169.t3 vdd.t2 0.000683982770199015f
CMODEL19434 a_3200_169.t3 vdd.n7 0.000699625426888179f
CMODEL19435 a_3200_169.t3 vdd.t25 5.45488641304555e-05f
CMODEL19436 a_3200_169.t3 vdd.n8 0.000315230742319558f
CMODEL19437 a_3200_169.t3 vdd.t24 0.000683982770199015f
CMODEL19438 a_3200_169.t3 vdd.n9 0.000699625426888179f
CMODEL19439 a_3200_169.t3 vdd.t5 5.45488641304555e-05f
CMODEL19440 a_3200_169.t3 vdd.n10 0.000933427781870519f
CMODEL19441 a_3200_169.t3 vdd.t4 0.000684359172605812f
CMODEL19442 a_3200_169.t3 vdd.n11 0.00225687119091784f
CMODEL19443 a_3200_169.t3 vdd.n12 0.00556460771462705f
CMODEL19444 a_3200_169.t3 vdd.n13 0.000421790263683964f
CMODEL19445 a_3200_169.t3 vdd.t42 3.42441499644303e-05f
CMODEL19446 a_3200_169.t3 vdd.t41 0.000270682262800371f
CMODEL19447 a_3200_169.t3 vdd.n14 0.000379222288161877f
CMODEL19448 a_3200_169.t3 vdd.t9 3.42441499644303e-05f
CMODEL19449 a_3200_169.t3 vdd.t8 0.000270682262800371f
CMODEL19450 a_3200_169.t3 vdd.n15 0.000728056355348292f
CMODEL19451 a_3200_169.t3 vdd.t15 5.7670494757497e-05f
CMODEL19452 a_3200_169.t3 vdd.n16 0.000453624497238873f
CMODEL19453 a_3200_169.t3 vdd.t14 0.000777939084309147f
CMODEL19454 a_3200_169.t3 vdd.n17 0.000635429996408845f
CMODEL19455 a_3200_169.t3 vdd.t32 0.000777939084309147f
CMODEL19456 a_3200_169.t3 vdd.n18 0.00062725579080789f
CMODEL19457 a_3200_169.t3 vdd.t34 5.7670494757497e-05f
CMODEL19458 a_3200_169.t3 vdd.n19 0.000631653425593976f
CMODEL19459 a_3200_169.t3 vdd.t33 0.000777939084309147f
CMODEL19460 a_3200_169.t3 vdd.n20 0.00126055597693161f
CMODEL19461 a_3200_169.t3 vdd.t48 0.000779425873815997f
CMODEL19462 a_3200_169.t3 vdd.n21 0.00223762448118359f
CMODEL19463 a_3200_169.t3 vdd.n22 0.00980609823562601f
CMODEL19464 a_3200_169.t3 vdd.t47 1.10865251229498e-05f
CMODEL19465 a_3200_169.t3 vdd.t45 1.09726947617608e-05f
CMODEL19466 a_3200_169.t3 vdd.n23 0.000125295578500102f
CMODEL19467 a_3200_169.t3 vdd.t46 0.000299024736694887f
CMODEL19468 a_3200_169.t3 vdd.n24 0.000321275137635383f
CMODEL19469 a_3200_169.t3 vdd.t44 0.000299024736694887f
CMODEL19470 a_3200_169.t3 vdd.n25 0.00050668155316372f
CMODEL19471 a_3200_169.t3 vdd.t43 0.000299672462503251f
CMODEL19472 a_3200_169.t3 vdd.n26 0.0027110320615864f
CMODEL19473 a_3200_169.t3 vdd.n27 0.00181238072541725f
CMODEL19474 a_3200_169.t3 vdd.n28 0.000409384667693259f
CMODEL19475 a_3200_169.t3 vdd.t29 3.42441499644303e-05f
CMODEL19476 a_3200_169.t3 vdd.t28 0.000270682262800371f
CMODEL19477 a_3200_169.t3 vdd.n29 6.11108127556273e-05f
CMODEL19478 a_3200_169.t3 vdd.n30 1.94956999263482e-05f
CMODEL19479 a_3200_169.t3 vdd.t38 8.97625639610619e-06f
CMODEL19480 a_3200_169.t3 vdd.t40 8.97625639610619e-06f
CMODEL19481 a_3200_169.t3 vdd.t37 0.000181383301137015f
CMODEL19482 a_3200_169.t3 vdd.t39 0.000181383301137015f
CMODEL19483 a_3200_169.t3 vdd.n31 5.87457509662489e-05f
CMODEL19484 a_3200_169.t3 vdd.n32 0.000708938249769697f
CMODEL19485 a_3200_169.t3 vdd.n33 0.000359219636927307f
CMODEL19486 a_3200_169.t3 vdd.t17 3.42441499644303e-05f
CMODEL19487 a_3200_169.t3 vdd.t16 0.000270682262800371f
CMODEL19488 a_3200_169.t3 vdd.n34 6.11108127556273e-05f
CMODEL19489 a_3200_169.t3 vdd.n35 1.94956999263482e-05f
CMODEL19490 a_3200_169.t3 vdd.t1 8.97625639610619e-06f
CMODEL19491 a_3200_169.t3 vdd.t31 8.97625639610619e-06f
CMODEL19492 a_3200_169.t3 vdd.t0 0.000181383301137015f
CMODEL19493 a_3200_169.t3 vdd.t30 0.000181383301137015f
CMODEL19494 a_3200_169.t3 vdd.n36 5.87457509662489e-05f
CMODEL19495 a_3200_169.t3 vdd.n37 0.000687530362883082f
CMODEL19496 a_3200_169.t3 vdd.n38 0.000396599532609033f
CMODEL19497 a_3200_169.t3 vdd.t19 3.42441499644303e-05f
CMODEL19498 a_3200_169.t3 vdd.t18 0.000270682262800371f
CMODEL19499 a_3200_169.t3 vdd.n39 0.000334675063317379f
CMODEL19500 a_3200_169.t3 vdd.t21 3.42444636331026e-05f
CMODEL19501 a_3200_169.t3 vdd.t20 0.000270682262800371f
CMODEL19502 a_3200_169.t3 vdd.n40 0.000334675063317379f
CMODEL19503 a_3200_169.t3 vdd.t11 3.42441499644303e-05f
CMODEL19504 a_3200_169.t3 vdd.t10 0.000270682262800371f
CMODEL19505 a_3200_169.t3 vdd.n41 0.00143983330660259f
CMODEL19506 a_3200_169.t3 vdd.n42 0.00275799767189457f
CMODEL19507 a_3200_169.t3 vdd.n43 0.000334675063317379f
CMODEL19508 a_3200_169.t3 vdd.t13 3.42441499644303e-05f
CMODEL19509 a_3200_169.t3 vdd.t12 0.000270682262800371f
CMODEL19510 a_3200_169.t3 vdd.n44 0.000334675063317379f
CMODEL19511 a_3200_169.t3 vdd.t23 3.42441499644303e-05f
CMODEL19512 a_3200_169.t3 vdd.t22 0.000270682262800371f
CMODEL19513 a_3200_169.t3 vdd.n45 0.000413142418387789f
CMODEL19514 a_3200_169.t3 vdd.n46 0.00681934513768691f
CMODEL19515 a_3200_169.t4 vdd 2.99381646363767e-06f
CMODEL19516 a_3200_169.t4 vdd.n0 0.00100466909484129f
CMODEL19517 a_3200_169.t4 vdd.n1 9.3103446463166e-05f
CMODEL19518 a_3200_169.t4 vdd.t7 7.67511312189803e-06f
CMODEL19519 a_3200_169.t4 vdd.t6 6.06677925789402e-05f
CMODEL19520 a_3200_169.t4 vdd.n2 8.34896067828462e-05f
CMODEL19521 a_3200_169.t4 vdd.t27 7.67511312189803e-06f
CMODEL19522 a_3200_169.t4 vdd.t26 6.06677925789402e-05f
CMODEL19523 a_3200_169.t4 vdd.n3 0.000156595563687936f
CMODEL19524 a_3200_169.t4 vdd.n4 8.34896067828462e-05f
CMODEL19525 a_3200_169.t4 vdd.t36 7.67511312189803e-06f
CMODEL19526 a_3200_169.t4 vdd.t35 6.06677925789402e-05f
CMODEL19527 a_3200_169.t4 vdd.n5 0.000119126546251592f
CMODEL19528 a_3200_169.t4 vdd.t3 1.22259919813214e-05f
CMODEL19529 a_3200_169.t4 vdd.n6 0.000116972483744791f
CMODEL19530 a_3200_169.t4 vdd.t2 0.000153300494833701f
CMODEL19531 a_3200_169.t4 vdd.n7 0.000156806470591343f
CMODEL19532 a_3200_169.t4 vdd.t25 1.22259919813214e-05f
CMODEL19533 a_3200_169.t4 vdd.n8 7.06524065954502e-05f
CMODEL19534 a_3200_169.t4 vdd.t24 0.000153300494833701f
CMODEL19535 a_3200_169.t4 vdd.n9 0.000156806470591343f
CMODEL19536 a_3200_169.t4 vdd.t5 1.22259919813214e-05f
CMODEL19537 a_3200_169.t4 vdd.n10 0.000209208399811941f
CMODEL19538 a_3200_169.t4 vdd.t4 0.000153384857595064f
CMODEL19539 a_3200_169.t4 vdd.n11 0.000505830680856129f
CMODEL19540 a_3200_169.t4 vdd.n12 0.00124719094306944f
CMODEL19541 a_3200_169.t4 vdd.n13 9.45355043373021e-05f
CMODEL19542 a_3200_169.t4 vdd.t42 7.67511312189803e-06f
CMODEL19543 a_3200_169.t4 vdd.t41 6.06677925789402e-05f
CMODEL19544 a_3200_169.t4 vdd.n14 8.49947790501635e-05f
CMODEL19545 a_3200_169.t4 vdd.t9 7.67511312189803e-06f
CMODEL19546 a_3200_169.t4 vdd.t8 6.06677925789402e-05f
CMODEL19547 a_3200_169.t4 vdd.n15 0.000163178671166291f
CMODEL19548 a_3200_169.t4 vdd.t15 1.29256404822248e-05f
CMODEL19549 a_3200_169.t4 vdd.n16 0.000101670484879574f
CMODEL19550 a_3200_169.t4 vdd.t14 0.000174358846115917f
CMODEL19551 a_3200_169.t4 vdd.n17 0.000142418401640891f
CMODEL19552 a_3200_169.t4 vdd.t32 0.000174358846115917f
CMODEL19553 a_3200_169.t4 vdd.n18 0.000140586323673293f
CMODEL19554 a_3200_169.t4 vdd.t34 1.29256404822248e-05f
CMODEL19555 a_3200_169.t4 vdd.n19 0.000141571961935216f
CMODEL19556 a_3200_169.t4 vdd.t33 0.000174358846115917f
CMODEL19557 a_3200_169.t4 vdd.n20 0.000282527372689472f
CMODEL19558 a_3200_169.t4 vdd.t48 0.0001746920790233f
CMODEL19559 a_3200_169.t4 vdd.n21 0.000501516931658436f
CMODEL19560 a_3200_169.t4 vdd.n22 0.00219783271948787f
CMODEL19561 a_3200_169.t4 vdd.t47 2.4848137429543e-06f
CMODEL19562 a_3200_169.t4 vdd.t45 2.45930103787212e-06f
CMODEL19563 a_3200_169.t4 vdd.n23 2.80823947932952e-05f
CMODEL19564 a_3200_169.t4 vdd.t46 6.70201679049683e-05f
CMODEL19565 a_3200_169.t4 vdd.n24 7.2007131938337e-05f
CMODEL19566 a_3200_169.t4 vdd.t44 6.70201679049683e-05f
CMODEL19567 a_3200_169.t4 vdd.n25 0.000113562119116693f
CMODEL19568 a_3200_169.t4 vdd.t43 6.71653421568137e-05f
CMODEL19569 a_3200_169.t4 vdd.n26 0.000607621382670644f
CMODEL19570 a_3200_169.t4 vdd.n27 0.000406207398985629f
CMODEL19571 a_3200_169.t4 vdd.n28 9.17550483273815e-05f
CMODEL19572 a_3200_169.t4 vdd.t29 7.67511312189803e-06f
CMODEL19573 a_3200_169.t4 vdd.t28 6.06677925789402e-05f
CMODEL19574 a_3200_169.t4 vdd.n29 1.36967161210822e-05f
CMODEL19575 a_3200_169.t4 vdd.n30 4.36955516433391e-06f
CMODEL19576 a_3200_169.t4 vdd.t38 2.01184095160302e-06f
CMODEL19577 a_3200_169.t4 vdd.t40 2.01184095160302e-06f
CMODEL19578 a_3200_169.t4 vdd.t37 4.06532898639888e-05f
CMODEL19579 a_3200_169.t4 vdd.t39 4.06532898639888e-05f
CMODEL19580 a_3200_169.t4 vdd.n31 1.31666367705183e-05f
CMODEL19581 a_3200_169.t4 vdd.n32 0.000158893745912065f
CMODEL19582 a_3200_169.t4 vdd.n33 8.0511601306734e-05f
CMODEL19583 a_3200_169.t4 vdd.t17 7.67511312189803e-06f
CMODEL19584 a_3200_169.t4 vdd.t16 6.06677925789402e-05f
CMODEL19585 a_3200_169.t4 vdd.n34 1.36967161210822e-05f
CMODEL19586 a_3200_169.t4 vdd.n35 4.36955516433391e-06f
CMODEL19587 a_3200_169.t4 vdd.t1 2.01184095160302e-06f
CMODEL19588 a_3200_169.t4 vdd.t31 2.01184095160302e-06f
CMODEL19589 a_3200_169.t4 vdd.t0 4.06532898639888e-05f
CMODEL19590 a_3200_169.t4 vdd.t30 4.06532898639888e-05f
CMODEL19591 a_3200_169.t4 vdd.n36 1.31666367705183e-05f
CMODEL19592 a_3200_169.t4 vdd.n37 0.000154095613859547f
CMODEL19593 a_3200_169.t4 vdd.n38 8.88895265330865e-05f
CMODEL19594 a_3200_169.t4 vdd.t19 7.67511312189803e-06f
CMODEL19595 a_3200_169.t4 vdd.t18 6.06677925789402e-05f
CMODEL19596 a_3200_169.t4 vdd.n39 7.50104462428581e-05f
CMODEL19597 a_3200_169.t4 vdd.t21 7.67518342419917e-06f
CMODEL19598 a_3200_169.t4 vdd.t20 6.06677925789402e-05f
CMODEL19599 a_3200_169.t4 vdd.n40 7.50104462428581e-05f
CMODEL19600 a_3200_169.t4 vdd.t11 7.67511312189803e-06f
CMODEL19601 a_3200_169.t4 vdd.t10 6.06677925789402e-05f
CMODEL19602 a_3200_169.t4 vdd.n41 0.000322708652903635f
CMODEL19603 a_3200_169.t4 vdd.n42 0.000618147746219707f
CMODEL19604 a_3200_169.t4 vdd.n43 7.50104462428581e-05f
CMODEL19605 a_3200_169.t4 vdd.t13 7.67511312189803e-06f
CMODEL19606 a_3200_169.t4 vdd.t12 6.06677925789402e-05f
CMODEL19607 a_3200_169.t4 vdd.n44 7.50104462428581e-05f
CMODEL19608 a_3200_169.t4 vdd.t23 7.67511312189803e-06f
CMODEL19609 a_3200_169.t4 vdd.t22 6.06677925789402e-05f
CMODEL19610 a_3200_169.t4 vdd.n45 9.25972698949883e-05f
CMODEL19611 a_3200_169.t4 vdd.n46 0.00152841420807284f
CMODEL19612 a_3200_169.t0 vdd 7.48787382821066e-06f
CMODEL19613 a_3200_169.t0 vdd.n0 0.00251279111884283f
CMODEL19614 a_3200_169.t0 vdd.n1 0.000232862257441352f
CMODEL19615 a_3200_169.t0 vdd.t7 1.91963266192299e-05f
CMODEL19616 a_3200_169.t0 vdd.t6 0.000151737015874109f
CMODEL19617 a_3200_169.t0 vdd.n2 0.000208816956266339f
CMODEL19618 a_3200_169.t0 vdd.t27 1.91963266192299e-05f
CMODEL19619 a_3200_169.t0 vdd.t26 0.000151737015874109f
CMODEL19620 a_3200_169.t0 vdd.n3 0.000391663228923542f
CMODEL19621 a_3200_169.t0 vdd.n4 0.000208816956266339f
CMODEL19622 a_3200_169.t0 vdd.t36 1.91963266192299e-05f
CMODEL19623 a_3200_169.t0 vdd.t35 0.000151737015874109f
CMODEL19624 a_3200_169.t0 vdd.n5 0.000297948975415339f
CMODEL19625 a_3200_169.t0 vdd.t3 3.05785897341265e-05f
CMODEL19626 a_3200_169.t0 vdd.n6 0.000292561421280038f
CMODEL19627 a_3200_169.t0 vdd.t2 0.000383421888769444f
CMODEL19628 a_3200_169.t0 vdd.n7 0.000392190730960288f
CMODEL19629 a_3200_169.t0 vdd.t25 3.05785897341265e-05f
CMODEL19630 a_3200_169.t0 vdd.n8 0.000176709665629722f
CMODEL19631 a_3200_169.t0 vdd.t24 0.000383421888769444f
CMODEL19632 a_3200_169.t0 vdd.n9 0.000392190730960288f
CMODEL19633 a_3200_169.t0 vdd.t5 3.05785897341265e-05f
CMODEL19634 a_3200_169.t0 vdd.n10 0.000523253887010241f
CMODEL19635 a_3200_169.t0 vdd.t4 0.000383632889584142f
CMODEL19636 a_3200_169.t0 vdd.n11 0.00126513978485054f
CMODEL19637 a_3200_169.t0 vdd.n12 0.00311936571089725f
CMODEL19638 a_3200_169.t0 vdd.n13 0.000236443996270858f
CMODEL19639 a_3200_169.t0 vdd.t42 1.91963266192299e-05f
CMODEL19640 a_3200_169.t0 vdd.t41 0.000151737015874109f
CMODEL19641 a_3200_169.t0 vdd.n14 0.000212581562468584f
CMODEL19642 a_3200_169.t0 vdd.t9 1.91963266192299e-05f
CMODEL19643 a_3200_169.t0 vdd.t8 0.000151737015874109f
CMODEL19644 a_3200_169.t0 vdd.n15 0.000408128325830512f
CMODEL19645 a_3200_169.t0 vdd.t15 3.23284898240258e-05f
CMODEL19646 a_3200_169.t0 vdd.n16 0.000254289390173981f
CMODEL19647 a_3200_169.t0 vdd.t14 0.000436091208798426f
CMODEL19648 a_3200_169.t0 vdd.n17 0.000356204542013464f
CMODEL19649 a_3200_169.t0 vdd.t32 0.000436091208798426f
CMODEL19650 a_3200_169.t0 vdd.n18 0.000351622307654262f
CMODEL19651 a_3200_169.t0 vdd.t34 3.23284898240258e-05f
CMODEL19652 a_3200_169.t0 vdd.n19 0.000354087500505989f
CMODEL19653 a_3200_169.t0 vdd.t33 0.000436091208798426f
CMODEL19654 a_3200_169.t0 vdd.n20 0.000706632936724557f
CMODEL19655 a_3200_169.t0 vdd.t48 0.000436924662016485f
CMODEL19656 a_3200_169.t0 vdd.n21 0.00125435060985896f
CMODEL19657 a_3200_169.t0 vdd.n22 0.00549702839132694f
CMODEL19658 a_3200_169.t0 vdd.t47 6.21480041272746e-06f
CMODEL19659 a_3200_169.t0 vdd.t45 6.15099024968239e-06f
CMODEL19660 a_3200_169.t0 vdd.n23 7.02372478607771e-05f
CMODEL19661 a_3200_169.t0 vdd.t46 0.00016762502555288f
CMODEL19662 a_3200_169.t0 vdd.n24 0.000180097987045755f
CMODEL19663 a_3200_169.t0 vdd.t44 0.00016762502555288f
CMODEL19664 a_3200_169.t0 vdd.n25 0.000284031713345853f
CMODEL19665 a_3200_169.t0 vdd.t43 0.000167988122788173f
CMODEL19666 a_3200_169.t0 vdd.n26 0.00151972985118547f
CMODEL19667 a_3200_169.t0 vdd.n27 0.00101597068111325f
CMODEL19668 a_3200_169.t0 vdd.n28 0.000229489761086421f
CMODEL19669 a_3200_169.t0 vdd.t29 1.91963266192299e-05f
CMODEL19670 a_3200_169.t0 vdd.t28 0.000151737015874109f
CMODEL19671 a_3200_169.t0 vdd.n29 3.42570372703698e-05f
CMODEL19672 a_3200_169.t0 vdd.n30 1.09287520305047e-05f
CMODEL19673 a_3200_169.t0 vdd.t38 5.03184192852172e-06f
CMODEL19674 a_3200_169.t0 vdd.t40 5.03184192852172e-06f
CMODEL19675 a_3200_169.t0 vdd.t37 0.000101678479258996f
CMODEL19676 a_3200_169.t0 vdd.t39 0.000101678479258996f
CMODEL19677 a_3200_169.t0 vdd.n31 3.29312488180144e-05f
CMODEL19678 a_3200_169.t0 vdd.n32 0.000397411242783952f
CMODEL19679 a_3200_169.t0 vdd.n33 0.000201368627507483f
CMODEL19680 a_3200_169.t0 vdd.t17 1.91963266192299e-05f
CMODEL19681 a_3200_169.t0 vdd.t16 0.000151737015874109f
CMODEL19682 a_3200_169.t0 vdd.n34 3.42570372703698e-05f
CMODEL19683 a_3200_169.t0 vdd.n35 1.09287520305047e-05f
CMODEL19684 a_3200_169.t0 vdd.t1 5.03184192852172e-06f
CMODEL19685 a_3200_169.t0 vdd.t31 5.03184192852172e-06f
CMODEL19686 a_3200_169.t0 vdd.t0 0.000101678479258996f
CMODEL19687 a_3200_169.t0 vdd.t30 0.000101678479258996f
CMODEL19688 a_3200_169.t0 vdd.n36 3.29312488180144e-05f
CMODEL19689 a_3200_169.t0 vdd.n37 0.000385410571447977f
CMODEL19690 a_3200_169.t0 vdd.n38 0.000222322766747163f
CMODEL19691 a_3200_169.t0 vdd.t19 1.91963266192299e-05f
CMODEL19692 a_3200_169.t0 vdd.t18 0.000151737015874109f
CMODEL19693 a_3200_169.t0 vdd.n39 0.00018760961604902f
CMODEL19694 a_3200_169.t0 vdd.t21 1.91965024532421e-05f
CMODEL19695 a_3200_169.t0 vdd.t20 0.000151737015874109f
CMODEL19696 a_3200_169.t0 vdd.n40 0.00018760961604902f
CMODEL19697 a_3200_169.t0 vdd.t11 1.91963266192299e-05f
CMODEL19698 a_3200_169.t0 vdd.t10 0.000151737015874109f
CMODEL19699 a_3200_169.t0 vdd.n41 0.000807130866425315f
CMODEL19700 a_3200_169.t0 vdd.n42 0.00154605747783947f
CMODEL19701 a_3200_169.t0 vdd.n43 0.00018760961604902f
CMODEL19702 a_3200_169.t0 vdd.t13 1.91963266192299e-05f
CMODEL19703 a_3200_169.t0 vdd.t12 0.000151737015874109f
CMODEL19704 a_3200_169.t0 vdd.n44 0.00018760961604902f
CMODEL19705 a_3200_169.t0 vdd.t23 1.91963266192299e-05f
CMODEL19706 a_3200_169.t0 vdd.t22 0.000151737015874109f
CMODEL19707 a_3200_169.t0 vdd.n45 0.000231596252553161f
CMODEL19708 a_3200_169.t0 vdd.n46 0.0038227369266946f
CMODEL19709 a_3200_169.n1 vdd 6.77010608462377e-06f
CMODEL19710 a_3200_169.n1 vdd.n0 0.00227192162065739f
CMODEL19711 a_3200_169.n1 vdd.n1 0.000210540698488192f
CMODEL19712 a_3200_169.n1 vdd.t7 1.73562176164939e-05f
CMODEL19713 a_3200_169.n1 vdd.t6 0.000137191907609566f
CMODEL19714 a_3200_169.n1 vdd.n2 0.000188800316167879f
CMODEL19715 a_3200_169.n1 vdd.t27 1.73562176164939e-05f
CMODEL19716 a_3200_169.n1 vdd.t26 0.000137191907609566f
CMODEL19717 a_3200_169.n1 vdd.n3 0.000354119429639522f
CMODEL19718 a_3200_169.n1 vdd.n4 0.000188800316167879f
CMODEL19719 a_3200_169.n1 vdd.t36 1.73562176164939e-05f
CMODEL19720 a_3200_169.n1 vdd.t35 0.000137191907609566f
CMODEL19721 a_3200_169.n1 vdd.n5 0.000269388376145867f
CMODEL19722 a_3200_169.n1 vdd.t3 2.76474071502477e-05f
CMODEL19723 a_3200_169.n1 vdd.n6 0.000264517258673879f
CMODEL19724 a_3200_169.n1 vdd.t2 0.000346668082514453f
CMODEL19725 a_3200_169.n1 vdd.n7 0.000354596366728816f
CMODEL19726 a_3200_169.n1 vdd.t25 2.76474071502477e-05f
CMODEL19727 a_3200_169.n1 vdd.n8 0.000159770745332857f
CMODEL19728 a_3200_169.n1 vdd.t24 0.000346668082514453f
CMODEL19729 a_3200_169.n1 vdd.n9 0.000354596366728816f
CMODEL19730 a_3200_169.n1 vdd.t5 2.76474071502477e-05f
CMODEL19731 a_3200_169.n1 vdd.n10 0.000473096155934775f
CMODEL19732 a_3200_169.n1 vdd.t4 0.000346858857350171f
CMODEL19733 a_3200_169.n1 vdd.n11 0.00114386683747889f
CMODEL19734 a_3200_169.n1 vdd.n12 0.00282035157963643f
CMODEL19735 a_3200_169.n1 vdd.n13 0.000213779101324497f
CMODEL19736 a_3200_169.n1 vdd.t42 1.73562176164939e-05f
CMODEL19737 a_3200_169.n1 vdd.t41 0.000137191907609566f
CMODEL19738 a_3200_169.n1 vdd.n14 0.000192204057195139f
CMODEL19739 a_3200_169.n1 vdd.t9 1.73562176164939e-05f
CMODEL19740 a_3200_169.n1 vdd.t8 0.000137191907609566f
CMODEL19741 a_3200_169.n1 vdd.n15 0.000369006225986682f
CMODEL19742 a_3200_169.n1 vdd.t15 2.92295664544653e-05f
CMODEL19743 a_3200_169.n1 vdd.n16 0.00022991388305531f
CMODEL19744 a_3200_169.n1 vdd.t14 0.000394288661090151f
CMODEL19745 a_3200_169.n1 vdd.n17 0.000322059718497186f
CMODEL19746 a_3200_169.n1 vdd.t32 0.000394288661090151f
CMODEL19747 a_3200_169.n1 vdd.n18 0.00031791672498152f
CMODEL19748 a_3200_169.n1 vdd.t34 2.92295664544653e-05f
CMODEL19749 a_3200_169.n1 vdd.n19 0.00032014561097882f
CMODEL19750 a_3200_169.n1 vdd.t33 0.000394288661090151f
CMODEL19751 a_3200_169.n1 vdd.n20 0.000638896975866605f
CMODEL19752 a_3200_169.n1 vdd.t48 0.000395042221691235f
CMODEL19753 a_3200_169.n1 vdd.n21 0.00113411188421253f
CMODEL19754 a_3200_169.n1 vdd.n22 0.00497009781591971f
CMODEL19755 a_3200_169.n1 vdd.t47 5.6190661133219e-06f
CMODEL19756 a_3200_169.n1 vdd.t45 5.56137262342032e-06f
CMODEL19757 a_3200_169.n1 vdd.n23 6.35044913975408e-05f
CMODEL19758 a_3200_169.n1 vdd.t46 0.000151556934781038f
CMODEL19759 a_3200_169.n1 vdd.n24 0.000162834271236422f
CMODEL19760 a_3200_169.n1 vdd.t44 0.000151556934781038f
CMODEL19761 a_3200_169.n1 vdd.n25 0.000256805185939997f
CMODEL19762 a_3200_169.n1 vdd.t43 0.000151885226477502f
CMODEL19763 a_3200_169.n1 vdd.n26 0.0013740525746751f
CMODEL19764 a_3200_169.n1 vdd.n27 0.000918582423770327f
CMODEL19765 a_3200_169.n1 vdd.n28 0.000207491480697306f
CMODEL19766 a_3200_169.n1 vdd.t29 1.73562176164939e-05f
CMODEL19767 a_3200_169.n1 vdd.t28 0.000137191907609566f
CMODEL19768 a_3200_169.n1 vdd.n29 3.09732484529237e-05f
CMODEL19769 a_3200_169.n1 vdd.n30 9.88115082018483e-06f
CMODEL19770 a_3200_169.n1 vdd.t38 4.5495028947744e-06f
CMODEL19771 a_3200_169.n1 vdd.t40 4.5495028947744e-06f
CMODEL19772 a_3200_169.n1 vdd.t37 9.19318496678137e-05f
CMODEL19773 a_3200_169.n1 vdd.t39 9.19318496678137e-05f
CMODEL19774 a_3200_169.n1 vdd.n31 2.97745465684984e-05f
CMODEL19775 a_3200_169.n1 vdd.n32 0.000359316454122527f
CMODEL19776 a_3200_169.n1 vdd.n33 0.000182065964467049f
CMODEL19777 a_3200_169.n1 vdd.t17 1.73562176164939e-05f
CMODEL19778 a_3200_169.n1 vdd.t16 0.000137191907609566f
CMODEL19779 a_3200_169.n1 vdd.n34 3.09732484529237e-05f
CMODEL19780 a_3200_169.n1 vdd.n35 9.88115082018483e-06f
CMODEL19781 a_3200_169.n1 vdd.t1 4.5495028947744e-06f
CMODEL19782 a_3200_169.n1 vdd.t31 4.5495028947744e-06f
CMODEL19783 a_3200_169.n1 vdd.t0 9.19318496678137e-05f
CMODEL19784 a_3200_169.n1 vdd.t30 9.19318496678137e-05f
CMODEL19785 a_3200_169.n1 vdd.n36 2.97745465684984e-05f
CMODEL19786 a_3200_169.n1 vdd.n37 0.000348466135341091f
CMODEL19787 a_3200_169.n1 vdd.n38 0.0002010114954441f
CMODEL19788 a_3200_169.n1 vdd.t19 1.73562176164939e-05f
CMODEL19789 a_3200_169.n1 vdd.t18 0.000137191907609566f
CMODEL19790 a_3200_169.n1 vdd.n39 0.000169625855387967f
CMODEL19791 a_3200_169.n1 vdd.t21 1.73563765955237e-05f
CMODEL19792 a_3200_169.n1 vdd.t20 0.000137191907609566f
CMODEL19793 a_3200_169.n1 vdd.n40 0.000169625855387967f
CMODEL19794 a_3200_169.n1 vdd.t11 1.73562176164939e-05f
CMODEL19795 a_3200_169.n1 vdd.t10 0.000137191907609566f
CMODEL19796 a_3200_169.n1 vdd.n41 0.000729761440328579f
CMODEL19797 a_3200_169.n1 vdd.n42 0.00139785650480176f
CMODEL19798 a_3200_169.n1 vdd.n43 0.000169625855387967f
CMODEL19799 a_3200_169.n1 vdd.t13 1.73562176164939e-05f
CMODEL19800 a_3200_169.n1 vdd.t12 0.000137191907609566f
CMODEL19801 a_3200_169.n1 vdd.n44 0.000169625855387967f
CMODEL19802 a_3200_169.n1 vdd.t23 1.73562176164939e-05f
CMODEL19803 a_3200_169.n1 vdd.t22 0.000137191907609566f
CMODEL19804 a_3200_169.n1 vdd.n45 0.000209396049473886f
CMODEL19805 a_3200_169.n1 vdd.n46 0.0034562994945009f
CMODEL19806 a_0_n35917.t1 a_3200_n35917.t1 0.00321649008375677f
CMODEL19807 a_0_n35917.t1 a_3200_n35917.n0 0.0417220556164363f
CMODEL19808 a_0_n35917.t1 a_3200_n35917.t0 0.000730221582366658f
CMODEL19809 a_0_n35917.t1 a_3200_n35917.t3 0.00537484357826354f
CMODEL19810 a_0_n35917.t1 a_3200_n35917.t2 0.00122798165302114f
CMODEL19811 a_0_n35917.n0 a_3200_n35917.t1 0.0400636647520117f
CMODEL19812 a_0_n35917.n0 a_3200_n35917.n0 0.519677787108046f
CMODEL19813 a_0_n35917.n0 a_3200_n35917.t0 0.00909542759617398f
CMODEL19814 a_0_n35917.n0 a_3200_n35917.t3 0.0669474879781216f
CMODEL19815 a_0_n35917.n0 a_3200_n35917.t2 0.015295382229439f
CMODEL19816 a_0_n35917.t0 a_3200_n35917.t1 0.000730220939513416f
CMODEL19817 a_0_n35917.t0 a_3200_n35917.n0 0.00947191437166855f
CMODEL19818 a_0_n35917.t0 a_3200_n35917.t0 0.000165777936832924f
CMODEL19819 a_0_n35917.t0 a_3200_n35917.t3 0.00122021931523357f
CMODEL19820 a_0_n35917.t0 a_3200_n35917.t2 0.000278781495675254f
CMODEL19821 a_0_n35917.t2 a_3200_n35917.t1 0.00512183669201557f
CMODEL19822 a_0_n35917.t2 a_3200_n35917.n0 0.0664368767687883f
CMODEL19823 a_0_n35917.t2 a_3200_n35917.t0 0.00116278166463331f
CMODEL19824 a_0_n35917.t2 a_3200_n35917.t3 0.00855873027310606f
CMODEL19825 a_0_n35917.t2 a_3200_n35917.t2 0.00195539899822095f
CMODEL19826 a_0_n35917.t3 a_3200_n35917.t1 0.00122798363252808f
CMODEL19827 a_0_n35917.t3 a_3200_n35917.n0 0.0159285432500293f
CMODEL19828 a_0_n35917.t3 a_3200_n35917.t0 0.000278782190498063f
CMODEL19829 a_0_n35917.t3 a_3200_n35917.t3 0.00205199449388553f
CMODEL19830 a_0_n35917.t3 a_3200_n35917.t2 0.000468815799734568f
CMODEL19831 a_0_n11917.t2 a_20000_14483.t0 5.50508742628372e-06f
CMODEL19832 a_0_n11917.t2 a_20000_14483.t1 2.60643763769756e-06f
CMODEL19833 a_0_n11917.t2 a_20000_14483.n0 7.07479392063251e-06f
CMODEL19834 a_0_n11917.t2 a_20000_14483.t2 2.36305726623301e-06f
CMODEL19835 a_0_n11917.t2 a_20000_14483.t3 2.48936063058455e-06f
CMODEL19836 a_0_n11917.t2 a_20000_14483.t4 2.43494665656556e-06f
CMODEL19837 a_0_n11917.t2 a_20000_14483.n1 6.20559487263476e-05f
CMODEL19838 a_0_n11917.t1 a_20000_14483.t0 8.61194624955848e-06f
CMODEL19839 a_0_n11917.t1 a_20000_14483.t1 4.07741042067889e-06f
CMODEL19840 a_0_n11917.t1 a_20000_14483.n0 1.10675344918764e-05f
CMODEL19841 a_0_n11917.t1 a_20000_14483.t2 3.69667556309186e-06f
CMODEL19842 a_0_n11917.t1 a_20000_14483.t3 3.89425967042876e-06f
CMODEL19843 a_0_n11917.t1 a_20000_14483.t4 3.80913655008755e-06f
CMODEL19844 a_0_n11917.t1 a_20000_14483.n1 9.70779305602113e-05f
CMODEL19845 a_0_n11917.n0 a_20000_14483.t0 0.000234832181326976f
CMODEL19846 a_0_n11917.n0 a_20000_14483.t1 0.000111183599561186f
CMODEL19847 a_0_n11917.n0 a_20000_14483.n0 0.000301791626575948f
CMODEL19848 a_0_n11917.n0 a_20000_14483.t2 0.000100801649358122f
CMODEL19849 a_0_n11917.n0 a_20000_14483.t3 0.000106189410216923f
CMODEL19850 a_0_n11917.n0 a_20000_14483.t4 0.000103868256850213f
CMODEL19851 a_0_n11917.n0 a_20000_14483.n1 0.00264713939585165f
CMODEL19852 a_0_n11917.t6 a_20000_14483.t0 1.46725686047965e-05f
CMODEL19853 a_0_n11917.t6 a_20000_14483.t1 6.9468715193607e-06f
CMODEL19854 a_0_n11917.t6 a_20000_14483.n0 1.88562671447622e-05f
CMODEL19855 a_0_n11917.t6 a_20000_14483.t2 6.29819604504854e-06f
CMODEL19856 a_0_n11917.t6 a_20000_14483.t3 6.63482916909606e-06f
CMODEL19857 a_0_n11917.t6 a_20000_14483.t4 6.48980099696542e-06f
CMODEL19858 a_0_n11917.t6 a_20000_14483.n1 0.000165396131708252f
CMODEL19859 a_0_n11917.n1 a_20000_14483.t0 0.000910398162287303f
CMODEL19860 a_0_n11917.n1 a_20000_14483.t1 0.000431036939422082f
CMODEL19861 a_0_n11917.n1 a_20000_14483.n0 0.00116998675682308f
CMODEL19862 a_0_n11917.n1 a_20000_14483.t2 0.000390788161199189f
CMODEL19863 a_0_n11917.n1 a_20000_14483.t3 0.000411675449972724f
CMODEL19864 a_0_n11917.n1 a_20000_14483.t4 0.000402676795071601f
CMODEL19865 a_0_n11917.n1 a_20000_14483.n1 0.0102624385962931f
CMODEL19866 a_0_n11917.t4 a_20000_14483.t0 1.16481695736445e-06f
CMODEL19867 a_0_n11917.t4 a_20000_14483.t1 5.51494013375289e-07f
CMODEL19868 a_0_n11917.t4 a_20000_14483.n0 1.49694987390504e-06f
CMODEL19869 a_0_n11917.t4 a_20000_14483.t2 4.99997359131789e-07f
CMODEL19870 a_0_n11917.t4 a_20000_14483.t3 5.26721784954064e-07f
CMODEL19871 a_0_n11917.t4 a_20000_14483.t4 5.15208376583418e-07f
CMODEL19872 a_0_n11917.t4 a_20000_14483.n1 1.31303675644956e-05f
CMODEL19873 a_0_n11917.t5 a_20000_14483.t0 1.17603452273098e-06f
CMODEL19874 a_0_n11917.t5 a_20000_14483.t1 5.56805079723677e-07f
CMODEL19875 a_0_n11917.t5 a_20000_14483.n0 1.51136598705895e-06f
CMODEL19876 a_0_n11917.t5 a_20000_14483.t2 5.04812495985434e-07f
CMODEL19877 a_0_n11917.t5 a_20000_14483.t3 5.31794286702381e-07f
CMODEL19878 a_0_n11917.t5 a_20000_14483.t4 5.20170000472195e-07f
CMODEL19879 a_0_n11917.t5 a_20000_14483.n1 1.3256817265893e-05f
CMODEL19880 a_0_n11917.n2 a_20000_14483.t0 0.000295757281583844f
CMODEL19881 a_0_n11917.n2 a_20000_14483.t1 0.000140029185851392f
CMODEL19882 a_0_n11917.n2 a_20000_14483.n0 0.000380088753494092f
CMODEL19883 a_0_n11917.n2 a_20000_14483.t2 0.000126953731915538f
CMODEL19884 a_0_n11917.n2 a_20000_14483.t3 0.00013373929893799f
CMODEL19885 a_0_n11917.n2 a_20000_14483.t4 0.000130815943178154f
CMODEL19886 a_0_n11917.n2 a_20000_14483.n1 0.00333391593633614f
CMODEL19887 a_0_n11917.t0 a_20000_14483.t0 2.33106455075443e-06f
CMODEL19888 a_0_n11917.t0 a_20000_14483.t1 1.10366537540902e-06f
CMODEL19889 a_0_n11917.t0 a_20000_14483.n0 2.99573831171877e-06f
CMODEL19890 a_0_n11917.t0 a_20000_14483.t2 1.00060881838474e-06f
CMODEL19891 a_0_n11917.t0 a_20000_14483.t3 1.05409049314892e-06f
CMODEL19892 a_0_n11917.t0 a_20000_14483.t4 1.03104953556199e-06f
CMODEL19893 a_0_n11917.t0 a_20000_14483.n1 2.62768619347933e-05f
CMODEL19894 a_0_n11917.t3 a_20000_14483.t0 4.18628232283514e-06f
CMODEL19895 a_0_n11917.t3 a_20000_14483.t1 1.98203642619192e-06f
CMODEL19896 a_0_n11917.t3 a_20000_14483.n0 5.37994811603543e-06f
CMODEL19897 a_0_n11917.t3 a_20000_14483.t2 1.79696053767422e-06f
CMODEL19898 a_0_n11917.t3 a_20000_14483.t3 1.89300652215305e-06f
CMODEL19899 a_0_n11917.t3 a_20000_14483.t4 1.85162802261037e-06f
CMODEL19900 a_0_n11917.t3 a_20000_14483.n1 4.71897539609545e-05f
CMODEL19901 a_0_n11917.n3 a_20000_14483.t0 0.000649057157235974f
CMODEL19902 a_0_n11917.n3 a_20000_14483.t1 0.000307302477261265f
CMODEL19903 a_0_n11917.n3 a_20000_14483.n0 0.000834127648587762f
CMODEL19904 a_0_n11917.n3 a_20000_14483.t2 0.000278607606535759f
CMODEL19905 a_0_n11917.n3 a_20000_14483.t3 0.00029349894181664f
CMODEL19906 a_0_n11917.n3 a_20000_14483.t4 0.000287083461633336f
CMODEL19907 a_0_n11917.n3 a_20000_14483.n1 0.00731647920387246f
CMODEL19908 a_0_n11917.n4 a_20000_14483.t0 0.0011822776115075f
CMODEL19909 a_0_n11917.n4 a_20000_14483.t1 0.000559760931339206f
CMODEL19910 a_0_n11917.n4 a_20000_14483.n0 0.00151938921414f
CMODEL19911 a_0_n11917.n4 a_20000_14483.t2 0.000507492340128627f
CMODEL19912 a_0_n11917.n4 a_20000_14483.t3 0.000534617366194145f
CMODEL19913 a_0_n11917.n4 a_20000_14483.t4 0.00052293137135805f
CMODEL19914 a_0_n11917.n4 a_20000_14483.n1 0.0133271923148268f
CMODEL19915 a_9600_n35917.t0 a_n104_n35959.t0 0.000386097263582035f
CMODEL19916 a_9600_n35917.t0 a_n104_n35959.t3 0.000336937852810135f
CMODEL19917 a_9600_n35917.t0 a_n104_n35959.t4 0.000135091058961807f
CMODEL19918 a_9600_n35917.t0 a_n104_n35959.t2 0.000184900521840614f
CMODEL19919 a_9600_n35917.t0 a_n104_n35959.n0 0.0138026898899529f
CMODEL19920 a_9600_n35917.t0 a_n104_n35959.t1 0.00034217944379117f
CMODEL19921 a_9600_n35917.t0 a_n104_n35959.n1 0.00644793048115646f
CMODEL19922 a_9600_n35917.n0 a_n104_n35959.t0 0.002119372938184f
CMODEL19923 a_9600_n35917.n0 a_n104_n35959.t3 0.00184952610249178f
CMODEL19924 a_9600_n35917.n0 a_n104_n35959.t4 0.00074154458360578f
CMODEL19925 a_9600_n35917.n0 a_n104_n35959.t2 0.00101495969852124f
CMODEL19926 a_9600_n35917.n0 a_n104_n35959.n0 0.0757660055798262f
CMODEL19927 a_9600_n35917.n0 a_n104_n35959.t1 0.00187829835012485f
CMODEL19928 a_9600_n35917.n0 a_n104_n35959.n1 0.0353941109094423f
CMODEL19929 a_9600_n35917.t2 a_n104_n35959.t0 0.000783581699577741f
CMODEL19930 a_9600_n35917.t2 a_n104_n35959.t3 0.000683813018791167f
CMODEL19931 a_9600_n35917.t2 a_n104_n35959.t4 0.000274166360561522f
CMODEL19932 a_9600_n35917.t2 a_n104_n35959.t2 0.000375254317558497f
CMODEL19933 a_9600_n35917.t2 a_n104_n35959.n0 0.0280124627208496f
CMODEL19934 a_9600_n35917.t2 a_n104_n35959.t1 0.000694450791075035f
CMODEL19935 a_9600_n35917.t2 a_n104_n35959.n1 0.01308602987317f
CMODEL19936 a_9600_n35917.n1 a_n104_n35959.t0 0.0247879764824908f
CMODEL19937 a_9600_n35917.n1 a_n104_n35959.t3 0.0216318745541795f
CMODEL19938 a_9600_n35917.n1 a_n104_n35959.t4 0.00867303218228726f
CMODEL19939 a_9600_n35917.n1 a_n104_n35959.t2 0.0118708683518333f
CMODEL19940 a_9600_n35917.n1 a_n104_n35959.n0 0.886151715277752f
CMODEL19941 a_9600_n35917.n1 a_n104_n35959.t1 0.021968391919683f
CMODEL19942 a_9600_n35917.n1 a_n104_n35959.n1 0.413966024117345f
CMODEL19943 a_9600_n35917.t1 a_n104_n35959.t0 0.000411703218616242f
CMODEL19944 a_9600_n35917.t1 a_n104_n35959.t3 0.000359283557693758f
CMODEL19945 a_9600_n35917.t1 a_n104_n35959.t4 0.000144050292573584f
CMODEL19946 a_9600_n35917.t1 a_n104_n35959.t2 0.000197163117032631f
CMODEL19947 a_9600_n35917.t1 a_n104_n35959.n0 0.0147180837298218f
CMODEL19948 a_9600_n35917.t1 a_n104_n35959.t1 0.000364872770778411f
CMODEL19949 a_9600_n35917.t1 a_n104_n35959.n1 0.00687555697203704f
CMODEL19950 a_1600_n11917.t5 pc_b 6.57469169690246e-06f
CMODEL19951 a_1600_n11917.t5 pc_b.t0 2.00602742951613e-05f
CMODEL19952 a_1600_n11917.t5 pc_b.n0 0.000368794755245253f
CMODEL19953 a_1600_n11917.t5 pc_b.t1 2.00602742951613e-05f
CMODEL19954 a_1600_n11917.t5 pc_b.n1 0.000910529123834307f
CMODEL19955 a_1600_n11917.t5 pc_b.t2 2.24433971260878e-05f
CMODEL19956 a_1600_n11917.t4 pc_b 1.04506467863441e-05f
CMODEL19957 a_1600_n11917.t4 pc_b.t0 3.18863379091491e-05f
CMODEL19958 a_1600_n11917.t4 pc_b.n0 0.000586209042401209f
CMODEL19959 a_1600_n11917.t4 pc_b.t1 3.18863379091491e-05f
CMODEL19960 a_1600_n11917.t4 pc_b.n1 0.00144731018586846f
CMODEL19961 a_1600_n11917.t4 pc_b.t2 3.56743748396441e-05f
CMODEL19962 a_1600_n11917.n0 pc_b 0.00018193390723444f
CMODEL19963 a_1600_n11917.n0 pc_b.t0 0.000555104976927323f
CMODEL19964 a_1600_n11917.n0 pc_b.n0 0.0102052345391266f
CMODEL19965 a_1600_n11917.n0 pc_b.t1 0.000555104976927323f
CMODEL19966 a_1600_n11917.n0 pc_b.n1 0.0251960287701357f
CMODEL19967 a_1600_n11917.n0 pc_b.t2 0.000621050403426078f
CMODEL19968 a_1600_n11917.t6 pc_b 1.92933007321707e-05f
CMODEL19969 a_1600_n11917.t6 pc_b.t0 5.8866472009436e-05f
CMODEL19970 a_1600_n11917.t6 pc_b.n0 0.00108222080204098f
CMODEL19971 a_1600_n11917.t6 pc_b.t1 5.8866472009436e-05f
CMODEL19972 a_1600_n11917.t6 pc_b.n1 0.00267192942595492f
CMODEL19973 a_1600_n11917.t6 pc_b.t2 6.58596980918739e-05f
CMODEL19974 a_1600_n11917.n1 pc_b 0.00107182620411359f
CMODEL19975 a_1600_n11917.n1 pc_b.t0 0.00327028682750098f
CMODEL19976 a_1600_n11917.n1 pc_b.n0 0.0601220408247813f
CMODEL19977 a_1600_n11917.n1 pc_b.t1 0.00327028682750098f
CMODEL19978 a_1600_n11917.n1 pc_b.n1 0.148437222538357f
CMODEL19979 a_1600_n11917.n1 pc_b.t2 0.00365879074761814f
CMODEL19980 a_1600_n11917.t2 pc_b 1.34758186171473e-06f
CMODEL19981 a_1600_n11917.t2 pc_b.t0 4.11165466419022e-06f
CMODEL19982 a_1600_n11917.t2 pc_b.n0 7.55900269967292e-05f
CMODEL19983 a_1600_n11917.t2 pc_b.t1 4.11165466419022e-06f
CMODEL19984 a_1600_n11917.t2 pc_b.n1 0.000186626626526108f
CMODEL19985 a_1600_n11917.t2 pc_b.t2 4.600111499772e-06f
CMODEL19986 a_1600_n11917.t3 pc_b 1.34758186171473e-06f
CMODEL19987 a_1600_n11917.t3 pc_b.t0 4.11165466419022e-06f
CMODEL19988 a_1600_n11917.t3 pc_b.n0 7.55900269967292e-05f
CMODEL19989 a_1600_n11917.t3 pc_b.t1 4.11165466419022e-06f
CMODEL19990 a_1600_n11917.t3 pc_b.n1 0.000186626626526108f
CMODEL19991 a_1600_n11917.t3 pc_b.t2 4.600111499772e-06f
CMODEL19992 a_1600_n11917.n2 pc_b 0.000326896265801494f
CMODEL19993 a_1600_n11917.n2 pc_b.t0 0.000997404754527339f
CMODEL19994 a_1600_n11917.n2 pc_b.n0 0.0183366207716854f
CMODEL19995 a_1600_n11917.n2 pc_b.t1 0.000997404754527339f
CMODEL19996 a_1600_n11917.n2 pc_b.n1 0.0452718673675866f
CMODEL19997 a_1600_n11917.n2 pc_b.t2 0.00111589456215485f
CMODEL19998 a_1600_n11917.t1 pc_b 4.76086797174178e-06f
CMODEL19999 a_1600_n11917.t1 pc_b.t0 1.45260525966843e-05f
CMODEL20000 a_1600_n11917.t1 pc_b.n0 0.000267051782704987f
CMODEL20001 a_1600_n11917.t1 pc_b.t1 1.45260525966843e-05f
CMODEL20002 a_1600_n11917.t1 pc_b.n1 0.000659332656623758f
CMODEL20003 a_1600_n11917.t1 pc_b.t2 1.62517203057618e-05f
CMODEL20004 a_1600_n11917.t0 pc_b 6.54360448540719e-06f
CMODEL20005 a_1600_n11917.t0 pc_b.t0 1.996542300503e-05f
CMODEL20006 a_1600_n11917.t0 pc_b.n0 0.000367050977577312f
CMODEL20007 a_1600_n11917.t0 pc_b.t1 1.996542300503e-05f
CMODEL20008 a_1600_n11917.t0 pc_b.n1 0.000906223855579892f
CMODEL20009 a_1600_n11917.t0 pc_b.t2 2.2337277681208e-05f
CMODEL20010 a_1600_n11917.n3 pc_b 0.000907060082660239f
CMODEL20011 a_1600_n11917.n3 pc_b.t0 0.00276756308876487f
CMODEL20012 a_1600_n11917.n3 pc_b.n0 0.050879800392013f
CMODEL20013 a_1600_n11917.n3 pc_b.t1 0.00276756308876487f
CMODEL20014 a_1600_n11917.n3 pc_b.n1 0.125618760605735f
CMODEL20015 a_1600_n11917.n3 pc_b.t2 0.00309634437489393f
CMODEL20016 a_1600_n11917.n4 pc_b 0.00132989296533694f
CMODEL20017 a_1600_n11917.n4 pc_b.t0 0.00405768344703269f
CMODEL20018 a_1600_n11917.n4 pc_b.n0 0.0745978021881831f
CMODEL20019 a_1600_n11917.n4 pc_b.t1 0.00405768344703269f
CMODEL20020 a_1600_n11917.n4 pc_b.n1 0.184176891076451f
CMODEL20021 a_1600_n11917.n4 pc_b.t2 0.00453972860359511f
CMODEL20022 a a_9600_83.t0 3.87386904446388e-06f
CMODEL20023 a a_9600_83.t1 3.87386904446388e-06f
CMODEL20024 a.t3 a_9600_83.t0 2.18085592064972e-05f
CMODEL20025 a.t3 a_9600_83.t1 2.18085592064972e-05f
CMODEL20026 a.t0 a_9600_83.t0 2.25653146998823e-05f
CMODEL20027 a.t0 a_9600_83.t1 2.25653146998823e-05f
CMODEL20028 a.n0 a_9600_83.t0 0.00137771094634879f
CMODEL20029 a.n0 a_9600_83.t1 0.00137771094634879f
CMODEL20030 a.t2 a_9600_83.t0 4.30472186756193e-05f
CMODEL20031 a.t2 a_9600_83.t1 4.30472186756193e-05f
CMODEL20032 a.t1 a_9600_83.t0 2.64390920247457e-05f
CMODEL20033 a.t1 a_9600_83.t1 2.64390920247457e-05f
CMODEL20034 a_3200_169.t2 a_6400_83.t1 0.000221832374915691f
CMODEL20035 a_3200_169.t2 a_6400_83.n0 0.00250247779356323f
CMODEL20036 a_3200_169.t2 a_6400_83.t0 5.03613114626638e-05f
CMODEL20037 a_3200_169.t2 a_6400_83.t3 4.96681940507852e-05f
CMODEL20038 a_3200_169.t2 a_6400_83.t2 4.96681940507852e-05f
CMODEL20039 a_3200_169.t2 a_6400_83.n1 0.0182905091302633f
CMODEL20040 a_3200_169.n0 a_6400_83.t1 0.00398633053112204f
CMODEL20041 a_3200_169.n0 a_6400_83.n0 0.0449695570167669f
CMODEL20042 a_3200_169.n0 a_6400_83.t0 0.000904993392183001f
CMODEL20043 a_3200_169.n0 a_6400_83.t3 0.000892538063686996f
CMODEL20044 a_3200_169.n0 a_6400_83.t2 0.000892538063686996f
CMODEL20045 a_3200_169.n0 a_6400_83.n1 0.328680676134156f
CMODEL20046 a_3200_169.t1 a_6400_83.t1 0.000323853732882977f
CMODEL20047 a_3200_169.t1 a_6400_83.n0 0.00365337464926036f
CMODEL20048 a_3200_169.t1 a_6400_83.t0 7.35226258848129e-05f
CMODEL20049 a_3200_169.t1 a_6400_83.t3 7.25107417482058e-05f
CMODEL20050 a_3200_169.t1 a_6400_83.t2 7.25107417482058e-05f
CMODEL20051 a_3200_169.t1 a_6400_83.n1 0.0267023677694349f
CMODEL20052 a_3200_169.t3 a_6400_83.t1 0.000642361087476806f
CMODEL20053 a_3200_169.t3 a_6400_83.n0 0.00724643712384528f
CMODEL20054 a_3200_169.t3 a_6400_83.t0 0.000145831494659919f
CMODEL20055 a_3200_169.t3 a_6400_83.t3 0.000143824431197642f
CMODEL20056 a_3200_169.t3 a_6400_83.t2 0.000143824431197642f
CMODEL20057 a_3200_169.t3 a_6400_83.n1 0.052963916289882f
CMODEL20058 a_3200_169.t4 a_6400_83.t1 0.000143971861372262f
CMODEL20059 a_3200_169.t4 a_6400_83.n0 0.00162413798310088f
CMODEL20060 a_3200_169.t4 a_6400_83.t0 3.26850927651277e-05f
CMODEL20061 a_3200_169.t4 a_6400_83.t3 3.22352512847053e-05f
CMODEL20062 a_3200_169.t4 a_6400_83.t2 3.22352512847053e-05f
CMODEL20063 a_3200_169.t4 a_6400_83.n1 0.0118707589274612f
CMODEL20064 a_3200_169.t0 a_6400_83.t1 0.000360089920628684f
CMODEL20065 a_3200_169.t0 a_6400_83.n0 0.00406215292245643f
CMODEL20066 a_3200_169.t0 a_6400_83.t0 8.17491164409126e-05f
CMODEL20067 a_3200_169.t0 a_6400_83.t3 8.06240119834384e-05f
CMODEL20068 a_3200_169.t0 a_6400_83.t2 8.06240119834384e-05f
CMODEL20069 a_3200_169.t0 a_6400_83.n1 0.0296901116596614f
CMODEL20070 a_3200_169.n1 a_6400_83.t1 0.000325572655013941f
CMODEL20071 a_3200_169.n1 a_6400_83.n0 0.00367276570732046f
CMODEL20072 a_3200_169.n1 a_6400_83.t0 7.3912862760068e-05f
CMODEL20073 a_3200_169.n1 a_6400_83.t3 7.28956078345528e-05f
CMODEL20074 a_3200_169.n1 a_6400_83.t2 7.28956078345528e-05f
CMODEL20075 a_3200_169.n1 a_6400_83.n1 0.0268440962296858f
CMODEL20076 a_1600_n11917.t5 a_9600_n35917.t0 2.88873565192506e-06f
CMODEL20077 a_1600_n11917.t5 a_9600_n35917.n0 1.58569063905226e-05f
CMODEL20078 a_1600_n11917.t5 a_9600_n35917.t2 5.86266882796827e-06f
CMODEL20079 a_1600_n11917.t5 a_9600_n35917.n1 0.000185460810417882f
CMODEL20080 a_1600_n11917.t5 a_9600_n35917.t1 3.08031648449209e-06f
CMODEL20081 a_1600_n11917.t4 a_9600_n35917.t0 4.59172191627043e-06f
CMODEL20082 a_1600_n11917.t4 a_9600_n35917.n0 2.5204973168483e-05f
CMODEL20083 a_1600_n11917.t4 a_9600_n35917.t2 9.31886755621895e-06f
CMODEL20084 a_1600_n11917.t4 a_9600_n35917.n1 0.000294794875826582f
CMODEL20085 a_1600_n11917.t4 a_9600_n35917.t1 4.89624472958123e-06f
CMODEL20086 a_1600_n11917.n0 a_9600_n35917.t0 7.99366705468122e-05f
CMODEL20087 a_1600_n11917.n0 a_9600_n35917.n0 0.00043878999491911f
CMODEL20088 a_1600_n11917.n0 a_9600_n35917.t2 0.000162230914522782f
CMODEL20089 a_1600_n11917.n0 a_9600_n35917.n1 0.00513204442637026f
CMODEL20090 a_1600_n11917.n0 a_9600_n35917.t1 8.52380673311769e-05f
CMODEL20091 a_1600_n11917.t6 a_9600_n35917.t0 8.4769367504473e-06f
CMODEL20092 a_1600_n11917.t6 a_9600_n35917.n0 4.65317733177307e-05f
CMODEL20093 a_1600_n11917.t6 a_9600_n35917.t2 1.72038839242309e-05f
CMODEL20094 a_1600_n11917.t6 a_9600_n35917.n1 0.000544231023199167f
CMODEL20095 a_1600_n11917.t6 a_9600_n35917.t1 9.03912685572279e-06f
CMODEL20096 a_1600_n11917.n1 a_9600_n35917.t0 0.000470930457461474f
CMODEL20097 a_1600_n11917.n1 a_9600_n35917.n0 0.00258504102839463f
CMODEL20098 a_1600_n11917.n1 a_9600_n35917.t2 0.00095575007400222f
CMODEL20099 a_1600_n11917.n1 a_9600_n35917.n1 0.0302343844557276f
CMODEL20100 a_1600_n11917.n1 a_9600_n35917.t1 0.000502162546511063f
CMODEL20101 a_1600_n11917.t2 a_9600_n35917.t0 5.92089781131017e-07f
CMODEL20102 a_1600_n11917.t2 a_9600_n35917.n0 3.25011124777822e-06f
CMODEL20103 a_1600_n11917.t2 a_9600_n35917.t2 1.20164207510028e-06f
CMODEL20104 a_1600_n11917.t2 a_9600_n35917.n1 3.80129800300446e-05f
CMODEL20105 a_1600_n11917.t2 a_9600_n35917.t1 6.31357151666609e-07f
CMODEL20106 a_1600_n11917.t3 a_9600_n35917.t0 5.92089781131017e-07f
CMODEL20107 a_1600_n11917.t3 a_9600_n35917.n0 3.25011124777822e-06f
CMODEL20108 a_1600_n11917.t3 a_9600_n35917.t2 1.20164207510028e-06f
CMODEL20109 a_1600_n11917.t3 a_9600_n35917.n1 3.80129800300446e-05f
CMODEL20110 a_1600_n11917.t3 a_9600_n35917.t1 6.31357151666609e-07f
CMODEL20111 a_1600_n11917.n2 a_9600_n35917.t0 0.00014362907662223f
CMODEL20112 a_1600_n11917.n2 a_9600_n35917.n0 0.00078841164349468f
CMODEL20113 a_1600_n11917.n2 a_9600_n35917.t2 0.000291494207765904f
CMODEL20114 a_1600_n11917.n2 a_9600_n35917.n1 0.00922118468409516f
CMODEL20115 a_1600_n11917.n2 a_9600_n35917.t1 0.000153154551222783f
CMODEL20116 a_1600_n11917.t1 a_9600_n35917.t0 2.09179223575731e-06f
CMODEL20117 a_1600_n11917.t1 a_9600_n35917.n0 1.14823084101592e-05f
CMODEL20118 a_1600_n11917.t1 a_9600_n35917.t2 4.24527773144907e-06f
CMODEL20119 a_1600_n11917.t1 a_9600_n35917.n1 0.0001342959446673f
CMODEL20120 a_1600_n11917.t1 a_9600_n35917.t1 2.2305198129299e-06f
CMODEL20121 a_1600_n11917.t0 a_9600_n35917.t0 2.8750768006351e-06f
CMODEL20122 a_1600_n11917.t0 a_9600_n35917.n0 1.57819299467062e-05f
CMODEL20123 a_1600_n11917.t0 a_9600_n35917.t2 5.83494828468141e-06f
CMODEL20124 a_1600_n11917.t0 a_9600_n35917.n1 0.000184583893338978f
CMODEL20125 a_1600_n11917.t0 a_9600_n35917.t1 3.06575177873245e-06f
CMODEL20126 a_1600_n11917.n3 a_9600_n35917.t0 0.000398536831841591f
CMODEL20127 a_1600_n11917.n3 a_9600_n35917.n0 0.0021876564688348f
CMODEL20128 a_1600_n11917.n3 a_9600_n35917.t2 0.000808827716471008f
CMODEL20129 a_1600_n11917.n3 a_9600_n35917.n1 0.0255866139102971f
CMODEL20130 a_1600_n11917.n3 a_9600_n35917.t1 0.000424967778543814f
CMODEL20131 a_1600_n11917.n4 a_9600_n35917.t0 0.000584317774782214f
CMODEL20132 a_1600_n11917.n4 a_9600_n35917.n0 0.00320744899273339f
CMODEL20133 a_1600_n11917.n4 a_9600_n35917.t2 0.00118586884250229f
CMODEL20134 a_1600_n11917.n4 a_9600_n35917.n1 0.0375140065102414f
CMODEL20135 a_1600_n11917.n4 a_9600_n35917.t1 0.000623069706168492f
CMODEL20136 pc_b vdd 1.56174095361252e-07f
CMODEL20137 pc_b vdd.n0 5.24091202416595e-05f
CMODEL20138 pc_b vdd.n1 4.8567928939546e-06f
CMODEL20139 pc_b vdd.t7 4.00376530480851e-07f
CMODEL20140 pc_b vdd.t6 3.16476902931708e-06f
CMODEL20141 pc_b vdd.n2 4.35528161787666e-06f
CMODEL20142 pc_b vdd.t27 4.00376530480851e-07f
CMODEL20143 pc_b vdd.t26 3.16476902931708e-06f
CMODEL20144 pc_b vdd.n3 8.16889438400407e-06f
CMODEL20145 pc_b vdd.n4 4.35528161787666e-06f
CMODEL20146 pc_b vdd.t36 4.00376530480851e-07f
CMODEL20147 pc_b vdd.t35 3.16476902931708e-06f
CMODEL20148 pc_b vdd.n5 6.21430231957075e-06f
CMODEL20149 pc_b vdd.t3 6.37775648830781e-07f
CMODEL20150 pc_b vdd.n6 6.10193445486122e-06f
CMODEL20151 pc_b vdd.t2 7.99700529069677e-06f
CMODEL20152 pc_b vdd.n7 8.17989645953046e-06f
CMODEL20153 pc_b vdd.t25 6.37775648830781e-07f
CMODEL20154 pc_b vdd.n8 3.6856219541704e-06f
CMODEL20155 pc_b vdd.t24 7.99700529069677e-06f
CMODEL20156 pc_b vdd.n9 8.17989645953046e-06f
CMODEL20157 pc_b vdd.t5 6.37775648830781e-07f
CMODEL20158 pc_b vdd.n10 1.09134721448173e-05f
CMODEL20159 pc_b vdd.t4 8.00140612090733e-06f
CMODEL20160 pc_b vdd.n11 2.63869378594722e-05f
CMODEL20161 pc_b vdd.n12 6.50604068894552e-05f
CMODEL20162 pc_b vdd.n13 4.93149698677879e-06f
CMODEL20163 pc_b vdd.t42 4.00376530480851e-07f
CMODEL20164 pc_b vdd.t41 3.16476902931708e-06f
CMODEL20165 pc_b vdd.n14 4.43379976355e-06f
CMODEL20166 pc_b vdd.t9 4.00376530480851e-07f
CMODEL20167 pc_b vdd.t8 3.16476902931708e-06f
CMODEL20168 pc_b vdd.n15 8.51230583476778e-06f
CMODEL20169 pc_b vdd.t15 6.74273200710325e-07f
CMODEL20170 pc_b vdd.n16 5.30369720183655e-06f
CMODEL20171 pc_b vdd.t14 9.09552585842171e-06f
CMODEL20172 pc_b vdd.n17 7.42933486712015e-06f
CMODEL20173 pc_b vdd.t32 9.09552585842171e-06f
CMODEL20174 pc_b vdd.n18 7.33376350438091e-06f
CMODEL20175 pc_b vdd.t34 6.74273200710325e-07f
CMODEL20176 pc_b vdd.n19 7.38517987067424e-06f
CMODEL20177 pc_b vdd.t33 9.09552585842171e-06f
CMODEL20178 pc_b vdd.n20 1.47381970072263e-05f
CMODEL20179 pc_b vdd.t48 9.1129091377534e-06f
CMODEL20180 pc_b vdd.n21 2.61619087413725e-05f
CMODEL20181 pc_b vdd.n22 0.000114651162117105f
CMODEL20182 pc_b vdd.t47 1.29621686285863e-07f
CMODEL20183 pc_b vdd.t45 1.28290801883021e-07f
CMODEL20184 pc_b vdd.n23 1.46493369105582e-06f
CMODEL20185 pc_b vdd.t46 3.49614420945492e-06f
CMODEL20186 pc_b vdd.n24 3.75629195263492e-06f
CMODEL20187 pc_b vdd.t44 3.49614420945492e-06f
CMODEL20188 pc_b vdd.n25 5.9240308935995e-06f
CMODEL20189 pc_b vdd.t43 3.50371730477558e-06f
CMODEL20190 pc_b vdd.n26 3.16969062443588e-05f
CMODEL20191 pc_b vdd.n27 2.11900341374118e-05f
CMODEL20192 pc_b vdd.n28 4.78645295775588e-06f
CMODEL20193 pc_b vdd.t29 4.00376530480851e-07f
CMODEL20194 pc_b vdd.t28 3.16476902931708e-06f
CMODEL20195 pc_b vdd.n29 7.14496788834806e-07f
CMODEL20196 pc_b vdd.n30 2.27940267284042e-07f
CMODEL20197 pc_b vdd.t38 1.04948798446232e-07f
CMODEL20198 pc_b vdd.t40 1.04948798446232e-07f
CMODEL20199 pc_b vdd.t37 2.12070140073076e-06f
CMODEL20200 pc_b vdd.t39 2.12070140073076e-06f
CMODEL20201 pc_b vdd.n31 6.8684490567848e-07f
CMODEL20202 pc_b vdd.n32 8.28878033365663e-06f
CMODEL20203 pc_b vdd.n33 4.19993231144404e-06f
CMODEL20204 pc_b vdd.t17 4.00376530480851e-07f
CMODEL20205 pc_b vdd.t16 3.16476902931708e-06f
CMODEL20206 pc_b vdd.n34 7.14496788834806e-07f
CMODEL20207 pc_b vdd.n35 2.27940267284042e-07f
CMODEL20208 pc_b vdd.t1 1.04948798446232e-07f
CMODEL20209 pc_b vdd.t31 1.04948798446232e-07f
CMODEL20210 pc_b vdd.t0 2.12070140073076e-06f
CMODEL20211 pc_b vdd.t30 2.12070140073076e-06f
CMODEL20212 pc_b vdd.n36 6.8684490567848e-07f
CMODEL20213 pc_b vdd.n37 8.03848311543126e-06f
CMODEL20214 pc_b vdd.n38 4.63697142493733e-06f
CMODEL20215 pc_b vdd.t19 4.00376530480851e-07f
CMODEL20216 pc_b vdd.t18 3.16476902931708e-06f
CMODEL20217 pc_b vdd.n39 3.91296150813071e-06f
CMODEL20218 pc_b vdd.t21 4.0038019783936e-07f
CMODEL20219 pc_b vdd.t20 3.16476902931708e-06f
CMODEL20220 pc_b vdd.n40 3.91296150813071e-06f
CMODEL20221 pc_b vdd.t11 4.00376530480851e-07f
CMODEL20222 pc_b vdd.t10 3.16476902931708e-06f
CMODEL20223 pc_b vdd.n41 1.6834275762929e-05f
CMODEL20224 pc_b vdd.n42 3.22460198338809e-05f
CMODEL20225 pc_b vdd.n43 3.91296150813071e-06f
CMODEL20226 pc_b vdd.t13 4.00376530480851e-07f
CMODEL20227 pc_b vdd.t12 3.16476902931708e-06f
CMODEL20228 pc_b vdd.n44 3.91296150813071e-06f
CMODEL20229 pc_b vdd.t23 4.00376530480851e-07f
CMODEL20230 pc_b vdd.t22 3.16476902931708e-06f
CMODEL20231 pc_b vdd.n45 4.83038791269126e-06f
CMODEL20232 pc_b vdd.n46 7.97305743963433e-05f
CMODEL20233 pc_b.t0 vdd 4.76508304141684e-07f
CMODEL20234 pc_b.t0 vdd.n0 0.00015990731977761f
CMODEL20235 pc_b.t0 vdd.n1 1.48187325184269e-05f
CMODEL20236 pc_b.t0 vdd.t7 1.22160298810283e-06f
CMODEL20237 pc_b.t0 vdd.t6 9.65613868082092e-06f
CMODEL20238 pc_b.t0 vdd.n2 1.32885537322521e-05f
CMODEL20239 pc_b.t0 vdd.t27 1.22160298810283e-06f
CMODEL20240 pc_b.t0 vdd.t26 9.65613868082092e-06f
CMODEL20241 pc_b.t0 vdd.n3 2.49244024793632e-05f
CMODEL20242 pc_b.t0 vdd.n4 1.32885537322521e-05f
CMODEL20243 pc_b.t0 vdd.t36 1.22160298810283e-06f
CMODEL20244 pc_b.t0 vdd.t35 9.65613868082092e-06f
CMODEL20245 pc_b.t0 vdd.n5 1.89606775238416e-05f
CMODEL20246 pc_b.t0 vdd.t3 1.94593983172588e-06f
CMODEL20247 pc_b.t0 vdd.n6 1.86178279588807e-05f
CMODEL20248 pc_b.t0 vdd.t2 2.43999455893595e-05f
CMODEL20249 pc_b.t0 vdd.n7 2.49579713009978e-05f
CMODEL20250 pc_b.t0 vdd.t25 1.94593983172588e-06f
CMODEL20251 pc_b.t0 vdd.n8 1.12453314554293e-05f
CMODEL20252 pc_b.t0 vdd.t24 2.43999455893595e-05f
CMODEL20253 pc_b.t0 vdd.n9 2.49579713009978e-05f
CMODEL20254 pc_b.t0 vdd.t5 1.94593983172588e-06f
CMODEL20255 pc_b.t0 vdd.n10 3.32984807243175e-05f
CMODEL20256 pc_b.t0 vdd.t4 2.44133731180133e-05f
CMODEL20257 pc_b.t0 vdd.n11 8.05101190554339e-05f
CMODEL20258 pc_b.t0 vdd.n12 0.000198508107775177f
CMODEL20259 pc_b.t0 vdd.n13 1.50466648173254e-05f
CMODEL20260 pc_b.t0 vdd.t42 1.22160298810283e-06f
CMODEL20261 pc_b.t0 vdd.t41 9.65613868082092e-06f
CMODEL20262 pc_b.t0 vdd.n14 1.35281232226506e-05f
CMODEL20263 pc_b.t0 vdd.t9 1.22160298810283e-06f
CMODEL20264 pc_b.t0 vdd.t8 9.65613868082092e-06f
CMODEL20265 pc_b.t0 vdd.n15 2.59721972986496e-05f
CMODEL20266 pc_b.t0 vdd.t15 2.05729880269489e-06f
CMODEL20267 pc_b.t0 vdd.n16 1.61822980532222e-05f
CMODEL20268 pc_b.t0 vdd.t14 2.77516805334969e-05f
CMODEL20269 pc_b.t0 vdd.n17 2.26679062890889e-05f
CMODEL20270 pc_b.t0 vdd.t32 2.77516805334969e-05f
CMODEL20271 pc_b.t0 vdd.n18 2.23763051251568e-05f
CMODEL20272 pc_b.t0 vdd.t34 2.05729880269489e-06f
CMODEL20273 pc_b.t0 vdd.n19 2.25331834182623e-05f
CMODEL20274 pc_b.t0 vdd.t33 2.77516805334969e-05f
CMODEL20275 pc_b.t0 vdd.n20 4.49682339812795e-05f
CMODEL20276 pc_b.t0 vdd.t48 2.78047192716795e-05f
CMODEL20277 pc_b.t0 vdd.n21 7.98235247569352e-05f
CMODEL20278 pc_b.t0 vdd.n22 0.000349816214410737f
CMODEL20279 pc_b.t0 vdd.t47 3.95493310008866e-07f
CMODEL20280 pc_b.t0 vdd.t45 3.91432601551807e-07f
CMODEL20281 pc_b.t0 vdd.n23 4.46971097985445e-06f
CMODEL20282 pc_b.t0 vdd.t46 1.06672092092391e-05f
CMODEL20283 pc_b.t0 vdd.n24 1.14609551863952e-05f
CMODEL20284 pc_b.t0 vdd.t44 1.06672092092391e-05f
CMODEL20285 pc_b.t0 vdd.n25 1.80750201130501e-05f
CMODEL20286 pc_b.t0 vdd.t43 1.06903157481309e-05f
CMODEL20287 pc_b.t0 vdd.n26 9.67115513369877e-05f
CMODEL20288 pc_b.t0 vdd.n27 6.4653662364211e-05f
CMODEL20289 pc_b.t0 vdd.n28 1.460411585211e-05f
CMODEL20290 pc_b.t0 vdd.t29 1.22160298810283e-06f
CMODEL20291 pc_b.t0 vdd.t28 9.65613868082092e-06f
CMODEL20292 pc_b.t0 vdd.n29 2.1800264145908e-06f
CMODEL20293 pc_b.t0 vdd.n30 6.95476608703117e-07f
CMODEL20294 pc_b.t0 vdd.t38 3.20212989571951e-07f
CMODEL20295 pc_b.t0 vdd.t40 3.20212989571951e-07f
CMODEL20296 pc_b.t0 vdd.t37 6.47054702456003e-06f
CMODEL20297 pc_b.t0 vdd.t39 6.47054702456003e-06f
CMODEL20298 pc_b.t0 vdd.n31 2.09565677621597e-06f
CMODEL20299 pc_b.t0 vdd.n32 2.52901907391077e-05f
CMODEL20300 pc_b.t0 vdd.n33 1.28145619707722e-05f
CMODEL20301 pc_b.t0 vdd.t17 1.22160298810283e-06f
CMODEL20302 pc_b.t0 vdd.t16 9.65613868082092e-06f
CMODEL20303 pc_b.t0 vdd.n34 2.1800264145908e-06f
CMODEL20304 pc_b.t0 vdd.n35 6.95476608703117e-07f
CMODEL20305 pc_b.t0 vdd.t1 3.20212989571951e-07f
CMODEL20306 pc_b.t0 vdd.t31 3.20212989571951e-07f
CMODEL20307 pc_b.t0 vdd.t0 6.47054702456003e-06f
CMODEL20308 pc_b.t0 vdd.t30 6.47054702456003e-06f
CMODEL20309 pc_b.t0 vdd.n36 2.09565677621597e-06f
CMODEL20310 pc_b.t0 vdd.n37 2.45265000469217e-05f
CMODEL20311 pc_b.t0 vdd.n38 1.41480274621686e-05f
CMODEL20312 pc_b.t0 vdd.t19 1.22160298810283e-06f
CMODEL20313 pc_b.t0 vdd.t18 9.65613868082092e-06f
CMODEL20314 pc_b.t0 vdd.n39 1.19389752064711e-05f
CMODEL20315 pc_b.t0 vdd.t21 1.22161417771004e-06f
CMODEL20316 pc_b.t0 vdd.t20 9.65613868082092e-06f
CMODEL20317 pc_b.t0 vdd.n40 1.19389752064711e-05f
CMODEL20318 pc_b.t0 vdd.t11 1.22160298810283e-06f
CMODEL20319 pc_b.t0 vdd.t10 9.65613868082092e-06f
CMODEL20320 pc_b.t0 vdd.n41 5.13636539830215e-05f
CMODEL20321 pc_b.t0 vdd.n42 9.8386971224768e-05f
CMODEL20322 pc_b.t0 vdd.n43 1.19389752064711e-05f
CMODEL20323 pc_b.t0 vdd.t13 1.22160298810283e-06f
CMODEL20324 pc_b.t0 vdd.t12 9.65613868082092e-06f
CMODEL20325 pc_b.t0 vdd.n44 1.19389752064711e-05f
CMODEL20326 pc_b.t0 vdd.t23 1.22160298810283e-06f
CMODEL20327 pc_b.t0 vdd.t22 9.65613868082092e-06f
CMODEL20328 pc_b.t0 vdd.n45 1.47381673465039e-05f
CMODEL20329 pc_b.t0 vdd.n46 0.000243268774542683f
CMODEL20330 pc_b.n0 vdd 8.76028716320451e-06f
CMODEL20331 pc_b.n0 vdd.n0 0.00293978935639644f
CMODEL20332 pc_b.n0 vdd.n1 0.000272432507739754f
CMODEL20333 pc_b.n0 vdd.t7 2.24583556722812e-05f
CMODEL20334 pc_b.n0 vdd.t6 0.000177521665407464f
CMODEL20335 pc_b.n0 vdd.n2 0.000244301191954858f
CMODEL20336 pc_b.n0 vdd.t27 2.24583556722812e-05f
CMODEL20337 pc_b.n0 vdd.t26 0.000177521665407464f
CMODEL20338 pc_b.n0 vdd.n3 0.000458218505727418f
CMODEL20339 pc_b.n0 vdd.n4 0.000244301191954858f
CMODEL20340 pc_b.n0 vdd.t36 2.24583556722812e-05f
CMODEL20341 pc_b.n0 vdd.t35 0.000177521665407464f
CMODEL20342 pc_b.n0 vdd.n5 0.000348579402444961f
CMODEL20343 pc_b.n0 vdd.t3 3.57748051399497e-05f
CMODEL20344 pc_b.n0 vdd.n6 0.000342276342001456f
CMODEL20345 pc_b.n0 vdd.t2 0.000448576715812697f
CMODEL20346 pc_b.n0 vdd.n7 0.000458835646110268f
CMODEL20347 pc_b.n0 vdd.t25 3.57748051399497e-05f
CMODEL20348 pc_b.n0 vdd.n8 0.00020673791398541f
CMODEL20349 pc_b.n0 vdd.t24 0.000448576715812697f
CMODEL20350 pc_b.n0 vdd.n9 0.000458835646110268f
CMODEL20351 pc_b.n0 vdd.t5 3.57748051399497e-05f
CMODEL20352 pc_b.n0 vdd.n10 0.000612170345633089f
CMODEL20353 pc_b.n0 vdd.t4 0.000448823571965837f
CMODEL20354 pc_b.n0 vdd.n11 0.00148012480861126f
CMODEL20355 pc_b.n0 vdd.n12 0.00364943908263524f
CMODEL20356 pc_b.n0 vdd.n13 0.000276622890939303f
CMODEL20357 pc_b.n0 vdd.t42 2.24583556722812e-05f
CMODEL20358 pc_b.n0 vdd.t41 0.000177521665407464f
CMODEL20359 pc_b.n0 vdd.n14 0.000248705517153794f
CMODEL20360 pc_b.n0 vdd.t9 2.24583556722812e-05f
CMODEL20361 pc_b.n0 vdd.t8 0.000177521665407464f
CMODEL20362 pc_b.n0 vdd.n15 0.000477481514210765f
CMODEL20363 pc_b.n0 vdd.t15 3.78220655033229e-05f
CMODEL20364 pc_b.n0 vdd.n16 0.000297500750091106f
CMODEL20365 pc_b.n0 vdd.t14 0.000510196125905624f
CMODEL20366 pc_b.n0 vdd.n17 0.000416734329192265f
CMODEL20367 pc_b.n0 vdd.t32 0.000510196125905624f
CMODEL20368 pc_b.n0 vdd.n18 0.000411373436399911f
CMODEL20369 pc_b.n0 vdd.t34 3.78220655033229e-05f
CMODEL20370 pc_b.n0 vdd.n19 0.000414257539122429f
CMODEL20371 pc_b.n0 vdd.t33 0.000510196125905624f
CMODEL20372 pc_b.n0 vdd.n20 0.000826710971192327f
CMODEL20373 pc_b.n0 vdd.t48 0.000511171207710526f
CMODEL20374 pc_b.n0 vdd.n21 0.00146750223064737f
CMODEL20375 pc_b.n0 vdd.n22 0.00643113764429169f
CMODEL20376 pc_b.n0 vdd.t47 7.2708805632352e-06f
CMODEL20377 pc_b.n0 vdd.t45 7.19622714825648e-06f
CMODEL20378 pc_b.n0 vdd.n23 8.21726534033511e-05f
CMODEL20379 pc_b.n0 vdd.t46 0.000196109522311973f
CMODEL20380 pc_b.n0 vdd.n24 0.000210702012377914f
CMODEL20381 pc_b.n0 vdd.t44 0.000196109522311973f
CMODEL20382 pc_b.n0 vdd.n25 0.000332297182010778f
CMODEL20383 pc_b.n0 vdd.t43 0.000196534320608835f
CMODEL20384 pc_b.n0 vdd.n26 0.00177797732872059f
CMODEL20385 pc_b.n0 vdd.n27 0.00118861443450301f
CMODEL20386 pc_b.n0 vdd.n28 0.000268486923558735f
CMODEL20387 pc_b.n0 vdd.t29 2.24583556722812e-05f
CMODEL20388 pc_b.n0 vdd.t28 0.000177521665407464f
CMODEL20389 pc_b.n0 vdd.n29 4.00783307430212e-05f
CMODEL20390 pc_b.n0 vdd.n30 1.27858733091866e-05f
CMODEL20391 pc_b.n0 vdd.t38 5.88690211200269e-06f
CMODEL20392 pc_b.n0 vdd.t40 5.88690211200269e-06f
CMODEL20393 pc_b.n0 vdd.t37 0.000118956688782721f
CMODEL20394 pc_b.n0 vdd.t39 0.000118956688782721f
CMODEL20395 pc_b.n0 vdd.n31 3.85272512474591e-05f
CMODEL20396 pc_b.n0 vdd.n32 0.000464943278765869f
CMODEL20397 pc_b.n0 vdd.n33 0.000235587169749021f
CMODEL20398 pc_b.n0 vdd.t17 2.24583556722812e-05f
CMODEL20399 pc_b.n0 vdd.t16 0.000177521665407464f
CMODEL20400 pc_b.n0 vdd.n34 4.00783307430212e-05f
CMODEL20401 pc_b.n0 vdd.n35 1.27858733091866e-05f
CMODEL20402 pc_b.n0 vdd.t1 5.88690211200269e-06f
CMODEL20403 pc_b.n0 vdd.t31 5.88690211200269e-06f
CMODEL20404 pc_b.n0 vdd.t0 0.000118956688782721f
CMODEL20405 pc_b.n0 vdd.t30 0.000118956688782721f
CMODEL20406 pc_b.n0 vdd.n36 3.85272512474591e-05f
CMODEL20407 pc_b.n0 vdd.n37 0.00045090333505604f
CMODEL20408 pc_b.n0 vdd.n38 0.000260102042890418f
CMODEL20409 pc_b.n0 vdd.t19 2.24583556722812e-05f
CMODEL20410 pc_b.n0 vdd.t18 0.000177521665407464f
CMODEL20411 pc_b.n0 vdd.n39 0.000219490091429693f
CMODEL20412 pc_b.n0 vdd.t21 2.24585613857421e-05f
CMODEL20413 pc_b.n0 vdd.t20 0.000177521665407464f
CMODEL20414 pc_b.n0 vdd.n40 0.000219490091429693f
CMODEL20415 pc_b.n0 vdd.t11 2.24583556722812e-05f
CMODEL20416 pc_b.n0 vdd.t10 0.000177521665407464f
CMODEL20417 pc_b.n0 vdd.n41 0.000944286499798231f
CMODEL20418 pc_b.n0 vdd.n42 0.00180877880522861f
CMODEL20419 pc_b.n0 vdd.n43 0.000219490091429693f
CMODEL20420 pc_b.n0 vdd.t13 2.24583556722812e-05f
CMODEL20421 pc_b.n0 vdd.t12 0.000177521665407464f
CMODEL20422 pc_b.n0 vdd.n44 0.000219490091429693f
CMODEL20423 pc_b.n0 vdd.t23 2.24583556722812e-05f
CMODEL20424 pc_b.n0 vdd.t22 0.000177521665407464f
CMODEL20425 pc_b.n0 vdd.n45 0.000270951370820914f
CMODEL20426 pc_b.n0 vdd.n46 0.00447233406912694f
CMODEL20427 pc_b.t1 vdd 4.76508304141684e-07f
CMODEL20428 pc_b.t1 vdd.n0 0.00015990731977761f
CMODEL20429 pc_b.t1 vdd.n1 1.48187325184269e-05f
CMODEL20430 pc_b.t1 vdd.t7 1.22160298810283e-06f
CMODEL20431 pc_b.t1 vdd.t6 9.65613868082092e-06f
CMODEL20432 pc_b.t1 vdd.n2 1.32885537322521e-05f
CMODEL20433 pc_b.t1 vdd.t27 1.22160298810283e-06f
CMODEL20434 pc_b.t1 vdd.t26 9.65613868082092e-06f
CMODEL20435 pc_b.t1 vdd.n3 2.49244024793632e-05f
CMODEL20436 pc_b.t1 vdd.n4 1.32885537322521e-05f
CMODEL20437 pc_b.t1 vdd.t36 1.22160298810283e-06f
CMODEL20438 pc_b.t1 vdd.t35 9.65613868082092e-06f
CMODEL20439 pc_b.t1 vdd.n5 1.89606775238416e-05f
CMODEL20440 pc_b.t1 vdd.t3 1.94593983172588e-06f
CMODEL20441 pc_b.t1 vdd.n6 1.86178279588807e-05f
CMODEL20442 pc_b.t1 vdd.t2 2.43999455893595e-05f
CMODEL20443 pc_b.t1 vdd.n7 2.49579713009978e-05f
CMODEL20444 pc_b.t1 vdd.t25 1.94593983172588e-06f
CMODEL20445 pc_b.t1 vdd.n8 1.12453314554293e-05f
CMODEL20446 pc_b.t1 vdd.t24 2.43999455893595e-05f
CMODEL20447 pc_b.t1 vdd.n9 2.49579713009978e-05f
CMODEL20448 pc_b.t1 vdd.t5 1.94593983172588e-06f
CMODEL20449 pc_b.t1 vdd.n10 3.32984807243175e-05f
CMODEL20450 pc_b.t1 vdd.t4 2.44133731180133e-05f
CMODEL20451 pc_b.t1 vdd.n11 8.05101190554339e-05f
CMODEL20452 pc_b.t1 vdd.n12 0.000198508107775177f
CMODEL20453 pc_b.t1 vdd.n13 1.50466648173254e-05f
CMODEL20454 pc_b.t1 vdd.t42 1.22160298810283e-06f
CMODEL20455 pc_b.t1 vdd.t41 9.65613868082092e-06f
CMODEL20456 pc_b.t1 vdd.n14 1.35281232226506e-05f
CMODEL20457 pc_b.t1 vdd.t9 1.22160298810283e-06f
CMODEL20458 pc_b.t1 vdd.t8 9.65613868082092e-06f
CMODEL20459 pc_b.t1 vdd.n15 2.59721972986496e-05f
CMODEL20460 pc_b.t1 vdd.t15 2.05729880269489e-06f
CMODEL20461 pc_b.t1 vdd.n16 1.61822980532222e-05f
CMODEL20462 pc_b.t1 vdd.t14 2.77516805334969e-05f
CMODEL20463 pc_b.t1 vdd.n17 2.26679062890889e-05f
CMODEL20464 pc_b.t1 vdd.t32 2.77516805334969e-05f
CMODEL20465 pc_b.t1 vdd.n18 2.23763051251568e-05f
CMODEL20466 pc_b.t1 vdd.t34 2.05729880269489e-06f
CMODEL20467 pc_b.t1 vdd.n19 2.25331834182623e-05f
CMODEL20468 pc_b.t1 vdd.t33 2.77516805334969e-05f
CMODEL20469 pc_b.t1 vdd.n20 4.49682339812795e-05f
CMODEL20470 pc_b.t1 vdd.t48 2.78047192716795e-05f
CMODEL20471 pc_b.t1 vdd.n21 7.98235247569352e-05f
CMODEL20472 pc_b.t1 vdd.n22 0.000349816214410737f
CMODEL20473 pc_b.t1 vdd.t47 3.95493310008866e-07f
CMODEL20474 pc_b.t1 vdd.t45 3.91432601551807e-07f
CMODEL20475 pc_b.t1 vdd.n23 4.46971097985445e-06f
CMODEL20476 pc_b.t1 vdd.t46 1.06672092092391e-05f
CMODEL20477 pc_b.t1 vdd.n24 1.14609551863952e-05f
CMODEL20478 pc_b.t1 vdd.t44 1.06672092092391e-05f
CMODEL20479 pc_b.t1 vdd.n25 1.80750201130501e-05f
CMODEL20480 pc_b.t1 vdd.t43 1.06903157481309e-05f
CMODEL20481 pc_b.t1 vdd.n26 9.67115513369877e-05f
CMODEL20482 pc_b.t1 vdd.n27 6.4653662364211e-05f
CMODEL20483 pc_b.t1 vdd.n28 1.460411585211e-05f
CMODEL20484 pc_b.t1 vdd.t29 1.22160298810283e-06f
CMODEL20485 pc_b.t1 vdd.t28 9.65613868082092e-06f
CMODEL20486 pc_b.t1 vdd.n29 2.1800264145908e-06f
CMODEL20487 pc_b.t1 vdd.n30 6.95476608703117e-07f
CMODEL20488 pc_b.t1 vdd.t38 3.20212989571951e-07f
CMODEL20489 pc_b.t1 vdd.t40 3.20212989571951e-07f
CMODEL20490 pc_b.t1 vdd.t37 6.47054702456003e-06f
CMODEL20491 pc_b.t1 vdd.t39 6.47054702456003e-06f
CMODEL20492 pc_b.t1 vdd.n31 2.09565677621597e-06f
CMODEL20493 pc_b.t1 vdd.n32 2.52901907391077e-05f
CMODEL20494 pc_b.t1 vdd.n33 1.28145619707722e-05f
CMODEL20495 pc_b.t1 vdd.t17 1.22160298810283e-06f
CMODEL20496 pc_b.t1 vdd.t16 9.65613868082092e-06f
CMODEL20497 pc_b.t1 vdd.n34 2.1800264145908e-06f
CMODEL20498 pc_b.t1 vdd.n35 6.95476608703117e-07f
CMODEL20499 pc_b.t1 vdd.t1 3.20212989571951e-07f
CMODEL20500 pc_b.t1 vdd.t31 3.20212989571951e-07f
CMODEL20501 pc_b.t1 vdd.t0 6.47054702456003e-06f
CMODEL20502 pc_b.t1 vdd.t30 6.47054702456003e-06f
CMODEL20503 pc_b.t1 vdd.n36 2.09565677621597e-06f
CMODEL20504 pc_b.t1 vdd.n37 2.45265000469217e-05f
CMODEL20505 pc_b.t1 vdd.n38 1.41480274621686e-05f
CMODEL20506 pc_b.t1 vdd.t19 1.22160298810283e-06f
CMODEL20507 pc_b.t1 vdd.t18 9.65613868082092e-06f
CMODEL20508 pc_b.t1 vdd.n39 1.19389752064711e-05f
CMODEL20509 pc_b.t1 vdd.t21 1.22161417771004e-06f
CMODEL20510 pc_b.t1 vdd.t20 9.65613868082092e-06f
CMODEL20511 pc_b.t1 vdd.n40 1.19389752064711e-05f
CMODEL20512 pc_b.t1 vdd.t11 1.22160298810283e-06f
CMODEL20513 pc_b.t1 vdd.t10 9.65613868082092e-06f
CMODEL20514 pc_b.t1 vdd.n41 5.13636539830215e-05f
CMODEL20515 pc_b.t1 vdd.n42 9.8386971224768e-05f
CMODEL20516 pc_b.t1 vdd.n43 1.19389752064711e-05f
CMODEL20517 pc_b.t1 vdd.t13 1.22160298810283e-06f
CMODEL20518 pc_b.t1 vdd.t12 9.65613868082092e-06f
CMODEL20519 pc_b.t1 vdd.n44 1.19389752064711e-05f
CMODEL20520 pc_b.t1 vdd.t23 1.22160298810283e-06f
CMODEL20521 pc_b.t1 vdd.t22 9.65613868082092e-06f
CMODEL20522 pc_b.t1 vdd.n45 1.47381673465039e-05f
CMODEL20523 pc_b.t1 vdd.n46 0.000243268774542683f
CMODEL20524 pc_b.n1 vdd 2.16285521466949e-05f
CMODEL20525 pc_b.n1 vdd.n0 0.00725813962608277f
CMODEL20526 pc_b.n1 vdd.n1 0.000672617300132967f
CMODEL20527 pc_b.n1 vdd.t7 5.54481500135287e-05f
CMODEL20528 pc_b.n1 vdd.t6 0.000438288896916588f
CMODEL20529 pc_b.n1 vdd.n2 0.000603162998113695f
CMODEL20530 pc_b.n1 vdd.t27 5.54481500135287e-05f
CMODEL20531 pc_b.n1 vdd.t26 0.000438288896916588f
CMODEL20532 pc_b.n1 vdd.n3 0.00113131027112138f
CMODEL20533 pc_b.n1 vdd.n4 0.000603162998113695f
CMODEL20534 pc_b.n1 vdd.t36 5.54481500135287e-05f
CMODEL20535 pc_b.n1 vdd.t35 0.000438288896916588f
CMODEL20536 pc_b.n1 vdd.n5 0.000860618795090583f
CMODEL20537 pc_b.n1 vdd.t3 8.83255564677413e-05f
CMODEL20538 pc_b.n1 vdd.n6 0.000845056968298111f
CMODEL20539 pc_b.n1 vdd.t2 0.00110750534874008f
CMODEL20540 pc_b.n1 vdd.n7 0.00113283394867939f
CMODEL20541 pc_b.n1 vdd.t25 8.83255564677413e-05f
CMODEL20542 pc_b.n1 vdd.n8 0.000510421824082842f
CMODEL20543 pc_b.n1 vdd.t24 0.00110750534874008f
CMODEL20544 pc_b.n1 vdd.n9 0.00113283394867939f
CMODEL20545 pc_b.n1 vdd.t5 8.83255564677413e-05f
CMODEL20546 pc_b.n1 vdd.n10 0.00151140687474247f
CMODEL20547 pc_b.n1 vdd.t4 0.00110811481976328f
CMODEL20548 pc_b.n1 vdd.n11 0.00365432730802799f
CMODEL20549 pc_b.n1 vdd.n12 0.00901021645003805f
CMODEL20550 pc_b.n1 vdd.n13 0.000682963070751853f
CMODEL20551 pc_b.n1 vdd.t42 5.54481500135287e-05f
CMODEL20552 pc_b.n1 vdd.t41 0.000438288896916588f
CMODEL20553 pc_b.n1 vdd.n14 0.00061403697695269f
CMODEL20554 pc_b.n1 vdd.t9 5.54481500135287e-05f
CMODEL20555 pc_b.n1 vdd.t8 0.000438288896916588f
CMODEL20556 pc_b.n1 vdd.n15 0.00117886932663206f
CMODEL20557 pc_b.n1 vdd.t15 9.33801028201786e-05f
CMODEL20558 pc_b.n1 vdd.n16 0.000734509082539319f
CMODEL20559 pc_b.n1 vdd.t14 0.00125963947398215f
CMODEL20560 pc_b.n1 vdd.n17 0.00102888866567197f
CMODEL20561 pc_b.n1 vdd.t32 0.00125963947398215f
CMODEL20562 pc_b.n1 vdd.n18 0.00101565298661806f
CMODEL20563 pc_b.n1 vdd.t34 9.33801028201786e-05f
CMODEL20564 pc_b.n1 vdd.n19 0.00102277363973916f
CMODEL20565 pc_b.n1 vdd.t33 0.00125963947398215f
CMODEL20566 pc_b.n1 vdd.n20 0.00204109306208374f
CMODEL20567 pc_b.n1 vdd.t48 0.0012620468845238f
CMODEL20568 pc_b.n1 vdd.n21 0.0036231630230415f
CMODEL20569 pc_b.n1 vdd.n22 0.0158780406750107f
CMODEL20570 pc_b.n1 vdd.t47 1.79513087281944e-05f
CMODEL20571 pc_b.n1 vdd.t45 1.77669945329272e-05f
CMODEL20572 pc_b.n1 vdd.n23 0.000202878682634022f
CMODEL20573 pc_b.n1 vdd.t46 0.0004841810491788f
CMODEL20574 pc_b.n1 vdd.n24 0.000520208912930457f
CMODEL20575 pc_b.n1 vdd.t44 0.0004841810491788f
CMODEL20576 pc_b.n1 vdd.n25 0.000820419102185096f
CMODEL20577 pc_b.n1 vdd.t43 0.00048522984723123f
CMODEL20578 pc_b.n1 vdd.n26 0.00438970488677538f
CMODEL20579 pc_b.n1 vdd.n27 0.00293460805565175f
CMODEL20580 pc_b.n1 vdd.n28 0.000662875921612092f
CMODEL20581 pc_b.n1 vdd.t29 5.54481500135287e-05f
CMODEL20582 pc_b.n1 vdd.t28 0.000438288896916588f
CMODEL20583 pc_b.n1 vdd.n29 9.89506679722618e-05f
CMODEL20584 pc_b.n1 vdd.n30 3.15674500683398e-05f
CMODEL20585 pc_b.n1 vdd.t38 1.45343602258539e-05f
CMODEL20586 pc_b.n1 vdd.t40 1.45343602258539e-05f
CMODEL20587 pc_b.n1 vdd.t37 0.000293695959801628f
CMODEL20588 pc_b.n1 vdd.t39 0.000293695959801628f
CMODEL20589 pc_b.n1 vdd.n31 9.51211583764643e-05f
CMODEL20590 pc_b.n1 vdd.n32 0.00114791327757849f
CMODEL20591 pc_b.n1 vdd.n33 0.000581648670994599f
CMODEL20592 pc_b.n1 vdd.t17 5.54481500135287e-05f
CMODEL20593 pc_b.n1 vdd.t16 0.000438288896916588f
CMODEL20594 pc_b.n1 vdd.n34 9.89506679722618e-05f
CMODEL20595 pc_b.n1 vdd.n35 3.15674500683398e-05f
CMODEL20596 pc_b.n1 vdd.t1 1.45343602258539e-05f
CMODEL20597 pc_b.n1 vdd.t31 1.45343602258539e-05f
CMODEL20598 pc_b.n1 vdd.t0 0.000293695959801628f
CMODEL20599 pc_b.n1 vdd.t30 0.000293695959801628f
CMODEL20600 pc_b.n1 vdd.n36 9.51211583764643e-05f
CMODEL20601 pc_b.n1 vdd.n37 0.00111324961313377f
CMODEL20602 pc_b.n1 vdd.n38 0.000642174222523935f
CMODEL20603 pc_b.n1 vdd.t19 5.54481500135287e-05f
CMODEL20604 pc_b.n1 vdd.t18 0.000438288896916588f
CMODEL20605 pc_b.n1 vdd.n39 0.000541906081356514f
CMODEL20606 pc_b.n1 vdd.t21 5.5448657906048e-05f
CMODEL20607 pc_b.n1 vdd.t20 0.000438288896916588f
CMODEL20608 pc_b.n1 vdd.n40 0.000541906081356514f
CMODEL20609 pc_b.n1 vdd.t11 5.54481500135287e-05f
CMODEL20610 pc_b.n1 vdd.t10 0.000438288896916588f
CMODEL20611 pc_b.n1 vdd.n41 0.00233137903151055f
CMODEL20612 pc_b.n1 vdd.n42 0.00446575163369564f
CMODEL20613 pc_b.n1 vdd.n43 0.000541906081356514f
CMODEL20614 pc_b.n1 vdd.t13 5.54481500135287e-05f
CMODEL20615 pc_b.n1 vdd.t12 0.000438288896916588f
CMODEL20616 pc_b.n1 vdd.n44 0.000541906081356514f
CMODEL20617 pc_b.n1 vdd.t23 5.54481500135287e-05f
CMODEL20618 pc_b.n1 vdd.t22 0.000438288896916588f
CMODEL20619 pc_b.n1 vdd.n45 0.000668960473993744f
CMODEL20620 pc_b.n1 vdd.n46 0.0110418881058881f
CMODEL20621 pc_b.t2 vdd 5.33116593839897e-07f
CMODEL20622 pc_b.t2 vdd.n0 0.00017890400840645f
CMODEL20623 pc_b.t2 vdd.n1 1.6579170051356e-05f
CMODEL20624 pc_b.t2 vdd.t7 1.36672712391676e-06f
CMODEL20625 pc_b.t2 vdd.t6 1.08032697823337e-05f
CMODEL20626 pc_b.t2 vdd.n2 1.48672089053252e-05f
CMODEL20627 pc_b.t2 vdd.t27 1.36672712391676e-06f
CMODEL20628 pc_b.t2 vdd.t26 1.08032697823337e-05f
CMODEL20629 pc_b.t2 vdd.n3 2.78853745838223e-05f
CMODEL20630 pc_b.t2 vdd.n4 1.48672089053252e-05f
CMODEL20631 pc_b.t2 vdd.t36 1.36672712391676e-06f
CMODEL20632 pc_b.t2 vdd.t35 1.08032697823337e-05f
CMODEL20633 pc_b.t2 vdd.n5 2.12131703278807e-05f
CMODEL20634 pc_b.t2 vdd.t3 2.17711382129161e-06f
CMODEL20635 pc_b.t2 vdd.n6 2.08295908798779e-05f
CMODEL20636 pc_b.t2 vdd.t2 2.72986132023638e-05f
CMODEL20637 pc_b.t2 vdd.n7 2.79229313182874e-05f
CMODEL20638 pc_b.t2 vdd.t25 2.17711382129161e-06f
CMODEL20639 pc_b.t2 vdd.n8 1.2581255667554e-05f
CMODEL20640 pc_b.t2 vdd.t24 2.72986132023638e-05f
CMODEL20641 pc_b.t2 vdd.n9 2.79229313182874e-05f
CMODEL20642 pc_b.t2 vdd.t5 2.17711382129161e-06f
CMODEL20643 pc_b.t2 vdd.n10 3.72542775634678e-05f
CMODEL20644 pc_b.t2 vdd.t4 2.73136358961498e-05f
CMODEL20645 pc_b.t2 vdd.n11 9.007456967154e-05f
CMODEL20646 pc_b.t2 vdd.n12 0.000222090497367783f
CMODEL20647 pc_b.t2 vdd.n13 1.68341802783735e-05f
CMODEL20648 pc_b.t2 vdd.t42 1.36672712391676e-06f
CMODEL20649 pc_b.t2 vdd.t41 1.08032697823337e-05f
CMODEL20650 pc_b.t2 vdd.n14 1.51352388002906e-05f
CMODEL20651 pc_b.t2 vdd.t9 1.36672712391676e-06f
CMODEL20652 pc_b.t2 vdd.t8 1.08032697823337e-05f
CMODEL20653 pc_b.t2 vdd.n15 2.90576454555907e-05f
CMODEL20654 pc_b.t2 vdd.t15 2.30170202842359e-06f
CMODEL20655 pc_b.t2 vdd.n16 1.81047246053254e-05f
CMODEL20656 pc_b.t2 vdd.t14 3.10485279495817e-05f
CMODEL20657 pc_b.t2 vdd.n17 2.53608108930833e-05f
CMODEL20658 pc_b.t2 vdd.t32 3.10485279495817e-05f
CMODEL20659 pc_b.t2 vdd.n18 2.50345680596971e-05f
CMODEL20660 pc_b.t2 vdd.t34 2.30170202842359e-06f
CMODEL20661 pc_b.t2 vdd.n19 2.52100831987637e-05f
CMODEL20662 pc_b.t2 vdd.t33 3.10485279495817e-05f
CMODEL20663 pc_b.t2 vdd.n20 5.03103755437746e-05f
CMODEL20664 pc_b.t2 vdd.t48 3.11078675900365e-05f
CMODEL20665 pc_b.t2 vdd.n21 8.93064092626153e-05f
CMODEL20666 pc_b.t2 vdd.n22 0.000391373722295442f
CMODEL20667 pc_b.t2 vdd.t47 4.42477170882003e-07f
CMODEL20668 pc_b.t2 vdd.t45 4.37934057902883e-07f
CMODEL20669 pc_b.t2 vdd.n23 5.0007042318412e-06f
CMODEL20670 pc_b.t2 vdd.t46 1.19344535865973e-05f
CMODEL20671 pc_b.t2 vdd.n24 1.28224950919343e-05f
CMODEL20672 pc_b.t2 vdd.t44 1.19344535865973e-05f
CMODEL20673 pc_b.t2 vdd.n25 2.02222984835784e-05f
CMODEL20674 pc_b.t2 vdd.t43 1.19603051388207e-05f
CMODEL20675 pc_b.t2 vdd.n26 0.00010820070161551f
CMODEL20676 pc_b.t2 vdd.n27 7.23343957687552e-05f
CMODEL20677 pc_b.t2 vdd.n28 1.63390573290096e-05f
CMODEL20678 pc_b.t2 vdd.t29 1.36672712391676e-06f
CMODEL20679 pc_b.t2 vdd.t28 1.08032697823337e-05f
CMODEL20680 pc_b.t2 vdd.n29 2.43900944962773e-06f
CMODEL20681 pc_b.t2 vdd.n30 7.78097920864113e-07f
CMODEL20682 pc_b.t2 vdd.t38 3.58253690061884e-07f
CMODEL20683 pc_b.t2 vdd.t40 3.58253690061884e-07f
CMODEL20684 pc_b.t2 vdd.t37 7.23923583289462e-06f
CMODEL20685 pc_b.t2 vdd.t39 7.23923583289462e-06f
CMODEL20686 pc_b.t2 vdd.n31 2.34461685700563e-06f
CMODEL20687 pc_b.t2 vdd.n32 2.82946178003763e-05f
CMODEL20688 pc_b.t2 vdd.n33 1.43369078146791e-05f
CMODEL20689 pc_b.t2 vdd.t17 1.36672712391676e-06f
CMODEL20690 pc_b.t2 vdd.t16 1.08032697823337e-05f
CMODEL20691 pc_b.t2 vdd.n34 2.43900944962773e-06f
CMODEL20692 pc_b.t2 vdd.n35 7.78097920864113e-07f
CMODEL20693 pc_b.t2 vdd.t1 3.58253690061884e-07f
CMODEL20694 pc_b.t2 vdd.t31 3.58253690061884e-07f
CMODEL20695 pc_b.t2 vdd.t0 7.23923583289462e-06f
CMODEL20696 pc_b.t2 vdd.t30 7.23923583289462e-06f
CMODEL20697 pc_b.t2 vdd.n36 2.34461685700563e-06f
CMODEL20698 pc_b.t2 vdd.n37 2.74402020912969e-05f
CMODEL20699 pc_b.t2 vdd.n38 1.58287864967448e-05f
CMODEL20700 pc_b.t2 vdd.t19 1.36672712391676e-06f
CMODEL20701 pc_b.t2 vdd.t18 1.08032697823337e-05f
CMODEL20702 pc_b.t2 vdd.n39 1.33573029907163e-05f
CMODEL20703 pc_b.t2 vdd.t21 1.36673964282825e-06f
CMODEL20704 pc_b.t2 vdd.t20 1.08032697823337e-05f
CMODEL20705 pc_b.t2 vdd.n40 1.33573029907163e-05f
CMODEL20706 pc_b.t2 vdd.t11 1.36672712391676e-06f
CMODEL20707 pc_b.t2 vdd.t10 1.08032697823337e-05f
CMODEL20708 pc_b.t2 vdd.n41 5.74655594049364e-05f
CMODEL20709 pc_b.t2 vdd.n42 0.00011007515823266f
CMODEL20710 pc_b.t2 vdd.n43 1.33573029907163e-05f
CMODEL20711 pc_b.t2 vdd.t13 1.36672712391676e-06f
CMODEL20712 pc_b.t2 vdd.t12 1.08032697823337e-05f
CMODEL20713 pc_b.t2 vdd.n44 1.33573029907163e-05f
CMODEL20714 pc_b.t2 vdd.t23 1.36672712391676e-06f
CMODEL20715 pc_b.t2 vdd.t22 1.08032697823337e-05f
CMODEL20716 pc_b.t2 vdd.n45 1.64890338886399e-05f
CMODEL20717 pc_b.t2 vdd.n46 0.000272168647103449f
CMODEL20718 a_9600_n35917.t0 vdd 5.21207781292005e-07f
CMODEL20719 a_9600_n35917.t0 vdd.n0 0.000174907632520205f
CMODEL20720 a_9600_n35917.t0 vdd.n1 1.62088228691025e-05f
CMODEL20721 a_9600_n35917.t0 vdd.t7 1.33619703479384e-06f
CMODEL20722 a_9600_n35917.t0 vdd.t6 1.05619452461465e-05f
CMODEL20723 a_9600_n35917.t0 vdd.n2 1.45351036847981e-05f
CMODEL20724 a_9600_n35917.t0 vdd.t27 1.33619703479384e-06f
CMODEL20725 a_9600_n35917.t0 vdd.t26 1.05619452461465e-05f
CMODEL20726 a_9600_n35917.t0 vdd.n3 2.72624682579198e-05f
CMODEL20727 a_9600_n35917.t0 vdd.n4 1.45351036847981e-05f
CMODEL20728 a_9600_n35917.t0 vdd.t36 1.33619703479384e-06f
CMODEL20729 a_9600_n35917.t0 vdd.t35 1.05619452461465e-05f
CMODEL20730 a_9600_n35917.t0 vdd.n5 2.07393083774176e-05f
CMODEL20731 a_9600_n35917.t0 vdd.t3 2.12848123192417e-06f
CMODEL20732 a_9600_n35917.t0 vdd.n6 2.03642973660312e-05f
CMODEL20733 a_9600_n35917.t0 vdd.t2 2.66888140117162e-05f
CMODEL20734 a_9600_n35917.t0 vdd.n7 2.72991860462409e-05f
CMODEL20735 a_9600_n35917.t0 vdd.t25 2.12848123192417e-06f
CMODEL20736 a_9600_n35917.t0 vdd.n8 1.23002143023194e-05f
CMODEL20737 a_9600_n35917.t0 vdd.t24 2.66888140117162e-05f
CMODEL20738 a_9600_n35917.t0 vdd.n9 2.72991860462409e-05f
CMODEL20739 a_9600_n35917.t0 vdd.t5 2.12848123192417e-06f
CMODEL20740 a_9600_n35917.t0 vdd.n10 3.64220877325061e-05f
CMODEL20741 a_9600_n35917.t0 vdd.t4 2.67035011270447e-05f
CMODEL20742 a_9600_n35917.t0 vdd.n11 8.80624747978387e-05f
CMODEL20743 a_9600_n35917.t0 vdd.n12 0.000217129417310659f
CMODEL20744 a_9600_n35917.t0 vdd.n13 1.64581366518029e-05f
CMODEL20745 a_9600_n35917.t0 vdd.t42 1.33619703479384e-06f
CMODEL20746 a_9600_n35917.t0 vdd.t41 1.05619452461465e-05f
CMODEL20747 a_9600_n35917.t0 vdd.n14 1.47971463007832e-05f
CMODEL20748 a_9600_n35917.t0 vdd.t9 1.33619703479384e-06f
CMODEL20749 a_9600_n35917.t0 vdd.t8 1.05619452461465e-05f
CMODEL20750 a_9600_n35917.t0 vdd.n15 2.84085528240497e-05f
CMODEL20751 a_9600_n35917.t0 vdd.t15 2.25028637504809e-06f
CMODEL20752 a_9600_n35917.t0 vdd.n16 1.77002994307063e-05f
CMODEL20753 a_9600_n35917.t0 vdd.t14 3.03549627829522e-05f
CMODEL20754 a_9600_n35917.t0 vdd.n17 2.47942985269742e-05f
CMODEL20755 a_9600_n35917.t0 vdd.t32 3.03549627829522e-05f
CMODEL20756 a_9600_n35917.t0 vdd.n18 2.44753433390914e-05f
CMODEL20757 a_9600_n35917.t0 vdd.t34 2.25028637504809e-06f
CMODEL20758 a_9600_n35917.t0 vdd.n19 2.46469378031788e-05f
CMODEL20759 a_9600_n35917.t0 vdd.t33 3.03549627829522e-05f
CMODEL20760 a_9600_n35917.t0 vdd.n20 4.91865372718322e-05f
CMODEL20761 a_9600_n35917.t0 vdd.t48 3.04129768884996e-05f
CMODEL20762 a_9600_n35917.t0 vdd.n21 8.73114736340441e-05f
CMODEL20763 a_9600_n35917.t0 vdd.n22 0.00038263117638927f
CMODEL20764 a_9600_n35917.t0 vdd.t47 4.32593070957817e-07f
CMODEL20765 a_9600_n35917.t0 vdd.t45 4.28151442497239e-07f
CMODEL20766 a_9600_n35917.t0 vdd.n23 4.88899799348253e-06f
CMODEL20767 a_9600_n35917.t0 vdd.t46 1.1667860551853e-05f
CMODEL20768 a_9600_n35917.t0 vdd.n24 1.25360648959687e-05f
CMODEL20769 a_9600_n35917.t0 vdd.t44 1.1667860551853e-05f
CMODEL20770 a_9600_n35917.t0 vdd.n25 1.97705707288787e-05f
CMODEL20771 a_9600_n35917.t0 vdd.t43 1.16931346294807e-05f
CMODEL20772 a_9600_n35917.t0 vdd.n26 0.000105783703367888f
CMODEL20773 a_9600_n35917.t0 vdd.n27 7.07185826991027e-05f
CMODEL20774 a_9600_n35917.t0 vdd.n28 1.59740738091028e-05f
CMODEL20775 a_9600_n35917.t0 vdd.t29 1.33619703479384e-06f
CMODEL20776 a_9600_n35917.t0 vdd.t28 1.05619452461465e-05f
CMODEL20777 a_9600_n35917.t0 vdd.n29 2.3845266091501e-06f
CMODEL20778 a_9600_n35917.t0 vdd.n30 7.60716690584386e-07f
CMODEL20779 a_9600_n35917.t0 vdd.t38 3.50250982795153e-07f
CMODEL20780 a_9600_n35917.t0 vdd.t40 3.50250982795153e-07f
CMODEL20781 a_9600_n35917.t0 vdd.t37 7.0775250485745e-06f
CMODEL20782 a_9600_n35917.t0 vdd.t39 7.0775250485745e-06f
CMODEL20783 a_9600_n35917.t0 vdd.n31 2.29224256783636e-06f
CMODEL20784 a_9600_n35917.t0 vdd.n32 2.76625697579923e-05f
CMODEL20785 a_9600_n35917.t0 vdd.n33 1.40166485137039e-05f
CMODEL20786 a_9600_n35917.t0 vdd.t17 1.33619703479384e-06f
CMODEL20787 a_9600_n35917.t0 vdd.t16 1.05619452461465e-05f
CMODEL20788 a_9600_n35917.t0 vdd.n34 2.3845266091501e-06f
CMODEL20789 a_9600_n35917.t0 vdd.n35 7.60716690584386e-07f
CMODEL20790 a_9600_n35917.t0 vdd.t1 3.50250982795153e-07f
CMODEL20791 a_9600_n35917.t0 vdd.t31 3.50250982795153e-07f
CMODEL20792 a_9600_n35917.t0 vdd.t0 7.0775250485745e-06f
CMODEL20793 a_9600_n35917.t0 vdd.t30 7.0775250485745e-06f
CMODEL20794 a_9600_n35917.t0 vdd.n36 2.29224256783636e-06f
CMODEL20795 a_9600_n35917.t0 vdd.n37 2.68272400736868e-05f
CMODEL20796 a_9600_n35917.t0 vdd.n38 1.54752014584465e-05f
CMODEL20797 a_9600_n35917.t0 vdd.t19 1.33619703479384e-06f
CMODEL20798 a_9600_n35917.t0 vdd.t18 1.05619452461465e-05f
CMODEL20799 a_9600_n35917.t0 vdd.n39 1.30589262016614e-05f
CMODEL20800 a_9600_n35917.t0 vdd.t21 1.33620927405661e-06f
CMODEL20801 a_9600_n35917.t0 vdd.t20 1.05619452461465e-05f
CMODEL20802 a_9600_n35917.t0 vdd.n40 1.30589262016614e-05f
CMODEL20803 a_9600_n35917.t0 vdd.t11 1.33619703479384e-06f
CMODEL20804 a_9600_n35917.t0 vdd.t10 1.05619452461465e-05f
CMODEL20805 a_9600_n35917.t0 vdd.n41 5.6181887910144e-05f
CMODEL20806 a_9600_n35917.t0 vdd.n42 0.000107616288182995f
CMODEL20807 a_9600_n35917.t0 vdd.n43 1.30589262016614e-05f
CMODEL20808 a_9600_n35917.t0 vdd.t13 1.33619703479384e-06f
CMODEL20809 a_9600_n35917.t0 vdd.t12 1.05619452461465e-05f
CMODEL20810 a_9600_n35917.t0 vdd.n44 1.30589262016614e-05f
CMODEL20811 a_9600_n35917.t0 vdd.t23 1.33619703479384e-06f
CMODEL20812 a_9600_n35917.t0 vdd.t22 1.05619452461465e-05f
CMODEL20813 a_9600_n35917.t0 vdd.n45 1.61207001771318e-05f
CMODEL20814 a_9600_n35917.t0 vdd.n46 0.000266088916258039f
CMODEL20815 a_9600_n35917.n0 vdd 2.86102433514527e-06f
CMODEL20816 a_9600_n35917.n0 vdd.n0 0.000960106527578096f
CMODEL20817 a_9600_n35917.n0 vdd.n1 8.89737995806714e-05f
CMODEL20818 a_9600_n35917.n0 vdd.t7 7.33467989218747e-06f
CMODEL20819 a_9600_n35917.n0 vdd.t6 5.79768442842327e-05f
CMODEL20820 a_9600_n35917.n0 vdd.n2 7.97863862526815e-05f
CMODEL20821 a_9600_n35917.n0 vdd.t27 7.33467989218747e-06f
CMODEL20822 a_9600_n35917.n0 vdd.t26 5.79768442842327e-05f
CMODEL20823 a_9600_n35917.n0 vdd.n3 0.000149649694271037f
CMODEL20824 a_9600_n35917.n0 vdd.n4 7.97863862526815e-05f
CMODEL20825 a_9600_n35917.n0 vdd.t36 7.33467989218747e-06f
CMODEL20826 a_9600_n35917.n0 vdd.t35 5.79768442842327e-05f
CMODEL20827 a_9600_n35917.n0 vdd.n5 0.000113842632615324f
CMODEL20828 a_9600_n35917.n0 vdd.t3 1.16837023928147e-05f
CMODEL20829 a_9600_n35917.n0 vdd.n6 0.000111784114557776f
CMODEL20830 a_9600_n35917.n0 vdd.t2 0.000146500779735879f
CMODEL20831 a_9600_n35917.n0 vdd.n7 0.00014985124630017f
CMODEL20832 a_9600_n35917.n0 vdd.t25 1.16837023928147e-05f
CMODEL20833 a_9600_n35917.n0 vdd.n8 6.75185860794387e-05f
CMODEL20834 a_9600_n35917.n0 vdd.t24 0.000146500779735879f
CMODEL20835 a_9600_n35917.n0 vdd.n9 0.00014985124630017f
CMODEL20836 a_9600_n35917.n0 vdd.t5 1.16837023928147e-05f
CMODEL20837 a_9600_n35917.n0 vdd.n10 0.000199928863458613f
CMODEL20838 a_9600_n35917.n0 vdd.t4 0.000146581400547532f
CMODEL20839 a_9600_n35917.n0 vdd.n11 0.00048339432459198f
CMODEL20840 a_9600_n35917.n0 vdd.n12 0.0011918712058784f
CMODEL20841 a_9600_n35917.n0 vdd.n13 9.0342337858486e-05f
CMODEL20842 a_9600_n35917.n0 vdd.t42 7.33467989218747e-06f
CMODEL20843 a_9600_n35917.n0 vdd.t41 5.79768442842327e-05f
CMODEL20844 a_9600_n35917.n0 vdd.n14 8.12247959005957e-05f
CMODEL20845 a_9600_n35917.n0 vdd.t9 7.33467989218747e-06f
CMODEL20846 a_9600_n35917.n0 vdd.t8 5.79768442842327e-05f
CMODEL20847 a_9600_n35917.n0 vdd.n15 0.000155940804940382f
CMODEL20848 a_9600_n35917.n0 vdd.t15 1.23523176574593e-05f
CMODEL20849 a_9600_n35917.n0 vdd.n16 9.71608430040633e-05f
CMODEL20850 a_9600_n35917.n0 vdd.t14 0.000166625078004735f
CMODEL20851 a_9600_n35917.n0 vdd.n17 0.000136101366872701f
CMODEL20852 a_9600_n35917.n0 vdd.t32 0.000166625078004735f
CMODEL20853 a_9600_n35917.n0 vdd.n18 0.00013435055157963f
CMODEL20854 a_9600_n35917.n0 vdd.t34 1.23523176574593e-05f
CMODEL20855 a_9600_n35917.n0 vdd.n19 0.00013529247139578f
CMODEL20856 a_9600_n35917.n0 vdd.t33 0.000166625078004735f
CMODEL20857 a_9600_n35917.n0 vdd.n20 0.000269995739026393f
CMODEL20858 a_9600_n35917.n0 vdd.t48 0.000166943530210765f
CMODEL20859 a_9600_n35917.n0 vdd.n21 0.000479271913756108f
CMODEL20860 a_9600_n35917.n0 vdd.n22 0.00210034682199353f
CMODEL20861 a_9600_n35917.n0 vdd.t47 2.37459866803512e-06f
CMODEL20862 a_9600_n35917.n0 vdd.t45 2.35021759091097e-06f
CMODEL20863 a_9600_n35917.n0 vdd.n23 2.68367870471094e-05f
CMODEL20864 a_9600_n35917.n0 vdd.t46 6.40474570337062e-05f
CMODEL20865 a_9600_n35917.n0 vdd.n24 6.88132219465712e-05f
CMODEL20866 a_9600_n35917.n0 vdd.t44 6.40474570337062e-05f
CMODEL20867 a_9600_n35917.n0 vdd.n25 0.000108525018246692f
CMODEL20868 a_9600_n35917.n0 vdd.t43 6.41861920137596e-05f
CMODEL20869 a_9600_n35917.n0 vdd.n26 0.000580670052252649f
CMODEL20870 a_9600_n35917.n0 vdd.n27 0.000388189879950703f
CMODEL20871 a_9600_n35917.n0 vdd.n28 8.76852102744129e-05f
CMODEL20872 a_9600_n35917.n0 vdd.t29 7.33467989218747e-06f
CMODEL20873 a_9600_n35917.n0 vdd.t28 5.79768442842327e-05f
CMODEL20874 a_9600_n35917.n0 vdd.n29 1.30891918759704e-05f
CMODEL20875 a_9600_n35917.n0 vdd.n30 4.17574150278037e-06f
CMODEL20876 a_9600_n35917.n0 vdd.t38 1.92260480590191e-06f
CMODEL20877 a_9600_n35917.n0 vdd.t40 1.92260480590191e-06f
CMODEL20878 a_9600_n35917.n0 vdd.t37 3.88500941915666e-05f
CMODEL20879 a_9600_n35917.n0 vdd.t39 3.88500941915666e-05f
CMODEL20880 a_9600_n35917.n0 vdd.n31 1.25826244427489e-05f
CMODEL20881 a_9600_n35917.n0 vdd.n32 0.000151845939548492f
CMODEL20882 a_9600_n35917.n0 vdd.n33 7.69404716013203e-05f
CMODEL20883 a_9600_n35917.n0 vdd.t17 7.33467989218747e-06f
CMODEL20884 a_9600_n35917.n0 vdd.t16 5.79768442842327e-05f
CMODEL20885 a_9600_n35917.n0 vdd.n34 1.30891918759704e-05f
CMODEL20886 a_9600_n35917.n0 vdd.n35 4.17574150278037e-06f
CMODEL20887 a_9600_n35917.n0 vdd.t1 1.92260480590191e-06f
CMODEL20888 a_9600_n35917.n0 vdd.t31 1.92260480590191e-06f
CMODEL20889 a_9600_n35917.n0 vdd.t0 3.88500941915666e-05f
CMODEL20890 a_9600_n35917.n0 vdd.t30 3.88500941915666e-05f
CMODEL20891 a_9600_n35917.n0 vdd.n36 1.25826244427489e-05f
CMODEL20892 a_9600_n35917.n0 vdd.n37 0.000147260630885711f
CMODEL20893 a_9600_n35917.n0 vdd.n38 8.49467900385894e-05f
CMODEL20894 a_9600_n35917.n0 vdd.t19 7.33467989218747e-06f
CMODEL20895 a_9600_n35917.n0 vdd.t18 5.79768442842327e-05f
CMODEL20896 a_9600_n35917.n0 vdd.n39 7.16833228414284e-05f
CMODEL20897 a_9600_n35917.n0 vdd.t21 7.33474707619718e-06f
CMODEL20898 a_9600_n35917.n0 vdd.t20 5.79768442842327e-05f
CMODEL20899 a_9600_n35917.n0 vdd.n40 7.16833228414284e-05f
CMODEL20900 a_9600_n35917.n0 vdd.t11 7.33467989218747e-06f
CMODEL20901 a_9600_n35917.n0 vdd.t10 5.79768442842327e-05f
CMODEL20902 a_9600_n35917.n0 vdd.n41 0.000308394759776759f
CMODEL20903 a_9600_n35917.n0 vdd.n42 0.000590729514026689f
CMODEL20904 a_9600_n35917.n0 vdd.n43 7.16833228414284e-05f
CMODEL20905 a_9600_n35917.n0 vdd.t13 7.33467989218747e-06f
CMODEL20906 a_9600_n35917.n0 vdd.t12 5.79768442842327e-05f
CMODEL20907 a_9600_n35917.n0 vdd.n44 7.16833228414284e-05f
CMODEL20908 a_9600_n35917.n0 vdd.t23 7.33467989218747e-06f
CMODEL20909 a_9600_n35917.n0 vdd.t22 5.79768442842327e-05f
CMODEL20910 a_9600_n35917.n0 vdd.n45 8.84900747107516e-05f
CMODEL20911 a_9600_n35917.n0 vdd.n46 0.00146062068152465f
CMODEL20912 a_9600_n35917.t2 vdd 1.05778755153274e-06f
CMODEL20913 a_9600_n35917.t2 vdd.n0 0.000354973818482348f
CMODEL20914 a_9600_n35917.t2 vdd.n1 3.28956927953654e-05f
CMODEL20915 a_9600_n35917.t2 vdd.t7 2.71180254887258e-06f
CMODEL20916 a_9600_n35917.t2 vdd.t6 2.14353941026159e-05f
CMODEL20917 a_9600_n35917.t2 vdd.n2 2.94988914016295e-05f
CMODEL20918 a_9600_n35917.t2 vdd.t27 2.71180254887258e-06f
CMODEL20919 a_9600_n35917.t2 vdd.t26 2.14353941026159e-05f
CMODEL20920 a_9600_n35917.t2 vdd.n3 5.53289889030413e-05f
CMODEL20921 a_9600_n35917.t2 vdd.n4 2.94988914016295e-05f
CMODEL20922 a_9600_n35917.t2 vdd.t36 2.71180254887258e-06f
CMODEL20923 a_9600_n35917.t2 vdd.t35 2.14353941026159e-05f
CMODEL20924 a_9600_n35917.t2 vdd.n5 4.2090281489371e-05f
CMODEL20925 a_9600_n35917.t2 vdd.t3 4.31973779289967e-06f
CMODEL20926 a_9600_n35917.t2 vdd.n6 4.13291992611877e-05f
CMODEL20927 a_9600_n35917.t2 vdd.t2 5.41647616173052e-05f
CMODEL20928 a_9600_n35917.t2 vdd.n7 5.54035073979678e-05f
CMODEL20929 a_9600_n35917.t2 vdd.t25 4.31973779289967e-06f
CMODEL20930 a_9600_n35917.t2 vdd.n8 2.49631990104327e-05f
CMODEL20931 a_9600_n35917.t2 vdd.t24 5.41647616173052e-05f
CMODEL20932 a_9600_n35917.t2 vdd.n9 5.54035073979678e-05f
CMODEL20933 a_9600_n35917.t2 vdd.t5 4.31973779289967e-06f
CMODEL20934 a_9600_n35917.t2 vdd.n10 7.39183726474219e-05f
CMODEL20935 a_9600_n35917.t2 vdd.t4 5.41945690152759e-05f
CMODEL20936 a_9600_n35917.t2 vdd.n11 0.000178722177492074f
CMODEL20937 a_9600_n35917.t2 vdd.n12 0.000440662635798404f
CMODEL20938 a_9600_n35917.t2 vdd.n13 3.34016733759168e-05f
CMODEL20939 a_9600_n35917.t2 vdd.t42 2.71180254887258e-06f
CMODEL20940 a_9600_n35917.t2 vdd.t41 2.14353941026159e-05f
CMODEL20941 a_9600_n35917.t2 vdd.n14 3.00307050604221e-05f
CMODEL20942 a_9600_n35917.t2 vdd.t9 2.71180254887258e-06f
CMODEL20943 a_9600_n35917.t2 vdd.t8 2.14353941026159e-05f
CMODEL20944 a_9600_n35917.t2 vdd.n15 5.76549595246824e-05f
CMODEL20945 a_9600_n35917.t2 vdd.t15 4.56694048006939e-06f
CMODEL20946 a_9600_n35917.t2 vdd.n16 3.59226340592824e-05f
CMODEL20947 a_9600_n35917.t2 vdd.t14 6.16051849407396e-05f
CMODEL20948 a_9600_n35917.t2 vdd.n17 5.03198556740776e-05f
CMODEL20949 a_9600_n35917.t2 vdd.t32 6.16051849407396e-05f
CMODEL20950 a_9600_n35917.t2 vdd.n18 4.96725383481489e-05f
CMODEL20951 a_9600_n35917.t2 vdd.t34 4.56694048006939e-06f
CMODEL20952 a_9600_n35917.t2 vdd.n19 5.0020788114439e-05f
CMODEL20953 a_9600_n35917.t2 vdd.t33 6.16051849407396e-05f
CMODEL20954 a_9600_n35917.t2 vdd.n20 9.98237338287094e-05f
CMODEL20955 a_9600_n35917.t2 vdd.t48 6.17229241627235e-05f
CMODEL20956 a_9600_n35917.t2 vdd.n21 0.000177198025875842f
CMODEL20957 a_9600_n35917.t2 vdd.n22 0.000776547299830398f
CMODEL20958 a_9600_n35917.t2 vdd.t47 8.77944615876973e-07f
CMODEL20959 a_9600_n35917.t2 vdd.t45 8.6893036194069e-07f
CMODEL20960 a_9600_n35917.t2 vdd.n23 9.92218727846859e-06f
CMODEL20961 a_9600_n35917.t2 vdd.t46 2.36798414908074e-05f
CMODEL20962 a_9600_n35917.t2 vdd.n24 2.54418561428443e-05f
CMODEL20963 a_9600_n35917.t2 vdd.t44 2.36798414908074e-05f
CMODEL20964 a_9600_n35917.t2 vdd.n25 4.01242351982252e-05f
CMODEL20965 a_9600_n35917.t2 vdd.t43 2.37311350548152e-05f
CMODEL20966 a_9600_n35917.t2 vdd.n26 0.000214687287093464f
CMODEL20967 a_9600_n35917.t2 vdd.n27 0.000143522869623545f
CMODEL20968 a_9600_n35917.t2 vdd.n28 3.24192712178016e-05f
CMODEL20969 a_9600_n35917.t2 vdd.t29 2.71180254887258e-06f
CMODEL20970 a_9600_n35917.t2 vdd.t28 2.14353941026159e-05f
CMODEL20971 a_9600_n35917.t2 vdd.n29 4.8393800975209e-06f
CMODEL20972 a_9600_n35917.t2 vdd.n30 1.54386920998889e-06f
CMODEL20973 a_9600_n35917.t2 vdd.t38 7.10831923104492e-07f
CMODEL20974 a_9600_n35917.t2 vdd.t40 7.10831923104492e-07f
CMODEL20975 a_9600_n35917.t2 vdd.t37 1.43637876500715e-05f
CMODEL20976 a_9600_n35917.t2 vdd.t39 1.43637876500715e-05f
CMODEL20977 a_9600_n35917.t2 vdd.n31 4.65209028027214e-06f
CMODEL20978 a_9600_n35917.t2 vdd.n32 5.61409921027577e-05f
CMODEL20979 a_9600_n35917.t2 vdd.n33 2.84466902532665e-05f
CMODEL20980 a_9600_n35917.t2 vdd.t17 2.71180254887258e-06f
CMODEL20981 a_9600_n35917.t2 vdd.t16 2.14353941026159e-05f
CMODEL20982 a_9600_n35917.t2 vdd.n34 4.8393800975209e-06f
CMODEL20983 a_9600_n35917.t2 vdd.n35 1.54386920998889e-06f
CMODEL20984 a_9600_n35917.t2 vdd.t1 7.10831923104492e-07f
CMODEL20985 a_9600_n35917.t2 vdd.t31 7.10831923104492e-07f
CMODEL20986 a_9600_n35917.t2 vdd.t0 1.43637876500715e-05f
CMODEL20987 a_9600_n35917.t2 vdd.t30 1.43637876500715e-05f
CMODEL20988 a_9600_n35917.t2 vdd.n36 4.65209028027214e-06f
CMODEL20989 a_9600_n35917.t2 vdd.n37 5.44456963431784e-05f
CMODEL20990 a_9600_n35917.t2 vdd.n38 3.14068132667327e-05f
CMODEL20991 a_9600_n35917.t2 vdd.t19 2.71180254887258e-06f
CMODEL20992 a_9600_n35917.t2 vdd.t18 2.14353941026159e-05f
CMODEL20993 a_9600_n35917.t2 vdd.n39 2.65029995105986e-05f
CMODEL20994 a_9600_n35917.t2 vdd.t21 2.71182738837089e-06f
CMODEL20995 a_9600_n35917.t2 vdd.t20 2.14353941026159e-05f
CMODEL20996 a_9600_n35917.t2 vdd.n40 2.65029995105986e-05f
CMODEL20997 a_9600_n35917.t2 vdd.t11 2.71180254887258e-06f
CMODEL20998 a_9600_n35917.t2 vdd.t10 2.14353941026159e-05f
CMODEL20999 a_9600_n35917.t2 vdd.n41 0.000114020749087135f
CMODEL21000 a_9600_n35917.t2 vdd.n42 0.000218406505175249f
CMODEL21001 a_9600_n35917.t2 vdd.n43 2.65029995105986e-05f
CMODEL21002 a_9600_n35917.t2 vdd.t13 2.71180254887258e-06f
CMODEL21003 a_9600_n35917.t2 vdd.t12 2.14353941026159e-05f
CMODEL21004 a_9600_n35917.t2 vdd.n44 2.65029995105986e-05f
CMODEL21005 a_9600_n35917.t2 vdd.t23 2.71180254887258e-06f
CMODEL21006 a_9600_n35917.t2 vdd.t22 2.14353941026159e-05f
CMODEL21007 a_9600_n35917.t2 vdd.n45 3.27168484075417e-05f
CMODEL21008 a_9600_n35917.t2 vdd.n46 0.000540025596933484f
CMODEL21009 a_9600_n35917.n1 vdd 3.34622579432303e-05f
CMODEL21010 a_9600_n35917.n1 vdd.n0 0.0112293110841947f
CMODEL21011 a_9600_n35917.n1 vdd.n1 0.00104062876892885f
CMODEL21012 a_9600_n35917.n1 vdd.t7 8.5785691323363e-05f
CMODEL21013 a_9600_n35917.n1 vdd.t6 0.000678091442404661f
CMODEL21014 a_9600_n35917.n1 vdd.n2 0.000933173690397803f
CMODEL21015 a_9600_n35917.n1 vdd.t27 8.5785691323363e-05f
CMODEL21016 a_9600_n35917.n1 vdd.t26 0.000678091442404661f
CMODEL21017 a_9600_n35917.n1 vdd.n3 0.00175028803820668f
CMODEL21018 a_9600_n35917.n1 vdd.n4 0.000933173690397803f
CMODEL21019 a_9600_n35917.n1 vdd.t36 8.5785691323363e-05f
CMODEL21020 a_9600_n35917.n1 vdd.t35 0.000678091442404661f
CMODEL21021 a_9600_n35917.n1 vdd.n5 0.00133149218296214f
CMODEL21022 a_9600_n35917.n1 vdd.t3 0.000136651428789909f
CMODEL21023 a_9600_n35917.n1 vdd.n6 0.00130741595915087f
CMODEL21024 a_9600_n35917.n1 vdd.t2 0.0017134586449288f
CMODEL21025 a_9600_n35917.n1 vdd.n7 0.00175264537082528f
CMODEL21026 a_9600_n35917.n1 vdd.t25 0.000136651428789909f
CMODEL21027 a_9600_n35917.n1 vdd.n8 0.0007896907116792f
CMODEL21028 a_9600_n35917.n1 vdd.t24 0.0017134586449288f
CMODEL21029 a_9600_n35917.n1 vdd.n9 0.00175264537082528f
CMODEL21030 a_9600_n35917.n1 vdd.t5 0.000136651428789909f
CMODEL21031 a_9600_n35917.n1 vdd.n10 0.00233834823324189f
CMODEL21032 a_9600_n35917.n1 vdd.t4 0.00171440157797624f
CMODEL21033 a_9600_n35917.n1 vdd.n11 0.00565373225913827f
CMODEL21034 a_9600_n35917.n1 vdd.n12 0.0139400078623193f
CMODEL21035 a_9600_n35917.n1 vdd.n13 0.00105663505740912f
CMODEL21036 a_9600_n35917.n1 vdd.t42 8.5785691323363e-05f
CMODEL21037 a_9600_n35917.n1 vdd.t41 0.000678091442404661f
CMODEL21038 a_9600_n35917.n1 vdd.n14 0.00094999718751919f
CMODEL21039 a_9600_n35917.n1 vdd.t9 8.5785691323363e-05f
CMODEL21040 a_9600_n35917.n1 vdd.t8 0.000678091442404661f
CMODEL21041 a_9600_n35917.n1 vdd.n15 0.00182386824700849f
CMODEL21042 a_9600_n35917.n1 vdd.t15 0.000144471486863335f
CMODEL21043 a_9600_n35917.n1 vdd.n16 0.00113638361989626f
CMODEL21044 a_9600_n35917.n1 vdd.t14 0.00194883044912032f
CMODEL21045 a_9600_n35917.n1 vdd.n17 0.00159182813958459f
CMODEL21046 a_9600_n35917.n1 vdd.t32 0.00194883044912032f
CMODEL21047 a_9600_n35917.n1 vdd.n18 0.00157135077690438f
CMODEL21048 a_9600_n35917.n1 vdd.t34 0.000144471486863335f
CMODEL21049 a_9600_n35917.n1 vdd.n19 0.00158236737800862f
CMODEL21050 a_9600_n35917.n1 vdd.t33 0.00194883044912032f
CMODEL21051 a_9600_n35917.n1 vdd.n20 0.00315784348699555f
CMODEL21052 a_9600_n35917.n1 vdd.t48 0.0019525550346577f
CMODEL21053 a_9600_n35917.n1 vdd.n21 0.00560551694931257f
CMODEL21054 a_9600_n35917.n1 vdd.n22 0.0245654489073834f
CMODEL21055 a_9600_n35917.n1 vdd.t47 2.77730714015083e-05f
CMODEL21056 a_9600_n35917.n1 vdd.t45 2.7487912732412e-05f
CMODEL21057 a_9600_n35917.n1 vdd.n23 0.000313880409721268f
CMODEL21058 a_9600_n35917.n1 vdd.t46 0.000749092729321723f
CMODEL21059 a_9600_n35917.n1 vdd.n24 0.000804832644865988f
CMODEL21060 a_9600_n35917.n1 vdd.t44 0.000749092729321723f
CMODEL21061 a_9600_n35917.n1 vdd.n25 0.00126929789070815f
CMODEL21062 a_9600_n35917.n1 vdd.t43 0.000750715359940857f
CMODEL21063 a_9600_n35917.n1 vdd.n26 0.00679145955862713f
CMODEL21064 a_9600_n35917.n1 vdd.n27 0.00454023048119319f
CMODEL21065 a_9600_n35917.n1 vdd.n28 0.00102555755572062f
CMODEL21066 a_9600_n35917.n1 vdd.t29 8.5785691323363e-05f
CMODEL21067 a_9600_n35917.n1 vdd.t28 0.000678091442404661f
CMODEL21068 a_9600_n35917.n1 vdd.n29 0.000153089894916926f
CMODEL21069 a_9600_n35917.n1 vdd.n30 4.88390600365845e-05f
CMODEL21070 a_9600_n35917.n1 vdd.t38 2.24865958487967e-05f
CMODEL21071 a_9600_n35917.n1 vdd.t40 2.24865958487967e-05f
CMODEL21072 a_9600_n35917.n1 vdd.t37 0.000454386863120123f
CMODEL21073 a_9600_n35917.n1 vdd.t39 0.000454386863120123f
CMODEL21074 a_9600_n35917.n1 vdd.n31 0.000147165132268852f
CMODEL21075 a_9600_n35917.n1 vdd.n32 0.00177597510597399f
CMODEL21076 a_9600_n35917.n1 vdd.n33 0.000899888153823214f
CMODEL21077 a_9600_n35917.n1 vdd.t17 8.5785691323363e-05f
CMODEL21078 a_9600_n35917.n1 vdd.t16 0.000678091442404661f
CMODEL21079 a_9600_n35917.n1 vdd.n34 0.000153089894916926f
CMODEL21080 a_9600_n35917.n1 vdd.n35 4.88390600365845e-05f
CMODEL21081 a_9600_n35917.n1 vdd.t1 2.24865958487967e-05f
CMODEL21082 a_9600_n35917.n1 vdd.t31 2.24865958487967e-05f
CMODEL21083 a_9600_n35917.n1 vdd.t0 0.000454386863120123f
CMODEL21084 a_9600_n35917.n1 vdd.t30 0.000454386863120123f
CMODEL21085 a_9600_n35917.n1 vdd.n36 0.000147165132268852f
CMODEL21086 a_9600_n35917.n1 vdd.n37 0.00172234578890091f
CMODEL21087 a_9600_n35917.n1 vdd.n38 0.000993529263209282f
CMODEL21088 a_9600_n35917.n1 vdd.t19 8.5785691323363e-05f
CMODEL21089 a_9600_n35917.n1 vdd.t18 0.000678091442404661f
CMODEL21090 a_9600_n35917.n1 vdd.n39 0.000838401061354809f
CMODEL21091 a_9600_n35917.n1 vdd.t21 8.57864771009025e-05f
CMODEL21092 a_9600_n35917.n1 vdd.t20 0.000678091442404661f
CMODEL21093 a_9600_n35917.n1 vdd.n40 0.000838401061354809f
CMODEL21094 a_9600_n35917.n1 vdd.t11 8.5785691323363e-05f
CMODEL21095 a_9600_n35917.n1 vdd.t10 0.000678091442404661f
CMODEL21096 a_9600_n35917.n1 vdd.n41 0.00360695463971525f
CMODEL21097 a_9600_n35917.n1 vdd.n42 0.0069091140296213f
CMODEL21098 a_9600_n35917.n1 vdd.n43 0.000838401061354809f
CMODEL21099 a_9600_n35917.n1 vdd.t13 8.5785691323363e-05f
CMODEL21100 a_9600_n35917.n1 vdd.t12 0.000678091442404661f
CMODEL21101 a_9600_n35917.n1 vdd.n44 0.000838401061354809f
CMODEL21102 a_9600_n35917.n1 vdd.t23 8.5785691323363e-05f
CMODEL21103 a_9600_n35917.n1 vdd.t22 0.000678091442404661f
CMODEL21104 a_9600_n35917.n1 vdd.n45 0.00103497117064422f
CMODEL21105 a_9600_n35917.n1 vdd.n46 0.0170832751759566f
CMODEL21106 a_9600_n35917.t1 vdd 5.55774260441386e-07f
CMODEL21107 a_9600_n35917.t1 vdd.n0 0.000186507499693312f
CMODEL21108 a_9600_n35917.t1 vdd.n1 1.72837913516373e-05f
CMODEL21109 a_9600_n35917.t1 vdd.t7 1.42481356854583e-06f
CMODEL21110 a_9600_n35917.t1 vdd.t6 1.1262413031226e-05f
CMODEL21111 a_9600_n35917.t1 vdd.n2 1.54990711781637e-05f
CMODEL21112 a_9600_n35917.t1 vdd.t27 1.42481356854583e-06f
CMODEL21113 a_9600_n35917.t1 vdd.t26 1.1262413031226e-05f
CMODEL21114 a_9600_n35917.t1 vdd.n3 2.90705140592738e-05f
CMODEL21115 a_9600_n35917.t1 vdd.n4 1.54990711781637e-05f
CMODEL21116 a_9600_n35917.t1 vdd.t36 1.42481356854583e-06f
CMODEL21117 a_9600_n35917.t1 vdd.t35 1.1262413031226e-05f
CMODEL21118 a_9600_n35917.t1 vdd.n5 2.21147384771439e-05f
CMODEL21119 a_9600_n35917.t1 vdd.t3 2.26964202185093e-06f
CMODEL21120 a_9600_n35917.t1 vdd.n6 2.17148567505243e-05f
CMODEL21121 a_9600_n35917.t1 vdd.t2 2.84588150864716e-05f
CMODEL21122 a_9600_n35917.t1 vdd.n7 2.91096669698436e-05f
CMODEL21123 a_9600_n35917.t1 vdd.t25 2.26964202185093e-06f
CMODEL21124 a_9600_n35917.t1 vdd.n8 1.31159640214814e-05f
CMODEL21125 a_9600_n35917.t1 vdd.t24 2.84588150864716e-05f
CMODEL21126 a_9600_n35917.t1 vdd.n9 2.91096669698436e-05f
CMODEL21127 a_9600_n35917.t1 vdd.t5 2.26964202185093e-06f
CMODEL21128 a_9600_n35917.t1 vdd.n10 3.88375991300178e-05f
CMODEL21129 a_9600_n35917.t1 vdd.t4 2.84744762506995e-05f
CMODEL21130 a_9600_n35917.t1 vdd.n11 9.39027745942014e-05f
CMODEL21131 a_9600_n35917.t1 vdd.n12 0.000231529431557533f
CMODEL21132 a_9600_n35917.t1 vdd.n13 1.75496396144063e-05f
CMODEL21133 a_9600_n35917.t1 vdd.t42 1.42481356854583e-06f
CMODEL21134 a_9600_n35917.t1 vdd.t41 1.1262413031226e-05f
CMODEL21135 a_9600_n35917.t1 vdd.n14 1.57784924499302e-05f
CMODEL21136 a_9600_n35917.t1 vdd.t9 1.42481356854583e-06f
CMODEL21137 a_9600_n35917.t1 vdd.t8 1.1262413031226e-05f
CMODEL21138 a_9600_n35917.t1 vdd.n15 3.02926069078594e-05f
CMODEL21139 a_9600_n35917.t1 vdd.t15 2.39952527718117e-06f
CMODEL21140 a_9600_n35917.t1 vdd.n16 1.88741825789829e-05f
CMODEL21141 a_9600_n35917.t1 vdd.t14 3.23681026971648e-05f
CMODEL21142 a_9600_n35917.t1 vdd.n17 2.64386554107714e-05f
CMODEL21143 a_9600_n35917.t1 vdd.t32 3.23681026971648e-05f
CMODEL21144 a_9600_n35917.t1 vdd.n18 2.60985471276217e-05f
CMODEL21145 a_9600_n35917.t1 vdd.t34 2.39952527718117e-06f
CMODEL21146 a_9600_n35917.t1 vdd.n19 2.62815217296846e-05f
CMODEL21147 a_9600_n35917.t1 vdd.t33 3.23681026971648e-05f
CMODEL21148 a_9600_n35917.t1 vdd.n20 5.24485864508035e-05f
CMODEL21149 a_9600_n35917.t1 vdd.t48 3.24299642958651e-05f
CMODEL21150 a_9600_n35917.t1 vdd.n21 9.3101967063347e-05f
CMODEL21151 a_9600_n35917.t1 vdd.n22 0.000408007260659879f
CMODEL21152 a_9600_n35917.t1 vdd.t47 4.61282626072215e-07f
CMODEL21153 a_9600_n35917.t1 vdd.t45 4.56546428990287e-07f
CMODEL21154 a_9600_n35917.t1 vdd.n23 5.21323614431013e-06f
CMODEL21155 a_9600_n35917.t1 vdd.t46 1.24416725956482e-05f
CMODEL21156 a_9600_n35917.t1 vdd.n24 1.33674562170415e-05f
CMODEL21157 a_9600_n35917.t1 vdd.t44 1.24416725956482e-05f
CMODEL21158 a_9600_n35917.t1 vdd.n25 2.10817541866105e-05f
CMODEL21159 a_9600_n35917.t1 vdd.t43 1.24686228490904e-05f
CMODEL21160 a_9600_n35917.t1 vdd.n26 0.000112799274332209f
CMODEL21161 a_9600_n35917.t1 vdd.n27 7.54086362671495e-05f
CMODEL21162 a_9600_n35917.t1 vdd.n28 1.70334737433944e-05f
CMODEL21163 a_9600_n35917.t1 vdd.t29 1.42481356854583e-06f
CMODEL21164 a_9600_n35917.t1 vdd.t28 1.1262413031226e-05f
CMODEL21165 a_9600_n35917.t1 vdd.n29 2.54266831822438e-06f
CMODEL21166 a_9600_n35917.t1 vdd.n30 8.11167390991216e-07f
CMODEL21167 a_9600_n35917.t1 vdd.t38 3.73479613925385e-07f
CMODEL21168 a_9600_n35917.t1 vdd.t40 3.73479613925385e-07f
CMODEL21169 a_9600_n35917.t1 vdd.t37 7.54690622591289e-06f
CMODEL21170 a_9600_n35917.t1 vdd.t39 7.54690622591289e-06f
CMODEL21171 a_9600_n35917.t1 vdd.n31 2.44426400299227e-06f
CMODEL21172 a_9600_n35917.t1 vdd.n32 2.94971502747828e-05f
CMODEL21173 a_9600_n35917.t1 vdd.n33 1.4946232080918e-05f
CMODEL21174 a_9600_n35917.t1 vdd.t17 1.42481356854583e-06f
CMODEL21175 a_9600_n35917.t1 vdd.t16 1.1262413031226e-05f
CMODEL21176 a_9600_n35917.t1 vdd.n34 2.54266831822438e-06f
CMODEL21177 a_9600_n35917.t1 vdd.n35 8.11167390991216e-07f
CMODEL21178 a_9600_n35917.t1 vdd.t1 3.73479613925385e-07f
CMODEL21179 a_9600_n35917.t1 vdd.t31 3.73479613925385e-07f
CMODEL21180 a_9600_n35917.t1 vdd.t0 7.54690622591289e-06f
CMODEL21181 a_9600_n35917.t1 vdd.t30 7.54690622591289e-06f
CMODEL21182 a_9600_n35917.t1 vdd.n36 2.44426400299227e-06f
CMODEL21183 a_9600_n35917.t1 vdd.n37 2.86064215593197e-05f
CMODEL21184 a_9600_n35917.t1 vdd.n38 1.65015161984526e-05f
CMODEL21185 a_9600_n35917.t1 vdd.t19 1.42481356854583e-06f
CMODEL21186 a_9600_n35917.t1 vdd.t18 1.1262413031226e-05f
CMODEL21187 a_9600_n35917.t1 vdd.n39 1.39249936635555e-05f
CMODEL21188 a_9600_n35917.t1 vdd.t21 1.42482661951602e-06f
CMODEL21189 a_9600_n35917.t1 vdd.t20 1.1262413031226e-05f
CMODEL21190 a_9600_n35917.t1 vdd.n40 1.39249936635555e-05f
CMODEL21191 a_9600_n35917.t1 vdd.t11 1.42481356854583e-06f
CMODEL21192 a_9600_n35917.t1 vdd.t10 1.1262413031226e-05f
CMODEL21193 a_9600_n35917.t1 vdd.n41 5.99078684628611e-05f
CMODEL21194 a_9600_n35917.t1 vdd.n42 0.000114753396098748f
CMODEL21195 a_9600_n35917.t1 vdd.n43 1.39249936635555e-05f
CMODEL21196 a_9600_n35917.t1 vdd.t13 1.42481356854583e-06f
CMODEL21197 a_9600_n35917.t1 vdd.t12 1.1262413031226e-05f
CMODEL21198 a_9600_n35917.t1 vdd.n44 1.39249936635555e-05f
CMODEL21199 a_9600_n35917.t1 vdd.t23 1.42481356854583e-06f
CMODEL21200 a_9600_n35917.t1 vdd.t22 1.1262413031226e-05f
CMODEL21201 a_9600_n35917.t1 vdd.n45 1.71898243662698e-05f
CMODEL21202 a_9600_n35917.t1 vdd.n46 0.000283735922511313f
.ends
