* COMETRAM R4 extracted integrated functional test
.lib "/opt/pdk/sky130A/libs.tech/ngspice/sky130.lib.spice" tt
.include "cell.spice"
VPCB pc_b 0 1.8

.option scale=1u
.temp 27
VDD vdd 0 1.8
XTOP vdd 0 a en dl we pc_b sa_en dout comet_ram_2x1
.model SWTEST SW(Ron=10 Roff=1e15 Vt=0.9 Vh=0)
* Ideal write switch removed
* Ideal write switch removed
CBL xtop.a_0_n11917.t0 0 10f
CBR xtop.a_1600_n11917.t0 0 10f

VA a 0 PWL(0 0 10n 0 10.1n 1.8 20n 1.8 20.1n 0 30n 0 30.1n 1.8)
VDL dl 0 PWL(0 0 10n 0 10.1n 1.8 30n 1.8 30.1n 0)
VDR dr 0 PWL(0 1.8 10n 1.8 10.1n 0 30n 0 30.1n 1.8)
VWE we 0 PWL(0 1.8 8n 1.8 8.1n 0 11n 0 11.1n 1.8 18n 1.8 18.1n 0 21n 0 21.1n 1.8 28n 1.8 28.1n 0 31n 0 31.1n 1.8 38n 1.8 38.1n 0)
VPC pc 0 0
VEN en 0 PWL(0 0 2n 0 2.1n 1.8 7n 1.8 7.1n 0 12n 0 12.1n 1.8 17n 1.8 17.1n 0 22n 0 22.1n 1.8 27n 1.8 27.1n 0 32n 0 32.1n 1.8 37n 1.8 37.1n 0)
.tran 10p 40n
.meas tran r0_init_q FIND v(xtop.a_20000_6483.t0) AT=19n
.meas tran r0_init_qb FIND v(xtop.a_19896_8041.t0) AT=19n
.meas tran r1_init_q FIND v(xtop.a_20000_14483.t0) AT=19n
.meas tran r1_init_qb FIND v(xtop.a_19896_16041.t0) AT=19n
.meas tran r0_select_q FIND v(xtop.a_20000_6483.t0) AT=26n
.meas tran r0_select_qb FIND v(xtop.a_19896_8041.t0) AT=26n
.meas tran r1_unselected_q FIND v(xtop.a_20000_14483.t0) AT=26n
.meas tran r1_unselected_qb FIND v(xtop.a_19896_16041.t0) AT=26n
.meas tran r0_hold_q FIND v(xtop.a_20000_6483.t0) AT=29n
.meas tran r0_hold_qb FIND v(xtop.a_19896_8041.t0) AT=29n
.meas tran r1_hold_q FIND v(xtop.a_20000_14483.t0) AT=29n
.meas tran r1_hold_qb FIND v(xtop.a_19896_16041.t0) AT=29n
.meas tran r0_unselected_q FIND v(xtop.a_20000_6483.t0) AT=36n
.meas tran r0_unselected_qb FIND v(xtop.a_19896_8041.t0) AT=36n
.meas tran r1_select_q FIND v(xtop.a_20000_14483.t0) AT=36n
.meas tran r1_select_qb FIND v(xtop.a_19896_16041.t0) AT=36n
.meas tran r0_final_q FIND v(xtop.a_20000_6483.t0) AT=39n
.meas tran r0_final_qb FIND v(xtop.a_19896_8041.t0) AT=39n
.meas tran r1_final_q FIND v(xtop.a_20000_14483.t0) AT=39n
.meas tran r1_final_qb FIND v(xtop.a_19896_16041.t0) AT=39n
VSA sa_en 0 0
COUT dout 0 10f
.meas tran an00000 FIND v(a) AT=19n
.meas tran an00001 FIND v(xtop.a.n0) AT=19n
.meas tran an00002 FIND v(xtop.a.t0) AT=19n
.meas tran an00003 FIND v(xtop.a.t1) AT=19n
.meas tran an00004 FIND v(xtop.a.t2) AT=19n
.meas tran an00005 FIND v(xtop.a.t3) AT=19n
.meas tran an00006 FIND v(xtop.a_0_83.n0) AT=19n
.meas tran an00007 FIND v(xtop.a_0_83.t0) AT=19n
.meas tran an00008 FIND v(xtop.a_0_83.t1) AT=19n
.meas tran an00009 FIND v(xtop.a_0_83.t2) AT=19n
.meas tran an00010 FIND v(xtop.a_0_83.t3) AT=19n
.meas tran an00011 FIND v(xtop.a_0_n11917.n0) AT=19n
.meas tran an00012 FIND v(xtop.a_0_n11917.n1) AT=19n
.meas tran an00013 FIND v(xtop.a_0_n11917.n2) AT=19n
.meas tran an00014 FIND v(xtop.a_0_n11917.n3) AT=19n
.meas tran an00015 FIND v(xtop.a_0_n11917.n4) AT=19n
.meas tran an00016 FIND v(xtop.a_0_n11917.t0) AT=19n
.meas tran an00017 FIND v(xtop.a_0_n11917.t1) AT=19n
.meas tran an00018 FIND v(xtop.a_0_n11917.t2) AT=19n
.meas tran an00019 FIND v(xtop.a_0_n11917.t3) AT=19n
.meas tran an00020 FIND v(xtop.a_0_n11917.t4) AT=19n
.meas tran an00021 FIND v(xtop.a_0_n11917.t5) AT=19n
.meas tran an00022 FIND v(xtop.a_0_n11917.t6) AT=19n
.meas tran an00023 FIND v(xtop.a_0_n23917.n0) AT=19n
.meas tran an00024 FIND v(xtop.a_0_n23917.n1) AT=19n
.meas tran an00025 FIND v(xtop.a_0_n23917.t0) AT=19n
.meas tran an00026 FIND v(xtop.a_0_n23917.t1) AT=19n
.meas tran an00027 FIND v(xtop.a_0_n23917.t2) AT=19n
.meas tran an00028 FIND v(xtop.a_0_n23917.t3) AT=19n
.meas tran an00029 FIND v(xtop.a_0_n35917.n0) AT=19n
.meas tran an00030 FIND v(xtop.a_0_n35917.t0) AT=19n
.meas tran an00031 FIND v(xtop.a_0_n35917.t1) AT=19n
.meas tran an00032 FIND v(xtop.a_0_n35917.t2) AT=19n
.meas tran an00033 FIND v(xtop.a_0_n35917.t3) AT=19n
.meas tran an00034 FIND v(xtop.a_11200_n23917.t0) AT=19n
.meas tran an00035 FIND v(xtop.a_11200_n23917.t1) AT=19n
.meas tran an00036 FIND v(xtop.a_12800_83.n0) AT=19n
.meas tran an00037 FIND v(xtop.a_12800_83.n1) AT=19n
.meas tran an00038 FIND v(xtop.a_12800_83.t0) AT=19n
.meas tran an00039 FIND v(xtop.a_12800_83.t1) AT=19n
.meas tran an00040 FIND v(xtop.a_12800_83.t2) AT=19n
.meas tran an00041 FIND v(xtop.a_12800_83.t3) AT=19n
.meas tran an00042 FIND v(xtop.a_16000_n24000.t0) AT=19n
.meas tran an00043 FIND v(xtop.a_16000_n24000.t1) AT=19n
.meas tran an00044 FIND v(xtop.a_1600_n11917.n0) AT=19n
.meas tran an00045 FIND v(xtop.a_1600_n11917.n1) AT=19n
.meas tran an00046 FIND v(xtop.a_1600_n11917.n2) AT=19n
.meas tran an00047 FIND v(xtop.a_1600_n11917.n3) AT=19n
.meas tran an00048 FIND v(xtop.a_1600_n11917.n4) AT=19n
.meas tran an00049 FIND v(xtop.a_1600_n11917.t0) AT=19n
.meas tran an00050 FIND v(xtop.a_1600_n11917.t1) AT=19n
.meas tran an00051 FIND v(xtop.a_1600_n11917.t2) AT=19n
.meas tran an00052 FIND v(xtop.a_1600_n11917.t3) AT=19n
.meas tran an00053 FIND v(xtop.a_1600_n11917.t4) AT=19n
.meas tran an00054 FIND v(xtop.a_1600_n11917.t5) AT=19n
.meas tran an00055 FIND v(xtop.a_1600_n11917.t6) AT=19n
.meas tran an00056 FIND v(xtop.a_19896_16041.n0) AT=19n
.meas tran an00057 FIND v(xtop.a_19896_16041.n1) AT=19n
.meas tran an00058 FIND v(xtop.a_19896_16041.t0) AT=19n
.meas tran an00059 FIND v(xtop.a_19896_16041.t1) AT=19n
.meas tran an00060 FIND v(xtop.a_19896_16041.t2) AT=19n
.meas tran an00061 FIND v(xtop.a_19896_16041.t3) AT=19n
.meas tran an00062 FIND v(xtop.a_19896_16041.t4) AT=19n
.meas tran an00063 FIND v(xtop.a_19896_8041.n0) AT=19n
.meas tran an00064 FIND v(xtop.a_19896_8041.n1) AT=19n
.meas tran an00065 FIND v(xtop.a_19896_8041.t0) AT=19n
.meas tran an00066 FIND v(xtop.a_19896_8041.t1) AT=19n
.meas tran an00067 FIND v(xtop.a_19896_8041.t2) AT=19n
.meas tran an00068 FIND v(xtop.a_19896_8041.t3) AT=19n
.meas tran an00069 FIND v(xtop.a_19896_8041.t4) AT=19n
.meas tran an00070 FIND v(xtop.a_20000_14483.n0) AT=19n
.meas tran an00071 FIND v(xtop.a_20000_14483.n1) AT=19n
.meas tran an00072 FIND v(xtop.a_20000_14483.t0) AT=19n
.meas tran an00073 FIND v(xtop.a_20000_14483.t1) AT=19n
.meas tran an00074 FIND v(xtop.a_20000_14483.t2) AT=19n
.meas tran an00075 FIND v(xtop.a_20000_14483.t3) AT=19n
.meas tran an00076 FIND v(xtop.a_20000_14483.t4) AT=19n
.meas tran an00077 FIND v(xtop.a_20000_6483.n0) AT=19n
.meas tran an00078 FIND v(xtop.a_20000_6483.n1) AT=19n
.meas tran an00079 FIND v(xtop.a_20000_6483.t0) AT=19n
.meas tran an00080 FIND v(xtop.a_20000_6483.t1) AT=19n
.meas tran an00081 FIND v(xtop.a_20000_6483.t2) AT=19n
.meas tran an00082 FIND v(xtop.a_20000_6483.t3) AT=19n
.meas tran an00083 FIND v(xtop.a_20000_6483.t4) AT=19n
.meas tran an00084 FIND v(xtop.a_20800_n23917.t0) AT=19n
.meas tran an00085 FIND v(xtop.a_20800_n23917.t1) AT=19n
.meas tran an00086 FIND v(xtop.a_3200_169.n0) AT=19n
.meas tran an00087 FIND v(xtop.a_3200_169.n1) AT=19n
.meas tran an00088 FIND v(xtop.a_3200_169.t0) AT=19n
.meas tran an00089 FIND v(xtop.a_3200_169.t1) AT=19n
.meas tran an00090 FIND v(xtop.a_3200_169.t2) AT=19n
.meas tran an00091 FIND v(xtop.a_3200_169.t3) AT=19n
.meas tran an00092 FIND v(xtop.a_3200_169.t4) AT=19n
.meas tran an00093 FIND v(xtop.a_3200_83.t0) AT=19n
.meas tran an00094 FIND v(xtop.a_3200_83.t1) AT=19n
.meas tran an00095 FIND v(xtop.a_3200_n23917.n0) AT=19n
.meas tran an00096 FIND v(xtop.a_3200_n23917.n1) AT=19n
.meas tran an00097 FIND v(xtop.a_3200_n23917.t0) AT=19n
.meas tran an00098 FIND v(xtop.a_3200_n23917.t1) AT=19n
.meas tran an00099 FIND v(xtop.a_3200_n23917.t2) AT=19n
.meas tran an00100 FIND v(xtop.a_3200_n23917.t3) AT=19n
.meas tran an00101 FIND v(xtop.a_3200_n35917.n0) AT=19n
.meas tran an00102 FIND v(xtop.a_3200_n35917.t0) AT=19n
.meas tran an00103 FIND v(xtop.a_3200_n35917.t1) AT=19n
.meas tran an00104 FIND v(xtop.a_3200_n35917.t2) AT=19n
.meas tran an00105 FIND v(xtop.a_3200_n35917.t3) AT=19n
.meas tran an00106 FIND v(xtop.a_6400_83.n0) AT=19n
.meas tran an00107 FIND v(xtop.a_6400_83.n1) AT=19n
.meas tran an00108 FIND v(xtop.a_6400_83.t0) AT=19n
.meas tran an00109 FIND v(xtop.a_6400_83.t1) AT=19n
.meas tran an00110 FIND v(xtop.a_6400_83.t2) AT=19n
.meas tran an00111 FIND v(xtop.a_6400_83.t3) AT=19n
.meas tran an00112 FIND v(xtop.a_6400_n24000.t0) AT=19n
.meas tran an00113 FIND v(xtop.a_6400_n24000.t1) AT=19n
.meas tran an00114 FIND v(xtop.a_9600_169.n0) AT=19n
.meas tran an00115 FIND v(xtop.a_9600_169.n1) AT=19n
.meas tran an00116 FIND v(xtop.a_9600_169.t0) AT=19n
.meas tran an00117 FIND v(xtop.a_9600_169.t1) AT=19n
.meas tran an00118 FIND v(xtop.a_9600_169.t2) AT=19n
.meas tran an00119 FIND v(xtop.a_9600_169.t3) AT=19n
.meas tran an00120 FIND v(xtop.a_9600_169.t4) AT=19n
.meas tran an00121 FIND v(xtop.a_9600_83.t0) AT=19n
.meas tran an00122 FIND v(xtop.a_9600_83.t1) AT=19n
.meas tran an00123 FIND v(xtop.a_9600_n35917.n0) AT=19n
.meas tran an00124 FIND v(xtop.a_9600_n35917.n1) AT=19n
.meas tran an00125 FIND v(xtop.a_9600_n35917.t0) AT=19n
.meas tran an00126 FIND v(xtop.a_9600_n35917.t1) AT=19n
.meas tran an00127 FIND v(xtop.a_9600_n35917.t2) AT=19n
.meas tran an00128 FIND v(xtop.a_9600_n36000.n0) AT=19n
.meas tran an00129 FIND v(xtop.a_9600_n36000.n1) AT=19n
.meas tran an00130 FIND v(xtop.a_9600_n36000.t0) AT=19n
.meas tran an00131 FIND v(xtop.a_9600_n36000.t1) AT=19n
.meas tran an00132 FIND v(xtop.a_9600_n36000.t2) AT=19n
.meas tran an00133 FIND v(xtop.a_9600_n36000.t3) AT=19n
.meas tran an00134 FIND v(xtop.a_n104_n35959.n0) AT=19n
.meas tran an00135 FIND v(xtop.a_n104_n35959.n1) AT=19n
.meas tran an00136 FIND v(xtop.a_n104_n35959.t0) AT=19n
.meas tran an00137 FIND v(xtop.a_n104_n35959.t1) AT=19n
.meas tran an00138 FIND v(xtop.a_n104_n35959.t2) AT=19n
.meas tran an00139 FIND v(xtop.a_n104_n35959.t3) AT=19n
.meas tran an00140 FIND v(xtop.a_n104_n35959.t4) AT=19n
.meas tran an00141 FIND v(dl) AT=19n
.meas tran an00142 FIND v(xtop.din.n0) AT=19n
.meas tran an00143 FIND v(xtop.din.n1) AT=19n
.meas tran an00144 FIND v(xtop.din.t0) AT=19n
.meas tran an00145 FIND v(xtop.din.t1) AT=19n
.meas tran an00146 FIND v(xtop.din.t2) AT=19n
.meas tran an00147 FIND v(xtop.din.t3) AT=19n
.meas tran an00148 FIND v(dout) AT=19n
.meas tran an00149 FIND v(xtop.dout.n0) AT=19n
.meas tran an00150 FIND v(xtop.dout.t0) AT=19n
.meas tran an00151 FIND v(xtop.dout.t1) AT=19n
.meas tran an00152 FIND v(en) AT=19n
.meas tran an00153 FIND v(xtop.en.n0) AT=19n
.meas tran an00154 FIND v(xtop.en.t0) AT=19n
.meas tran an00155 FIND v(xtop.en.t1) AT=19n
.meas tran an00156 FIND v(xtop.en.t2) AT=19n
.meas tran an00157 FIND v(xtop.en.t3) AT=19n
.meas tran an00158 FIND v(pc_b) AT=19n
.meas tran an00159 FIND v(xtop.pc_b.n0) AT=19n
.meas tran an00160 FIND v(xtop.pc_b.n1) AT=19n
.meas tran an00161 FIND v(xtop.pc_b.t0) AT=19n
.meas tran an00162 FIND v(xtop.pc_b.t1) AT=19n
.meas tran an00163 FIND v(xtop.pc_b.t2) AT=19n
.meas tran an00164 FIND v(sa_en) AT=19n
.meas tran an00165 FIND v(xtop.sa_en.n0) AT=19n
.meas tran an00166 FIND v(xtop.sa_en.t0) AT=19n
.meas tran an00167 FIND v(xtop.sa_en.t1) AT=19n
.meas tran an00168 FIND v(vdd) AT=19n
.meas tran an00169 FIND v(xtop.vdd.n0) AT=19n
.meas tran an00170 FIND v(xtop.vdd.n1) AT=19n
.meas tran an00171 FIND v(xtop.vdd.n10) AT=19n
.meas tran an00172 FIND v(xtop.vdd.n11) AT=19n
.meas tran an00173 FIND v(xtop.vdd.n12) AT=19n
.meas tran an00174 FIND v(xtop.vdd.n13) AT=19n
.meas tran an00175 FIND v(xtop.vdd.n14) AT=19n
.meas tran an00176 FIND v(xtop.vdd.n15) AT=19n
.meas tran an00177 FIND v(xtop.vdd.n16) AT=19n
.meas tran an00178 FIND v(xtop.vdd.n17) AT=19n
.meas tran an00179 FIND v(xtop.vdd.n18) AT=19n
.meas tran an00180 FIND v(xtop.vdd.n19) AT=19n
.meas tran an00181 FIND v(xtop.vdd.n2) AT=19n
.meas tran an00182 FIND v(xtop.vdd.n20) AT=19n
.meas tran an00183 FIND v(xtop.vdd.n21) AT=19n
.meas tran an00184 FIND v(xtop.vdd.n22) AT=19n
.meas tran an00185 FIND v(xtop.vdd.n23) AT=19n
.meas tran an00186 FIND v(xtop.vdd.n24) AT=19n
.meas tran an00187 FIND v(xtop.vdd.n25) AT=19n
.meas tran an00188 FIND v(xtop.vdd.n26) AT=19n
.meas tran an00189 FIND v(xtop.vdd.n27) AT=19n
.meas tran an00190 FIND v(xtop.vdd.n28) AT=19n
.meas tran an00191 FIND v(xtop.vdd.n29) AT=19n
.meas tran an00192 FIND v(xtop.vdd.n3) AT=19n
.meas tran an00193 FIND v(xtop.vdd.n30) AT=19n
.meas tran an00194 FIND v(xtop.vdd.n31) AT=19n
.meas tran an00195 FIND v(xtop.vdd.n32) AT=19n
.meas tran an00196 FIND v(xtop.vdd.n33) AT=19n
.meas tran an00197 FIND v(xtop.vdd.n34) AT=19n
.meas tran an00198 FIND v(xtop.vdd.n35) AT=19n
.meas tran an00199 FIND v(xtop.vdd.n36) AT=19n
.meas tran an00200 FIND v(xtop.vdd.n37) AT=19n
.meas tran an00201 FIND v(xtop.vdd.n38) AT=19n
.meas tran an00202 FIND v(xtop.vdd.n39) AT=19n
.meas tran an00203 FIND v(xtop.vdd.n4) AT=19n
.meas tran an00204 FIND v(xtop.vdd.n40) AT=19n
.meas tran an00205 FIND v(xtop.vdd.n41) AT=19n
.meas tran an00206 FIND v(xtop.vdd.n42) AT=19n
.meas tran an00207 FIND v(xtop.vdd.n43) AT=19n
.meas tran an00208 FIND v(xtop.vdd.n44) AT=19n
.meas tran an00209 FIND v(xtop.vdd.n45) AT=19n
.meas tran an00210 FIND v(xtop.vdd.n46) AT=19n
.meas tran an00211 FIND v(xtop.vdd.n5) AT=19n
.meas tran an00212 FIND v(xtop.vdd.n6) AT=19n
.meas tran an00213 FIND v(xtop.vdd.n7) AT=19n
.meas tran an00214 FIND v(xtop.vdd.n8) AT=19n
.meas tran an00215 FIND v(xtop.vdd.n9) AT=19n
.meas tran an00216 FIND v(xtop.vdd.t0) AT=19n
.meas tran an00217 FIND v(xtop.vdd.t1) AT=19n
.meas tran an00218 FIND v(xtop.vdd.t10) AT=19n
.meas tran an00219 FIND v(xtop.vdd.t11) AT=19n
.meas tran an00220 FIND v(xtop.vdd.t12) AT=19n
.meas tran an00221 FIND v(xtop.vdd.t13) AT=19n
.meas tran an00222 FIND v(xtop.vdd.t14) AT=19n
.meas tran an00223 FIND v(xtop.vdd.t15) AT=19n
.meas tran an00224 FIND v(xtop.vdd.t16) AT=19n
.meas tran an00225 FIND v(xtop.vdd.t17) AT=19n
.meas tran an00226 FIND v(xtop.vdd.t18) AT=19n
.meas tran an00227 FIND v(xtop.vdd.t19) AT=19n
.meas tran an00228 FIND v(xtop.vdd.t2) AT=19n
.meas tran an00229 FIND v(xtop.vdd.t20) AT=19n
.meas tran an00230 FIND v(xtop.vdd.t21) AT=19n
.meas tran an00231 FIND v(xtop.vdd.t22) AT=19n
.meas tran an00232 FIND v(xtop.vdd.t23) AT=19n
.meas tran an00233 FIND v(xtop.vdd.t24) AT=19n
.meas tran an00234 FIND v(xtop.vdd.t25) AT=19n
.meas tran an00235 FIND v(xtop.vdd.t26) AT=19n
.meas tran an00236 FIND v(xtop.vdd.t27) AT=19n
.meas tran an00237 FIND v(xtop.vdd.t28) AT=19n
.meas tran an00238 FIND v(xtop.vdd.t29) AT=19n
.meas tran an00239 FIND v(xtop.vdd.t3) AT=19n
.meas tran an00240 FIND v(xtop.vdd.t30) AT=19n
.meas tran an00241 FIND v(xtop.vdd.t31) AT=19n
.meas tran an00242 FIND v(xtop.vdd.t32) AT=19n
.meas tran an00243 FIND v(xtop.vdd.t33) AT=19n
.meas tran an00244 FIND v(xtop.vdd.t34) AT=19n
.meas tran an00245 FIND v(xtop.vdd.t35) AT=19n
.meas tran an00246 FIND v(xtop.vdd.t36) AT=19n
.meas tran an00247 FIND v(xtop.vdd.t37) AT=19n
.meas tran an00248 FIND v(xtop.vdd.t38) AT=19n
.meas tran an00249 FIND v(xtop.vdd.t39) AT=19n
.meas tran an00250 FIND v(xtop.vdd.t4) AT=19n
.meas tran an00251 FIND v(xtop.vdd.t40) AT=19n
.meas tran an00252 FIND v(xtop.vdd.t41) AT=19n
.meas tran an00253 FIND v(xtop.vdd.t42) AT=19n
.meas tran an00254 FIND v(xtop.vdd.t43) AT=19n
.meas tran an00255 FIND v(xtop.vdd.t44) AT=19n
.meas tran an00256 FIND v(xtop.vdd.t45) AT=19n
.meas tran an00257 FIND v(xtop.vdd.t46) AT=19n
.meas tran an00258 FIND v(xtop.vdd.t47) AT=19n
.meas tran an00259 FIND v(xtop.vdd.t48) AT=19n
.meas tran an00260 FIND v(xtop.vdd.t5) AT=19n
.meas tran an00261 FIND v(xtop.vdd.t6) AT=19n
.meas tran an00262 FIND v(xtop.vdd.t7) AT=19n
.meas tran an00263 FIND v(xtop.vdd.t8) AT=19n
.meas tran an00264 FIND v(xtop.vdd.t9) AT=19n
.meas tran an00266 FIND v(xtop.vss.n0) AT=19n
.meas tran an00267 FIND v(xtop.vss.n1) AT=19n
.meas tran an00268 FIND v(xtop.vss.n10) AT=19n
.meas tran an00269 FIND v(xtop.vss.n11) AT=19n
.meas tran an00270 FIND v(xtop.vss.n12) AT=19n
.meas tran an00271 FIND v(xtop.vss.n13) AT=19n
.meas tran an00272 FIND v(xtop.vss.n14) AT=19n
.meas tran an00273 FIND v(xtop.vss.n15) AT=19n
.meas tran an00274 FIND v(xtop.vss.n16) AT=19n
.meas tran an00275 FIND v(xtop.vss.n17) AT=19n
.meas tran an00276 FIND v(xtop.vss.n18) AT=19n
.meas tran an00277 FIND v(xtop.vss.n19) AT=19n
.meas tran an00278 FIND v(xtop.vss.n2) AT=19n
.meas tran an00279 FIND v(xtop.vss.n20) AT=19n
.meas tran an00280 FIND v(xtop.vss.n21) AT=19n
.meas tran an00281 FIND v(xtop.vss.n22) AT=19n
.meas tran an00282 FIND v(xtop.vss.n23) AT=19n
.meas tran an00283 FIND v(xtop.vss.n24) AT=19n
.meas tran an00284 FIND v(xtop.vss.n25) AT=19n
.meas tran an00285 FIND v(xtop.vss.n26) AT=19n
.meas tran an00286 FIND v(xtop.vss.n27) AT=19n
.meas tran an00287 FIND v(xtop.vss.n28) AT=19n
.meas tran an00288 FIND v(xtop.vss.n29) AT=19n
.meas tran an00289 FIND v(xtop.vss.n3) AT=19n
.meas tran an00290 FIND v(xtop.vss.n30) AT=19n
.meas tran an00291 FIND v(xtop.vss.n31) AT=19n
.meas tran an00292 FIND v(xtop.vss.n32) AT=19n
.meas tran an00293 FIND v(xtop.vss.n33) AT=19n
.meas tran an00294 FIND v(xtop.vss.n34) AT=19n
.meas tran an00295 FIND v(xtop.vss.n35) AT=19n
.meas tran an00296 FIND v(xtop.vss.n36) AT=19n
.meas tran an00297 FIND v(xtop.vss.n37) AT=19n
.meas tran an00298 FIND v(xtop.vss.n38) AT=19n
.meas tran an00299 FIND v(xtop.vss.n39) AT=19n
.meas tran an00300 FIND v(xtop.vss.n4) AT=19n
.meas tran an00301 FIND v(xtop.vss.n40) AT=19n
.meas tran an00302 FIND v(xtop.vss.n41) AT=19n
.meas tran an00303 FIND v(xtop.vss.n42) AT=19n
.meas tran an00304 FIND v(xtop.vss.n43) AT=19n
.meas tran an00305 FIND v(xtop.vss.n44) AT=19n
.meas tran an00306 FIND v(xtop.vss.n45) AT=19n
.meas tran an00307 FIND v(xtop.vss.n46) AT=19n
.meas tran an00308 FIND v(xtop.vss.n47) AT=19n
.meas tran an00309 FIND v(xtop.vss.n48) AT=19n
.meas tran an00310 FIND v(xtop.vss.n49) AT=19n
.meas tran an00311 FIND v(xtop.vss.n5) AT=19n
.meas tran an00312 FIND v(xtop.vss.n50) AT=19n
.meas tran an00313 FIND v(xtop.vss.n51) AT=19n
.meas tran an00314 FIND v(xtop.vss.n52) AT=19n
.meas tran an00315 FIND v(xtop.vss.n53) AT=19n
.meas tran an00316 FIND v(xtop.vss.n54) AT=19n
.meas tran an00317 FIND v(xtop.vss.n55) AT=19n
.meas tran an00318 FIND v(xtop.vss.n56) AT=19n
.meas tran an00319 FIND v(xtop.vss.n57) AT=19n
.meas tran an00320 FIND v(xtop.vss.n58) AT=19n
.meas tran an00321 FIND v(xtop.vss.n59) AT=19n
.meas tran an00322 FIND v(xtop.vss.n6) AT=19n
.meas tran an00323 FIND v(xtop.vss.n60) AT=19n
.meas tran an00324 FIND v(xtop.vss.n61) AT=19n
.meas tran an00325 FIND v(xtop.vss.n62) AT=19n
.meas tran an00326 FIND v(xtop.vss.n63) AT=19n
.meas tran an00327 FIND v(xtop.vss.n64) AT=19n
.meas tran an00328 FIND v(xtop.vss.n65) AT=19n
.meas tran an00329 FIND v(xtop.vss.n66) AT=19n
.meas tran an00330 FIND v(xtop.vss.n67) AT=19n
.meas tran an00331 FIND v(xtop.vss.n68) AT=19n
.meas tran an00332 FIND v(xtop.vss.n69) AT=19n
.meas tran an00333 FIND v(xtop.vss.n7) AT=19n
.meas tran an00334 FIND v(xtop.vss.n70) AT=19n
.meas tran an00335 FIND v(xtop.vss.n71) AT=19n
.meas tran an00336 FIND v(xtop.vss.n72) AT=19n
.meas tran an00337 FIND v(xtop.vss.n73) AT=19n
.meas tran an00338 FIND v(xtop.vss.n74) AT=19n
.meas tran an00339 FIND v(xtop.vss.n75) AT=19n
.meas tran an00340 FIND v(xtop.vss.n76) AT=19n
.meas tran an00341 FIND v(xtop.vss.n77) AT=19n
.meas tran an00342 FIND v(xtop.vss.n78) AT=19n
.meas tran an00343 FIND v(xtop.vss.n79) AT=19n
.meas tran an00344 FIND v(xtop.vss.n8) AT=19n
.meas tran an00345 FIND v(xtop.vss.n9) AT=19n
.meas tran an00346 FIND v(xtop.vss.t0) AT=19n
.meas tran an00347 FIND v(xtop.vss.t1) AT=19n
.meas tran an00348 FIND v(xtop.vss.t10) AT=19n
.meas tran an00349 FIND v(xtop.vss.t11) AT=19n
.meas tran an00350 FIND v(xtop.vss.t12) AT=19n
.meas tran an00351 FIND v(xtop.vss.t13) AT=19n
.meas tran an00352 FIND v(xtop.vss.t14) AT=19n
.meas tran an00353 FIND v(xtop.vss.t15) AT=19n
.meas tran an00354 FIND v(xtop.vss.t16) AT=19n
.meas tran an00355 FIND v(xtop.vss.t17) AT=19n
.meas tran an00356 FIND v(xtop.vss.t18) AT=19n
.meas tran an00357 FIND v(xtop.vss.t19) AT=19n
.meas tran an00358 FIND v(xtop.vss.t2) AT=19n
.meas tran an00359 FIND v(xtop.vss.t20) AT=19n
.meas tran an00360 FIND v(xtop.vss.t21) AT=19n
.meas tran an00361 FIND v(xtop.vss.t22) AT=19n
.meas tran an00362 FIND v(xtop.vss.t23) AT=19n
.meas tran an00363 FIND v(xtop.vss.t24) AT=19n
.meas tran an00364 FIND v(xtop.vss.t25) AT=19n
.meas tran an00365 FIND v(xtop.vss.t26) AT=19n
.meas tran an00366 FIND v(xtop.vss.t27) AT=19n
.meas tran an00367 FIND v(xtop.vss.t28) AT=19n
.meas tran an00368 FIND v(xtop.vss.t29) AT=19n
.meas tran an00369 FIND v(xtop.vss.t3) AT=19n
.meas tran an00370 FIND v(xtop.vss.t30) AT=19n
.meas tran an00371 FIND v(xtop.vss.t31) AT=19n
.meas tran an00372 FIND v(xtop.vss.t32) AT=19n
.meas tran an00373 FIND v(xtop.vss.t33) AT=19n
.meas tran an00374 FIND v(xtop.vss.t34) AT=19n
.meas tran an00375 FIND v(xtop.vss.t35) AT=19n
.meas tran an00376 FIND v(xtop.vss.t36) AT=19n
.meas tran an00377 FIND v(xtop.vss.t37) AT=19n
.meas tran an00378 FIND v(xtop.vss.t38) AT=19n
.meas tran an00379 FIND v(xtop.vss.t39) AT=19n
.meas tran an00380 FIND v(xtop.vss.t4) AT=19n
.meas tran an00381 FIND v(xtop.vss.t40) AT=19n
.meas tran an00382 FIND v(xtop.vss.t41) AT=19n
.meas tran an00383 FIND v(xtop.vss.t42) AT=19n
.meas tran an00384 FIND v(xtop.vss.t43) AT=19n
.meas tran an00385 FIND v(xtop.vss.t5) AT=19n
.meas tran an00386 FIND v(xtop.vss.t6) AT=19n
.meas tran an00387 FIND v(xtop.vss.t7) AT=19n
.meas tran an00388 FIND v(xtop.vss.t8) AT=19n
.meas tran an00389 FIND v(xtop.vss.t9) AT=19n
.meas tran an00390 FIND v(we) AT=19n
.meas tran an00391 FIND v(xtop.we.n0) AT=19n
.meas tran an00392 FIND v(xtop.we.n1) AT=19n
.meas tran an00393 FIND v(xtop.we.t0) AT=19n
.meas tran an00394 FIND v(xtop.we.t1) AT=19n
.meas tran an00395 FIND v(xtop.we.t2) AT=19n
.meas tran an00396 FIND v(xtop.we.t3) AT=19n
.meas tran an00397 FIND v(a) AT=26n
.meas tran an00398 FIND v(xtop.a.n0) AT=26n
.meas tran an00399 FIND v(xtop.a.t0) AT=26n
.meas tran an00400 FIND v(xtop.a.t1) AT=26n
.meas tran an00401 FIND v(xtop.a.t2) AT=26n
.meas tran an00402 FIND v(xtop.a.t3) AT=26n
.meas tran an00403 FIND v(xtop.a_0_83.n0) AT=26n
.meas tran an00404 FIND v(xtop.a_0_83.t0) AT=26n
.meas tran an00405 FIND v(xtop.a_0_83.t1) AT=26n
.meas tran an00406 FIND v(xtop.a_0_83.t2) AT=26n
.meas tran an00407 FIND v(xtop.a_0_83.t3) AT=26n
.meas tran an00408 FIND v(xtop.a_0_n11917.n0) AT=26n
.meas tran an00409 FIND v(xtop.a_0_n11917.n1) AT=26n
.meas tran an00410 FIND v(xtop.a_0_n11917.n2) AT=26n
.meas tran an00411 FIND v(xtop.a_0_n11917.n3) AT=26n
.meas tran an00412 FIND v(xtop.a_0_n11917.n4) AT=26n
.meas tran an00413 FIND v(xtop.a_0_n11917.t0) AT=26n
.meas tran an00414 FIND v(xtop.a_0_n11917.t1) AT=26n
.meas tran an00415 FIND v(xtop.a_0_n11917.t2) AT=26n
.meas tran an00416 FIND v(xtop.a_0_n11917.t3) AT=26n
.meas tran an00417 FIND v(xtop.a_0_n11917.t4) AT=26n
.meas tran an00418 FIND v(xtop.a_0_n11917.t5) AT=26n
.meas tran an00419 FIND v(xtop.a_0_n11917.t6) AT=26n
.meas tran an00420 FIND v(xtop.a_0_n23917.n0) AT=26n
.meas tran an00421 FIND v(xtop.a_0_n23917.n1) AT=26n
.meas tran an00422 FIND v(xtop.a_0_n23917.t0) AT=26n
.meas tran an00423 FIND v(xtop.a_0_n23917.t1) AT=26n
.meas tran an00424 FIND v(xtop.a_0_n23917.t2) AT=26n
.meas tran an00425 FIND v(xtop.a_0_n23917.t3) AT=26n
.meas tran an00426 FIND v(xtop.a_0_n35917.n0) AT=26n
.meas tran an00427 FIND v(xtop.a_0_n35917.t0) AT=26n
.meas tran an00428 FIND v(xtop.a_0_n35917.t1) AT=26n
.meas tran an00429 FIND v(xtop.a_0_n35917.t2) AT=26n
.meas tran an00430 FIND v(xtop.a_0_n35917.t3) AT=26n
.meas tran an00431 FIND v(xtop.a_11200_n23917.t0) AT=26n
.meas tran an00432 FIND v(xtop.a_11200_n23917.t1) AT=26n
.meas tran an00433 FIND v(xtop.a_12800_83.n0) AT=26n
.meas tran an00434 FIND v(xtop.a_12800_83.n1) AT=26n
.meas tran an00435 FIND v(xtop.a_12800_83.t0) AT=26n
.meas tran an00436 FIND v(xtop.a_12800_83.t1) AT=26n
.meas tran an00437 FIND v(xtop.a_12800_83.t2) AT=26n
.meas tran an00438 FIND v(xtop.a_12800_83.t3) AT=26n
.meas tran an00439 FIND v(xtop.a_16000_n24000.t0) AT=26n
.meas tran an00440 FIND v(xtop.a_16000_n24000.t1) AT=26n
.meas tran an00441 FIND v(xtop.a_1600_n11917.n0) AT=26n
.meas tran an00442 FIND v(xtop.a_1600_n11917.n1) AT=26n
.meas tran an00443 FIND v(xtop.a_1600_n11917.n2) AT=26n
.meas tran an00444 FIND v(xtop.a_1600_n11917.n3) AT=26n
.meas tran an00445 FIND v(xtop.a_1600_n11917.n4) AT=26n
.meas tran an00446 FIND v(xtop.a_1600_n11917.t0) AT=26n
.meas tran an00447 FIND v(xtop.a_1600_n11917.t1) AT=26n
.meas tran an00448 FIND v(xtop.a_1600_n11917.t2) AT=26n
.meas tran an00449 FIND v(xtop.a_1600_n11917.t3) AT=26n
.meas tran an00450 FIND v(xtop.a_1600_n11917.t4) AT=26n
.meas tran an00451 FIND v(xtop.a_1600_n11917.t5) AT=26n
.meas tran an00452 FIND v(xtop.a_1600_n11917.t6) AT=26n
.meas tran an00453 FIND v(xtop.a_19896_16041.n0) AT=26n
.meas tran an00454 FIND v(xtop.a_19896_16041.n1) AT=26n
.meas tran an00455 FIND v(xtop.a_19896_16041.t0) AT=26n
.meas tran an00456 FIND v(xtop.a_19896_16041.t1) AT=26n
.meas tran an00457 FIND v(xtop.a_19896_16041.t2) AT=26n
.meas tran an00458 FIND v(xtop.a_19896_16041.t3) AT=26n
.meas tran an00459 FIND v(xtop.a_19896_16041.t4) AT=26n
.meas tran an00460 FIND v(xtop.a_19896_8041.n0) AT=26n
.meas tran an00461 FIND v(xtop.a_19896_8041.n1) AT=26n
.meas tran an00462 FIND v(xtop.a_19896_8041.t0) AT=26n
.meas tran an00463 FIND v(xtop.a_19896_8041.t1) AT=26n
.meas tran an00464 FIND v(xtop.a_19896_8041.t2) AT=26n
.meas tran an00465 FIND v(xtop.a_19896_8041.t3) AT=26n
.meas tran an00466 FIND v(xtop.a_19896_8041.t4) AT=26n
.meas tran an00467 FIND v(xtop.a_20000_14483.n0) AT=26n
.meas tran an00468 FIND v(xtop.a_20000_14483.n1) AT=26n
.meas tran an00469 FIND v(xtop.a_20000_14483.t0) AT=26n
.meas tran an00470 FIND v(xtop.a_20000_14483.t1) AT=26n
.meas tran an00471 FIND v(xtop.a_20000_14483.t2) AT=26n
.meas tran an00472 FIND v(xtop.a_20000_14483.t3) AT=26n
.meas tran an00473 FIND v(xtop.a_20000_14483.t4) AT=26n
.meas tran an00474 FIND v(xtop.a_20000_6483.n0) AT=26n
.meas tran an00475 FIND v(xtop.a_20000_6483.n1) AT=26n
.meas tran an00476 FIND v(xtop.a_20000_6483.t0) AT=26n
.meas tran an00477 FIND v(xtop.a_20000_6483.t1) AT=26n
.meas tran an00478 FIND v(xtop.a_20000_6483.t2) AT=26n
.meas tran an00479 FIND v(xtop.a_20000_6483.t3) AT=26n
.meas tran an00480 FIND v(xtop.a_20000_6483.t4) AT=26n
.meas tran an00481 FIND v(xtop.a_20800_n23917.t0) AT=26n
.meas tran an00482 FIND v(xtop.a_20800_n23917.t1) AT=26n
.meas tran an00483 FIND v(xtop.a_3200_169.n0) AT=26n
.meas tran an00484 FIND v(xtop.a_3200_169.n1) AT=26n
.meas tran an00485 FIND v(xtop.a_3200_169.t0) AT=26n
.meas tran an00486 FIND v(xtop.a_3200_169.t1) AT=26n
.meas tran an00487 FIND v(xtop.a_3200_169.t2) AT=26n
.meas tran an00488 FIND v(xtop.a_3200_169.t3) AT=26n
.meas tran an00489 FIND v(xtop.a_3200_169.t4) AT=26n
.meas tran an00490 FIND v(xtop.a_3200_83.t0) AT=26n
.meas tran an00491 FIND v(xtop.a_3200_83.t1) AT=26n
.meas tran an00492 FIND v(xtop.a_3200_n23917.n0) AT=26n
.meas tran an00493 FIND v(xtop.a_3200_n23917.n1) AT=26n
.meas tran an00494 FIND v(xtop.a_3200_n23917.t0) AT=26n
.meas tran an00495 FIND v(xtop.a_3200_n23917.t1) AT=26n
.meas tran an00496 FIND v(xtop.a_3200_n23917.t2) AT=26n
.meas tran an00497 FIND v(xtop.a_3200_n23917.t3) AT=26n
.meas tran an00498 FIND v(xtop.a_3200_n35917.n0) AT=26n
.meas tran an00499 FIND v(xtop.a_3200_n35917.t0) AT=26n
.meas tran an00500 FIND v(xtop.a_3200_n35917.t1) AT=26n
.meas tran an00501 FIND v(xtop.a_3200_n35917.t2) AT=26n
.meas tran an00502 FIND v(xtop.a_3200_n35917.t3) AT=26n
.meas tran an00503 FIND v(xtop.a_6400_83.n0) AT=26n
.meas tran an00504 FIND v(xtop.a_6400_83.n1) AT=26n
.meas tran an00505 FIND v(xtop.a_6400_83.t0) AT=26n
.meas tran an00506 FIND v(xtop.a_6400_83.t1) AT=26n
.meas tran an00507 FIND v(xtop.a_6400_83.t2) AT=26n
.meas tran an00508 FIND v(xtop.a_6400_83.t3) AT=26n
.meas tran an00509 FIND v(xtop.a_6400_n24000.t0) AT=26n
.meas tran an00510 FIND v(xtop.a_6400_n24000.t1) AT=26n
.meas tran an00511 FIND v(xtop.a_9600_169.n0) AT=26n
.meas tran an00512 FIND v(xtop.a_9600_169.n1) AT=26n
.meas tran an00513 FIND v(xtop.a_9600_169.t0) AT=26n
.meas tran an00514 FIND v(xtop.a_9600_169.t1) AT=26n
.meas tran an00515 FIND v(xtop.a_9600_169.t2) AT=26n
.meas tran an00516 FIND v(xtop.a_9600_169.t3) AT=26n
.meas tran an00517 FIND v(xtop.a_9600_169.t4) AT=26n
.meas tran an00518 FIND v(xtop.a_9600_83.t0) AT=26n
.meas tran an00519 FIND v(xtop.a_9600_83.t1) AT=26n
.meas tran an00520 FIND v(xtop.a_9600_n35917.n0) AT=26n
.meas tran an00521 FIND v(xtop.a_9600_n35917.n1) AT=26n
.meas tran an00522 FIND v(xtop.a_9600_n35917.t0) AT=26n
.meas tran an00523 FIND v(xtop.a_9600_n35917.t1) AT=26n
.meas tran an00524 FIND v(xtop.a_9600_n35917.t2) AT=26n
.meas tran an00525 FIND v(xtop.a_9600_n36000.n0) AT=26n
.meas tran an00526 FIND v(xtop.a_9600_n36000.n1) AT=26n
.meas tran an00527 FIND v(xtop.a_9600_n36000.t0) AT=26n
.meas tran an00528 FIND v(xtop.a_9600_n36000.t1) AT=26n
.meas tran an00529 FIND v(xtop.a_9600_n36000.t2) AT=26n
.meas tran an00530 FIND v(xtop.a_9600_n36000.t3) AT=26n
.meas tran an00531 FIND v(xtop.a_n104_n35959.n0) AT=26n
.meas tran an00532 FIND v(xtop.a_n104_n35959.n1) AT=26n
.meas tran an00533 FIND v(xtop.a_n104_n35959.t0) AT=26n
.meas tran an00534 FIND v(xtop.a_n104_n35959.t1) AT=26n
.meas tran an00535 FIND v(xtop.a_n104_n35959.t2) AT=26n
.meas tran an00536 FIND v(xtop.a_n104_n35959.t3) AT=26n
.meas tran an00537 FIND v(xtop.a_n104_n35959.t4) AT=26n
.meas tran an00538 FIND v(dl) AT=26n
.meas tran an00539 FIND v(xtop.din.n0) AT=26n
.meas tran an00540 FIND v(xtop.din.n1) AT=26n
.meas tran an00541 FIND v(xtop.din.t0) AT=26n
.meas tran an00542 FIND v(xtop.din.t1) AT=26n
.meas tran an00543 FIND v(xtop.din.t2) AT=26n
.meas tran an00544 FIND v(xtop.din.t3) AT=26n
.meas tran an00545 FIND v(dout) AT=26n
.meas tran an00546 FIND v(xtop.dout.n0) AT=26n
.meas tran an00547 FIND v(xtop.dout.t0) AT=26n
.meas tran an00548 FIND v(xtop.dout.t1) AT=26n
.meas tran an00549 FIND v(en) AT=26n
.meas tran an00550 FIND v(xtop.en.n0) AT=26n
.meas tran an00551 FIND v(xtop.en.t0) AT=26n
.meas tran an00552 FIND v(xtop.en.t1) AT=26n
.meas tran an00553 FIND v(xtop.en.t2) AT=26n
.meas tran an00554 FIND v(xtop.en.t3) AT=26n
.meas tran an00555 FIND v(pc_b) AT=26n
.meas tran an00556 FIND v(xtop.pc_b.n0) AT=26n
.meas tran an00557 FIND v(xtop.pc_b.n1) AT=26n
.meas tran an00558 FIND v(xtop.pc_b.t0) AT=26n
.meas tran an00559 FIND v(xtop.pc_b.t1) AT=26n
.meas tran an00560 FIND v(xtop.pc_b.t2) AT=26n
.meas tran an00561 FIND v(sa_en) AT=26n
.meas tran an00562 FIND v(xtop.sa_en.n0) AT=26n
.meas tran an00563 FIND v(xtop.sa_en.t0) AT=26n
.meas tran an00564 FIND v(xtop.sa_en.t1) AT=26n
.meas tran an00565 FIND v(vdd) AT=26n
.meas tran an00566 FIND v(xtop.vdd.n0) AT=26n
.meas tran an00567 FIND v(xtop.vdd.n1) AT=26n
.meas tran an00568 FIND v(xtop.vdd.n10) AT=26n
.meas tran an00569 FIND v(xtop.vdd.n11) AT=26n
.meas tran an00570 FIND v(xtop.vdd.n12) AT=26n
.meas tran an00571 FIND v(xtop.vdd.n13) AT=26n
.meas tran an00572 FIND v(xtop.vdd.n14) AT=26n
.meas tran an00573 FIND v(xtop.vdd.n15) AT=26n
.meas tran an00574 FIND v(xtop.vdd.n16) AT=26n
.meas tran an00575 FIND v(xtop.vdd.n17) AT=26n
.meas tran an00576 FIND v(xtop.vdd.n18) AT=26n
.meas tran an00577 FIND v(xtop.vdd.n19) AT=26n
.meas tran an00578 FIND v(xtop.vdd.n2) AT=26n
.meas tran an00579 FIND v(xtop.vdd.n20) AT=26n
.meas tran an00580 FIND v(xtop.vdd.n21) AT=26n
.meas tran an00581 FIND v(xtop.vdd.n22) AT=26n
.meas tran an00582 FIND v(xtop.vdd.n23) AT=26n
.meas tran an00583 FIND v(xtop.vdd.n24) AT=26n
.meas tran an00584 FIND v(xtop.vdd.n25) AT=26n
.meas tran an00585 FIND v(xtop.vdd.n26) AT=26n
.meas tran an00586 FIND v(xtop.vdd.n27) AT=26n
.meas tran an00587 FIND v(xtop.vdd.n28) AT=26n
.meas tran an00588 FIND v(xtop.vdd.n29) AT=26n
.meas tran an00589 FIND v(xtop.vdd.n3) AT=26n
.meas tran an00590 FIND v(xtop.vdd.n30) AT=26n
.meas tran an00591 FIND v(xtop.vdd.n31) AT=26n
.meas tran an00592 FIND v(xtop.vdd.n32) AT=26n
.meas tran an00593 FIND v(xtop.vdd.n33) AT=26n
.meas tran an00594 FIND v(xtop.vdd.n34) AT=26n
.meas tran an00595 FIND v(xtop.vdd.n35) AT=26n
.meas tran an00596 FIND v(xtop.vdd.n36) AT=26n
.meas tran an00597 FIND v(xtop.vdd.n37) AT=26n
.meas tran an00598 FIND v(xtop.vdd.n38) AT=26n
.meas tran an00599 FIND v(xtop.vdd.n39) AT=26n
.meas tran an00600 FIND v(xtop.vdd.n4) AT=26n
.meas tran an00601 FIND v(xtop.vdd.n40) AT=26n
.meas tran an00602 FIND v(xtop.vdd.n41) AT=26n
.meas tran an00603 FIND v(xtop.vdd.n42) AT=26n
.meas tran an00604 FIND v(xtop.vdd.n43) AT=26n
.meas tran an00605 FIND v(xtop.vdd.n44) AT=26n
.meas tran an00606 FIND v(xtop.vdd.n45) AT=26n
.meas tran an00607 FIND v(xtop.vdd.n46) AT=26n
.meas tran an00608 FIND v(xtop.vdd.n5) AT=26n
.meas tran an00609 FIND v(xtop.vdd.n6) AT=26n
.meas tran an00610 FIND v(xtop.vdd.n7) AT=26n
.meas tran an00611 FIND v(xtop.vdd.n8) AT=26n
.meas tran an00612 FIND v(xtop.vdd.n9) AT=26n
.meas tran an00613 FIND v(xtop.vdd.t0) AT=26n
.meas tran an00614 FIND v(xtop.vdd.t1) AT=26n
.meas tran an00615 FIND v(xtop.vdd.t10) AT=26n
.meas tran an00616 FIND v(xtop.vdd.t11) AT=26n
.meas tran an00617 FIND v(xtop.vdd.t12) AT=26n
.meas tran an00618 FIND v(xtop.vdd.t13) AT=26n
.meas tran an00619 FIND v(xtop.vdd.t14) AT=26n
.meas tran an00620 FIND v(xtop.vdd.t15) AT=26n
.meas tran an00621 FIND v(xtop.vdd.t16) AT=26n
.meas tran an00622 FIND v(xtop.vdd.t17) AT=26n
.meas tran an00623 FIND v(xtop.vdd.t18) AT=26n
.meas tran an00624 FIND v(xtop.vdd.t19) AT=26n
.meas tran an00625 FIND v(xtop.vdd.t2) AT=26n
.meas tran an00626 FIND v(xtop.vdd.t20) AT=26n
.meas tran an00627 FIND v(xtop.vdd.t21) AT=26n
.meas tran an00628 FIND v(xtop.vdd.t22) AT=26n
.meas tran an00629 FIND v(xtop.vdd.t23) AT=26n
.meas tran an00630 FIND v(xtop.vdd.t24) AT=26n
.meas tran an00631 FIND v(xtop.vdd.t25) AT=26n
.meas tran an00632 FIND v(xtop.vdd.t26) AT=26n
.meas tran an00633 FIND v(xtop.vdd.t27) AT=26n
.meas tran an00634 FIND v(xtop.vdd.t28) AT=26n
.meas tran an00635 FIND v(xtop.vdd.t29) AT=26n
.meas tran an00636 FIND v(xtop.vdd.t3) AT=26n
.meas tran an00637 FIND v(xtop.vdd.t30) AT=26n
.meas tran an00638 FIND v(xtop.vdd.t31) AT=26n
.meas tran an00639 FIND v(xtop.vdd.t32) AT=26n
.meas tran an00640 FIND v(xtop.vdd.t33) AT=26n
.meas tran an00641 FIND v(xtop.vdd.t34) AT=26n
.meas tran an00642 FIND v(xtop.vdd.t35) AT=26n
.meas tran an00643 FIND v(xtop.vdd.t36) AT=26n
.meas tran an00644 FIND v(xtop.vdd.t37) AT=26n
.meas tran an00645 FIND v(xtop.vdd.t38) AT=26n
.meas tran an00646 FIND v(xtop.vdd.t39) AT=26n
.meas tran an00647 FIND v(xtop.vdd.t4) AT=26n
.meas tran an00648 FIND v(xtop.vdd.t40) AT=26n
.meas tran an00649 FIND v(xtop.vdd.t41) AT=26n
.meas tran an00650 FIND v(xtop.vdd.t42) AT=26n
.meas tran an00651 FIND v(xtop.vdd.t43) AT=26n
.meas tran an00652 FIND v(xtop.vdd.t44) AT=26n
.meas tran an00653 FIND v(xtop.vdd.t45) AT=26n
.meas tran an00654 FIND v(xtop.vdd.t46) AT=26n
.meas tran an00655 FIND v(xtop.vdd.t47) AT=26n
.meas tran an00656 FIND v(xtop.vdd.t48) AT=26n
.meas tran an00657 FIND v(xtop.vdd.t5) AT=26n
.meas tran an00658 FIND v(xtop.vdd.t6) AT=26n
.meas tran an00659 FIND v(xtop.vdd.t7) AT=26n
.meas tran an00660 FIND v(xtop.vdd.t8) AT=26n
.meas tran an00661 FIND v(xtop.vdd.t9) AT=26n
.meas tran an00663 FIND v(xtop.vss.n0) AT=26n
.meas tran an00664 FIND v(xtop.vss.n1) AT=26n
.meas tran an00665 FIND v(xtop.vss.n10) AT=26n
.meas tran an00666 FIND v(xtop.vss.n11) AT=26n
.meas tran an00667 FIND v(xtop.vss.n12) AT=26n
.meas tran an00668 FIND v(xtop.vss.n13) AT=26n
.meas tran an00669 FIND v(xtop.vss.n14) AT=26n
.meas tran an00670 FIND v(xtop.vss.n15) AT=26n
.meas tran an00671 FIND v(xtop.vss.n16) AT=26n
.meas tran an00672 FIND v(xtop.vss.n17) AT=26n
.meas tran an00673 FIND v(xtop.vss.n18) AT=26n
.meas tran an00674 FIND v(xtop.vss.n19) AT=26n
.meas tran an00675 FIND v(xtop.vss.n2) AT=26n
.meas tran an00676 FIND v(xtop.vss.n20) AT=26n
.meas tran an00677 FIND v(xtop.vss.n21) AT=26n
.meas tran an00678 FIND v(xtop.vss.n22) AT=26n
.meas tran an00679 FIND v(xtop.vss.n23) AT=26n
.meas tran an00680 FIND v(xtop.vss.n24) AT=26n
.meas tran an00681 FIND v(xtop.vss.n25) AT=26n
.meas tran an00682 FIND v(xtop.vss.n26) AT=26n
.meas tran an00683 FIND v(xtop.vss.n27) AT=26n
.meas tran an00684 FIND v(xtop.vss.n28) AT=26n
.meas tran an00685 FIND v(xtop.vss.n29) AT=26n
.meas tran an00686 FIND v(xtop.vss.n3) AT=26n
.meas tran an00687 FIND v(xtop.vss.n30) AT=26n
.meas tran an00688 FIND v(xtop.vss.n31) AT=26n
.meas tran an00689 FIND v(xtop.vss.n32) AT=26n
.meas tran an00690 FIND v(xtop.vss.n33) AT=26n
.meas tran an00691 FIND v(xtop.vss.n34) AT=26n
.meas tran an00692 FIND v(xtop.vss.n35) AT=26n
.meas tran an00693 FIND v(xtop.vss.n36) AT=26n
.meas tran an00694 FIND v(xtop.vss.n37) AT=26n
.meas tran an00695 FIND v(xtop.vss.n38) AT=26n
.meas tran an00696 FIND v(xtop.vss.n39) AT=26n
.meas tran an00697 FIND v(xtop.vss.n4) AT=26n
.meas tran an00698 FIND v(xtop.vss.n40) AT=26n
.meas tran an00699 FIND v(xtop.vss.n41) AT=26n
.meas tran an00700 FIND v(xtop.vss.n42) AT=26n
.meas tran an00701 FIND v(xtop.vss.n43) AT=26n
.meas tran an00702 FIND v(xtop.vss.n44) AT=26n
.meas tran an00703 FIND v(xtop.vss.n45) AT=26n
.meas tran an00704 FIND v(xtop.vss.n46) AT=26n
.meas tran an00705 FIND v(xtop.vss.n47) AT=26n
.meas tran an00706 FIND v(xtop.vss.n48) AT=26n
.meas tran an00707 FIND v(xtop.vss.n49) AT=26n
.meas tran an00708 FIND v(xtop.vss.n5) AT=26n
.meas tran an00709 FIND v(xtop.vss.n50) AT=26n
.meas tran an00710 FIND v(xtop.vss.n51) AT=26n
.meas tran an00711 FIND v(xtop.vss.n52) AT=26n
.meas tran an00712 FIND v(xtop.vss.n53) AT=26n
.meas tran an00713 FIND v(xtop.vss.n54) AT=26n
.meas tran an00714 FIND v(xtop.vss.n55) AT=26n
.meas tran an00715 FIND v(xtop.vss.n56) AT=26n
.meas tran an00716 FIND v(xtop.vss.n57) AT=26n
.meas tran an00717 FIND v(xtop.vss.n58) AT=26n
.meas tran an00718 FIND v(xtop.vss.n59) AT=26n
.meas tran an00719 FIND v(xtop.vss.n6) AT=26n
.meas tran an00720 FIND v(xtop.vss.n60) AT=26n
.meas tran an00721 FIND v(xtop.vss.n61) AT=26n
.meas tran an00722 FIND v(xtop.vss.n62) AT=26n
.meas tran an00723 FIND v(xtop.vss.n63) AT=26n
.meas tran an00724 FIND v(xtop.vss.n64) AT=26n
.meas tran an00725 FIND v(xtop.vss.n65) AT=26n
.meas tran an00726 FIND v(xtop.vss.n66) AT=26n
.meas tran an00727 FIND v(xtop.vss.n67) AT=26n
.meas tran an00728 FIND v(xtop.vss.n68) AT=26n
.meas tran an00729 FIND v(xtop.vss.n69) AT=26n
.meas tran an00730 FIND v(xtop.vss.n7) AT=26n
.meas tran an00731 FIND v(xtop.vss.n70) AT=26n
.meas tran an00732 FIND v(xtop.vss.n71) AT=26n
.meas tran an00733 FIND v(xtop.vss.n72) AT=26n
.meas tran an00734 FIND v(xtop.vss.n73) AT=26n
.meas tran an00735 FIND v(xtop.vss.n74) AT=26n
.meas tran an00736 FIND v(xtop.vss.n75) AT=26n
.meas tran an00737 FIND v(xtop.vss.n76) AT=26n
.meas tran an00738 FIND v(xtop.vss.n77) AT=26n
.meas tran an00739 FIND v(xtop.vss.n78) AT=26n
.meas tran an00740 FIND v(xtop.vss.n79) AT=26n
.meas tran an00741 FIND v(xtop.vss.n8) AT=26n
.meas tran an00742 FIND v(xtop.vss.n9) AT=26n
.meas tran an00743 FIND v(xtop.vss.t0) AT=26n
.meas tran an00744 FIND v(xtop.vss.t1) AT=26n
.meas tran an00745 FIND v(xtop.vss.t10) AT=26n
.meas tran an00746 FIND v(xtop.vss.t11) AT=26n
.meas tran an00747 FIND v(xtop.vss.t12) AT=26n
.meas tran an00748 FIND v(xtop.vss.t13) AT=26n
.meas tran an00749 FIND v(xtop.vss.t14) AT=26n
.meas tran an00750 FIND v(xtop.vss.t15) AT=26n
.meas tran an00751 FIND v(xtop.vss.t16) AT=26n
.meas tran an00752 FIND v(xtop.vss.t17) AT=26n
.meas tran an00753 FIND v(xtop.vss.t18) AT=26n
.meas tran an00754 FIND v(xtop.vss.t19) AT=26n
.meas tran an00755 FIND v(xtop.vss.t2) AT=26n
.meas tran an00756 FIND v(xtop.vss.t20) AT=26n
.meas tran an00757 FIND v(xtop.vss.t21) AT=26n
.meas tran an00758 FIND v(xtop.vss.t22) AT=26n
.meas tran an00759 FIND v(xtop.vss.t23) AT=26n
.meas tran an00760 FIND v(xtop.vss.t24) AT=26n
.meas tran an00761 FIND v(xtop.vss.t25) AT=26n
.meas tran an00762 FIND v(xtop.vss.t26) AT=26n
.meas tran an00763 FIND v(xtop.vss.t27) AT=26n
.meas tran an00764 FIND v(xtop.vss.t28) AT=26n
.meas tran an00765 FIND v(xtop.vss.t29) AT=26n
.meas tran an00766 FIND v(xtop.vss.t3) AT=26n
.meas tran an00767 FIND v(xtop.vss.t30) AT=26n
.meas tran an00768 FIND v(xtop.vss.t31) AT=26n
.meas tran an00769 FIND v(xtop.vss.t32) AT=26n
.meas tran an00770 FIND v(xtop.vss.t33) AT=26n
.meas tran an00771 FIND v(xtop.vss.t34) AT=26n
.meas tran an00772 FIND v(xtop.vss.t35) AT=26n
.meas tran an00773 FIND v(xtop.vss.t36) AT=26n
.meas tran an00774 FIND v(xtop.vss.t37) AT=26n
.meas tran an00775 FIND v(xtop.vss.t38) AT=26n
.meas tran an00776 FIND v(xtop.vss.t39) AT=26n
.meas tran an00777 FIND v(xtop.vss.t4) AT=26n
.meas tran an00778 FIND v(xtop.vss.t40) AT=26n
.meas tran an00779 FIND v(xtop.vss.t41) AT=26n
.meas tran an00780 FIND v(xtop.vss.t42) AT=26n
.meas tran an00781 FIND v(xtop.vss.t43) AT=26n
.meas tran an00782 FIND v(xtop.vss.t5) AT=26n
.meas tran an00783 FIND v(xtop.vss.t6) AT=26n
.meas tran an00784 FIND v(xtop.vss.t7) AT=26n
.meas tran an00785 FIND v(xtop.vss.t8) AT=26n
.meas tran an00786 FIND v(xtop.vss.t9) AT=26n
.meas tran an00787 FIND v(we) AT=26n
.meas tran an00788 FIND v(xtop.we.n0) AT=26n
.meas tran an00789 FIND v(xtop.we.n1) AT=26n
.meas tran an00790 FIND v(xtop.we.t0) AT=26n
.meas tran an00791 FIND v(xtop.we.t1) AT=26n
.meas tran an00792 FIND v(xtop.we.t2) AT=26n
.meas tran an00793 FIND v(xtop.we.t3) AT=26n
.meas tran an00794 FIND v(a) AT=29n
.meas tran an00795 FIND v(xtop.a.n0) AT=29n
.meas tran an00796 FIND v(xtop.a.t0) AT=29n
.meas tran an00797 FIND v(xtop.a.t1) AT=29n
.meas tran an00798 FIND v(xtop.a.t2) AT=29n
.meas tran an00799 FIND v(xtop.a.t3) AT=29n
.meas tran an00800 FIND v(xtop.a_0_83.n0) AT=29n
.meas tran an00801 FIND v(xtop.a_0_83.t0) AT=29n
.meas tran an00802 FIND v(xtop.a_0_83.t1) AT=29n
.meas tran an00803 FIND v(xtop.a_0_83.t2) AT=29n
.meas tran an00804 FIND v(xtop.a_0_83.t3) AT=29n
.meas tran an00805 FIND v(xtop.a_0_n11917.n0) AT=29n
.meas tran an00806 FIND v(xtop.a_0_n11917.n1) AT=29n
.meas tran an00807 FIND v(xtop.a_0_n11917.n2) AT=29n
.meas tran an00808 FIND v(xtop.a_0_n11917.n3) AT=29n
.meas tran an00809 FIND v(xtop.a_0_n11917.n4) AT=29n
.meas tran an00810 FIND v(xtop.a_0_n11917.t0) AT=29n
.meas tran an00811 FIND v(xtop.a_0_n11917.t1) AT=29n
.meas tran an00812 FIND v(xtop.a_0_n11917.t2) AT=29n
.meas tran an00813 FIND v(xtop.a_0_n11917.t3) AT=29n
.meas tran an00814 FIND v(xtop.a_0_n11917.t4) AT=29n
.meas tran an00815 FIND v(xtop.a_0_n11917.t5) AT=29n
.meas tran an00816 FIND v(xtop.a_0_n11917.t6) AT=29n
.meas tran an00817 FIND v(xtop.a_0_n23917.n0) AT=29n
.meas tran an00818 FIND v(xtop.a_0_n23917.n1) AT=29n
.meas tran an00819 FIND v(xtop.a_0_n23917.t0) AT=29n
.meas tran an00820 FIND v(xtop.a_0_n23917.t1) AT=29n
.meas tran an00821 FIND v(xtop.a_0_n23917.t2) AT=29n
.meas tran an00822 FIND v(xtop.a_0_n23917.t3) AT=29n
.meas tran an00823 FIND v(xtop.a_0_n35917.n0) AT=29n
.meas tran an00824 FIND v(xtop.a_0_n35917.t0) AT=29n
.meas tran an00825 FIND v(xtop.a_0_n35917.t1) AT=29n
.meas tran an00826 FIND v(xtop.a_0_n35917.t2) AT=29n
.meas tran an00827 FIND v(xtop.a_0_n35917.t3) AT=29n
.meas tran an00828 FIND v(xtop.a_11200_n23917.t0) AT=29n
.meas tran an00829 FIND v(xtop.a_11200_n23917.t1) AT=29n
.meas tran an00830 FIND v(xtop.a_12800_83.n0) AT=29n
.meas tran an00831 FIND v(xtop.a_12800_83.n1) AT=29n
.meas tran an00832 FIND v(xtop.a_12800_83.t0) AT=29n
.meas tran an00833 FIND v(xtop.a_12800_83.t1) AT=29n
.meas tran an00834 FIND v(xtop.a_12800_83.t2) AT=29n
.meas tran an00835 FIND v(xtop.a_12800_83.t3) AT=29n
.meas tran an00836 FIND v(xtop.a_16000_n24000.t0) AT=29n
.meas tran an00837 FIND v(xtop.a_16000_n24000.t1) AT=29n
.meas tran an00838 FIND v(xtop.a_1600_n11917.n0) AT=29n
.meas tran an00839 FIND v(xtop.a_1600_n11917.n1) AT=29n
.meas tran an00840 FIND v(xtop.a_1600_n11917.n2) AT=29n
.meas tran an00841 FIND v(xtop.a_1600_n11917.n3) AT=29n
.meas tran an00842 FIND v(xtop.a_1600_n11917.n4) AT=29n
.meas tran an00843 FIND v(xtop.a_1600_n11917.t0) AT=29n
.meas tran an00844 FIND v(xtop.a_1600_n11917.t1) AT=29n
.meas tran an00845 FIND v(xtop.a_1600_n11917.t2) AT=29n
.meas tran an00846 FIND v(xtop.a_1600_n11917.t3) AT=29n
.meas tran an00847 FIND v(xtop.a_1600_n11917.t4) AT=29n
.meas tran an00848 FIND v(xtop.a_1600_n11917.t5) AT=29n
.meas tran an00849 FIND v(xtop.a_1600_n11917.t6) AT=29n
.meas tran an00850 FIND v(xtop.a_19896_16041.n0) AT=29n
.meas tran an00851 FIND v(xtop.a_19896_16041.n1) AT=29n
.meas tran an00852 FIND v(xtop.a_19896_16041.t0) AT=29n
.meas tran an00853 FIND v(xtop.a_19896_16041.t1) AT=29n
.meas tran an00854 FIND v(xtop.a_19896_16041.t2) AT=29n
.meas tran an00855 FIND v(xtop.a_19896_16041.t3) AT=29n
.meas tran an00856 FIND v(xtop.a_19896_16041.t4) AT=29n
.meas tran an00857 FIND v(xtop.a_19896_8041.n0) AT=29n
.meas tran an00858 FIND v(xtop.a_19896_8041.n1) AT=29n
.meas tran an00859 FIND v(xtop.a_19896_8041.t0) AT=29n
.meas tran an00860 FIND v(xtop.a_19896_8041.t1) AT=29n
.meas tran an00861 FIND v(xtop.a_19896_8041.t2) AT=29n
.meas tran an00862 FIND v(xtop.a_19896_8041.t3) AT=29n
.meas tran an00863 FIND v(xtop.a_19896_8041.t4) AT=29n
.meas tran an00864 FIND v(xtop.a_20000_14483.n0) AT=29n
.meas tran an00865 FIND v(xtop.a_20000_14483.n1) AT=29n
.meas tran an00866 FIND v(xtop.a_20000_14483.t0) AT=29n
.meas tran an00867 FIND v(xtop.a_20000_14483.t1) AT=29n
.meas tran an00868 FIND v(xtop.a_20000_14483.t2) AT=29n
.meas tran an00869 FIND v(xtop.a_20000_14483.t3) AT=29n
.meas tran an00870 FIND v(xtop.a_20000_14483.t4) AT=29n
.meas tran an00871 FIND v(xtop.a_20000_6483.n0) AT=29n
.meas tran an00872 FIND v(xtop.a_20000_6483.n1) AT=29n
.meas tran an00873 FIND v(xtop.a_20000_6483.t0) AT=29n
.meas tran an00874 FIND v(xtop.a_20000_6483.t1) AT=29n
.meas tran an00875 FIND v(xtop.a_20000_6483.t2) AT=29n
.meas tran an00876 FIND v(xtop.a_20000_6483.t3) AT=29n
.meas tran an00877 FIND v(xtop.a_20000_6483.t4) AT=29n
.meas tran an00878 FIND v(xtop.a_20800_n23917.t0) AT=29n
.meas tran an00879 FIND v(xtop.a_20800_n23917.t1) AT=29n
.meas tran an00880 FIND v(xtop.a_3200_169.n0) AT=29n
.meas tran an00881 FIND v(xtop.a_3200_169.n1) AT=29n
.meas tran an00882 FIND v(xtop.a_3200_169.t0) AT=29n
.meas tran an00883 FIND v(xtop.a_3200_169.t1) AT=29n
.meas tran an00884 FIND v(xtop.a_3200_169.t2) AT=29n
.meas tran an00885 FIND v(xtop.a_3200_169.t3) AT=29n
.meas tran an00886 FIND v(xtop.a_3200_169.t4) AT=29n
.meas tran an00887 FIND v(xtop.a_3200_83.t0) AT=29n
.meas tran an00888 FIND v(xtop.a_3200_83.t1) AT=29n
.meas tran an00889 FIND v(xtop.a_3200_n23917.n0) AT=29n
.meas tran an00890 FIND v(xtop.a_3200_n23917.n1) AT=29n
.meas tran an00891 FIND v(xtop.a_3200_n23917.t0) AT=29n
.meas tran an00892 FIND v(xtop.a_3200_n23917.t1) AT=29n
.meas tran an00893 FIND v(xtop.a_3200_n23917.t2) AT=29n
.meas tran an00894 FIND v(xtop.a_3200_n23917.t3) AT=29n
.meas tran an00895 FIND v(xtop.a_3200_n35917.n0) AT=29n
.meas tran an00896 FIND v(xtop.a_3200_n35917.t0) AT=29n
.meas tran an00897 FIND v(xtop.a_3200_n35917.t1) AT=29n
.meas tran an00898 FIND v(xtop.a_3200_n35917.t2) AT=29n
.meas tran an00899 FIND v(xtop.a_3200_n35917.t3) AT=29n
.meas tran an00900 FIND v(xtop.a_6400_83.n0) AT=29n
.meas tran an00901 FIND v(xtop.a_6400_83.n1) AT=29n
.meas tran an00902 FIND v(xtop.a_6400_83.t0) AT=29n
.meas tran an00903 FIND v(xtop.a_6400_83.t1) AT=29n
.meas tran an00904 FIND v(xtop.a_6400_83.t2) AT=29n
.meas tran an00905 FIND v(xtop.a_6400_83.t3) AT=29n
.meas tran an00906 FIND v(xtop.a_6400_n24000.t0) AT=29n
.meas tran an00907 FIND v(xtop.a_6400_n24000.t1) AT=29n
.meas tran an00908 FIND v(xtop.a_9600_169.n0) AT=29n
.meas tran an00909 FIND v(xtop.a_9600_169.n1) AT=29n
.meas tran an00910 FIND v(xtop.a_9600_169.t0) AT=29n
.meas tran an00911 FIND v(xtop.a_9600_169.t1) AT=29n
.meas tran an00912 FIND v(xtop.a_9600_169.t2) AT=29n
.meas tran an00913 FIND v(xtop.a_9600_169.t3) AT=29n
.meas tran an00914 FIND v(xtop.a_9600_169.t4) AT=29n
.meas tran an00915 FIND v(xtop.a_9600_83.t0) AT=29n
.meas tran an00916 FIND v(xtop.a_9600_83.t1) AT=29n
.meas tran an00917 FIND v(xtop.a_9600_n35917.n0) AT=29n
.meas tran an00918 FIND v(xtop.a_9600_n35917.n1) AT=29n
.meas tran an00919 FIND v(xtop.a_9600_n35917.t0) AT=29n
.meas tran an00920 FIND v(xtop.a_9600_n35917.t1) AT=29n
.meas tran an00921 FIND v(xtop.a_9600_n35917.t2) AT=29n
.meas tran an00922 FIND v(xtop.a_9600_n36000.n0) AT=29n
.meas tran an00923 FIND v(xtop.a_9600_n36000.n1) AT=29n
.meas tran an00924 FIND v(xtop.a_9600_n36000.t0) AT=29n
.meas tran an00925 FIND v(xtop.a_9600_n36000.t1) AT=29n
.meas tran an00926 FIND v(xtop.a_9600_n36000.t2) AT=29n
.meas tran an00927 FIND v(xtop.a_9600_n36000.t3) AT=29n
.meas tran an00928 FIND v(xtop.a_n104_n35959.n0) AT=29n
.meas tran an00929 FIND v(xtop.a_n104_n35959.n1) AT=29n
.meas tran an00930 FIND v(xtop.a_n104_n35959.t0) AT=29n
.meas tran an00931 FIND v(xtop.a_n104_n35959.t1) AT=29n
.meas tran an00932 FIND v(xtop.a_n104_n35959.t2) AT=29n
.meas tran an00933 FIND v(xtop.a_n104_n35959.t3) AT=29n
.meas tran an00934 FIND v(xtop.a_n104_n35959.t4) AT=29n
.meas tran an00935 FIND v(dl) AT=29n
.meas tran an00936 FIND v(xtop.din.n0) AT=29n
.meas tran an00937 FIND v(xtop.din.n1) AT=29n
.meas tran an00938 FIND v(xtop.din.t0) AT=29n
.meas tran an00939 FIND v(xtop.din.t1) AT=29n
.meas tran an00940 FIND v(xtop.din.t2) AT=29n
.meas tran an00941 FIND v(xtop.din.t3) AT=29n
.meas tran an00942 FIND v(dout) AT=29n
.meas tran an00943 FIND v(xtop.dout.n0) AT=29n
.meas tran an00944 FIND v(xtop.dout.t0) AT=29n
.meas tran an00945 FIND v(xtop.dout.t1) AT=29n
.meas tran an00946 FIND v(en) AT=29n
.meas tran an00947 FIND v(xtop.en.n0) AT=29n
.meas tran an00948 FIND v(xtop.en.t0) AT=29n
.meas tran an00949 FIND v(xtop.en.t1) AT=29n
.meas tran an00950 FIND v(xtop.en.t2) AT=29n
.meas tran an00951 FIND v(xtop.en.t3) AT=29n
.meas tran an00952 FIND v(pc_b) AT=29n
.meas tran an00953 FIND v(xtop.pc_b.n0) AT=29n
.meas tran an00954 FIND v(xtop.pc_b.n1) AT=29n
.meas tran an00955 FIND v(xtop.pc_b.t0) AT=29n
.meas tran an00956 FIND v(xtop.pc_b.t1) AT=29n
.meas tran an00957 FIND v(xtop.pc_b.t2) AT=29n
.meas tran an00958 FIND v(sa_en) AT=29n
.meas tran an00959 FIND v(xtop.sa_en.n0) AT=29n
.meas tran an00960 FIND v(xtop.sa_en.t0) AT=29n
.meas tran an00961 FIND v(xtop.sa_en.t1) AT=29n
.meas tran an00962 FIND v(vdd) AT=29n
.meas tran an00963 FIND v(xtop.vdd.n0) AT=29n
.meas tran an00964 FIND v(xtop.vdd.n1) AT=29n
.meas tran an00965 FIND v(xtop.vdd.n10) AT=29n
.meas tran an00966 FIND v(xtop.vdd.n11) AT=29n
.meas tran an00967 FIND v(xtop.vdd.n12) AT=29n
.meas tran an00968 FIND v(xtop.vdd.n13) AT=29n
.meas tran an00969 FIND v(xtop.vdd.n14) AT=29n
.meas tran an00970 FIND v(xtop.vdd.n15) AT=29n
.meas tran an00971 FIND v(xtop.vdd.n16) AT=29n
.meas tran an00972 FIND v(xtop.vdd.n17) AT=29n
.meas tran an00973 FIND v(xtop.vdd.n18) AT=29n
.meas tran an00974 FIND v(xtop.vdd.n19) AT=29n
.meas tran an00975 FIND v(xtop.vdd.n2) AT=29n
.meas tran an00976 FIND v(xtop.vdd.n20) AT=29n
.meas tran an00977 FIND v(xtop.vdd.n21) AT=29n
.meas tran an00978 FIND v(xtop.vdd.n22) AT=29n
.meas tran an00979 FIND v(xtop.vdd.n23) AT=29n
.meas tran an00980 FIND v(xtop.vdd.n24) AT=29n
.meas tran an00981 FIND v(xtop.vdd.n25) AT=29n
.meas tran an00982 FIND v(xtop.vdd.n26) AT=29n
.meas tran an00983 FIND v(xtop.vdd.n27) AT=29n
.meas tran an00984 FIND v(xtop.vdd.n28) AT=29n
.meas tran an00985 FIND v(xtop.vdd.n29) AT=29n
.meas tran an00986 FIND v(xtop.vdd.n3) AT=29n
.meas tran an00987 FIND v(xtop.vdd.n30) AT=29n
.meas tran an00988 FIND v(xtop.vdd.n31) AT=29n
.meas tran an00989 FIND v(xtop.vdd.n32) AT=29n
.meas tran an00990 FIND v(xtop.vdd.n33) AT=29n
.meas tran an00991 FIND v(xtop.vdd.n34) AT=29n
.meas tran an00992 FIND v(xtop.vdd.n35) AT=29n
.meas tran an00993 FIND v(xtop.vdd.n36) AT=29n
.meas tran an00994 FIND v(xtop.vdd.n37) AT=29n
.meas tran an00995 FIND v(xtop.vdd.n38) AT=29n
.meas tran an00996 FIND v(xtop.vdd.n39) AT=29n
.meas tran an00997 FIND v(xtop.vdd.n4) AT=29n
.meas tran an00998 FIND v(xtop.vdd.n40) AT=29n
.meas tran an00999 FIND v(xtop.vdd.n41) AT=29n
.meas tran an01000 FIND v(xtop.vdd.n42) AT=29n
.meas tran an01001 FIND v(xtop.vdd.n43) AT=29n
.meas tran an01002 FIND v(xtop.vdd.n44) AT=29n
.meas tran an01003 FIND v(xtop.vdd.n45) AT=29n
.meas tran an01004 FIND v(xtop.vdd.n46) AT=29n
.meas tran an01005 FIND v(xtop.vdd.n5) AT=29n
.meas tran an01006 FIND v(xtop.vdd.n6) AT=29n
.meas tran an01007 FIND v(xtop.vdd.n7) AT=29n
.meas tran an01008 FIND v(xtop.vdd.n8) AT=29n
.meas tran an01009 FIND v(xtop.vdd.n9) AT=29n
.meas tran an01010 FIND v(xtop.vdd.t0) AT=29n
.meas tran an01011 FIND v(xtop.vdd.t1) AT=29n
.meas tran an01012 FIND v(xtop.vdd.t10) AT=29n
.meas tran an01013 FIND v(xtop.vdd.t11) AT=29n
.meas tran an01014 FIND v(xtop.vdd.t12) AT=29n
.meas tran an01015 FIND v(xtop.vdd.t13) AT=29n
.meas tran an01016 FIND v(xtop.vdd.t14) AT=29n
.meas tran an01017 FIND v(xtop.vdd.t15) AT=29n
.meas tran an01018 FIND v(xtop.vdd.t16) AT=29n
.meas tran an01019 FIND v(xtop.vdd.t17) AT=29n
.meas tran an01020 FIND v(xtop.vdd.t18) AT=29n
.meas tran an01021 FIND v(xtop.vdd.t19) AT=29n
.meas tran an01022 FIND v(xtop.vdd.t2) AT=29n
.meas tran an01023 FIND v(xtop.vdd.t20) AT=29n
.meas tran an01024 FIND v(xtop.vdd.t21) AT=29n
.meas tran an01025 FIND v(xtop.vdd.t22) AT=29n
.meas tran an01026 FIND v(xtop.vdd.t23) AT=29n
.meas tran an01027 FIND v(xtop.vdd.t24) AT=29n
.meas tran an01028 FIND v(xtop.vdd.t25) AT=29n
.meas tran an01029 FIND v(xtop.vdd.t26) AT=29n
.meas tran an01030 FIND v(xtop.vdd.t27) AT=29n
.meas tran an01031 FIND v(xtop.vdd.t28) AT=29n
.meas tran an01032 FIND v(xtop.vdd.t29) AT=29n
.meas tran an01033 FIND v(xtop.vdd.t3) AT=29n
.meas tran an01034 FIND v(xtop.vdd.t30) AT=29n
.meas tran an01035 FIND v(xtop.vdd.t31) AT=29n
.meas tran an01036 FIND v(xtop.vdd.t32) AT=29n
.meas tran an01037 FIND v(xtop.vdd.t33) AT=29n
.meas tran an01038 FIND v(xtop.vdd.t34) AT=29n
.meas tran an01039 FIND v(xtop.vdd.t35) AT=29n
.meas tran an01040 FIND v(xtop.vdd.t36) AT=29n
.meas tran an01041 FIND v(xtop.vdd.t37) AT=29n
.meas tran an01042 FIND v(xtop.vdd.t38) AT=29n
.meas tran an01043 FIND v(xtop.vdd.t39) AT=29n
.meas tran an01044 FIND v(xtop.vdd.t4) AT=29n
.meas tran an01045 FIND v(xtop.vdd.t40) AT=29n
.meas tran an01046 FIND v(xtop.vdd.t41) AT=29n
.meas tran an01047 FIND v(xtop.vdd.t42) AT=29n
.meas tran an01048 FIND v(xtop.vdd.t43) AT=29n
.meas tran an01049 FIND v(xtop.vdd.t44) AT=29n
.meas tran an01050 FIND v(xtop.vdd.t45) AT=29n
.meas tran an01051 FIND v(xtop.vdd.t46) AT=29n
.meas tran an01052 FIND v(xtop.vdd.t47) AT=29n
.meas tran an01053 FIND v(xtop.vdd.t48) AT=29n
.meas tran an01054 FIND v(xtop.vdd.t5) AT=29n
.meas tran an01055 FIND v(xtop.vdd.t6) AT=29n
.meas tran an01056 FIND v(xtop.vdd.t7) AT=29n
.meas tran an01057 FIND v(xtop.vdd.t8) AT=29n
.meas tran an01058 FIND v(xtop.vdd.t9) AT=29n
.meas tran an01060 FIND v(xtop.vss.n0) AT=29n
.meas tran an01061 FIND v(xtop.vss.n1) AT=29n
.meas tran an01062 FIND v(xtop.vss.n10) AT=29n
.meas tran an01063 FIND v(xtop.vss.n11) AT=29n
.meas tran an01064 FIND v(xtop.vss.n12) AT=29n
.meas tran an01065 FIND v(xtop.vss.n13) AT=29n
.meas tran an01066 FIND v(xtop.vss.n14) AT=29n
.meas tran an01067 FIND v(xtop.vss.n15) AT=29n
.meas tran an01068 FIND v(xtop.vss.n16) AT=29n
.meas tran an01069 FIND v(xtop.vss.n17) AT=29n
.meas tran an01070 FIND v(xtop.vss.n18) AT=29n
.meas tran an01071 FIND v(xtop.vss.n19) AT=29n
.meas tran an01072 FIND v(xtop.vss.n2) AT=29n
.meas tran an01073 FIND v(xtop.vss.n20) AT=29n
.meas tran an01074 FIND v(xtop.vss.n21) AT=29n
.meas tran an01075 FIND v(xtop.vss.n22) AT=29n
.meas tran an01076 FIND v(xtop.vss.n23) AT=29n
.meas tran an01077 FIND v(xtop.vss.n24) AT=29n
.meas tran an01078 FIND v(xtop.vss.n25) AT=29n
.meas tran an01079 FIND v(xtop.vss.n26) AT=29n
.meas tran an01080 FIND v(xtop.vss.n27) AT=29n
.meas tran an01081 FIND v(xtop.vss.n28) AT=29n
.meas tran an01082 FIND v(xtop.vss.n29) AT=29n
.meas tran an01083 FIND v(xtop.vss.n3) AT=29n
.meas tran an01084 FIND v(xtop.vss.n30) AT=29n
.meas tran an01085 FIND v(xtop.vss.n31) AT=29n
.meas tran an01086 FIND v(xtop.vss.n32) AT=29n
.meas tran an01087 FIND v(xtop.vss.n33) AT=29n
.meas tran an01088 FIND v(xtop.vss.n34) AT=29n
.meas tran an01089 FIND v(xtop.vss.n35) AT=29n
.meas tran an01090 FIND v(xtop.vss.n36) AT=29n
.meas tran an01091 FIND v(xtop.vss.n37) AT=29n
.meas tran an01092 FIND v(xtop.vss.n38) AT=29n
.meas tran an01093 FIND v(xtop.vss.n39) AT=29n
.meas tran an01094 FIND v(xtop.vss.n4) AT=29n
.meas tran an01095 FIND v(xtop.vss.n40) AT=29n
.meas tran an01096 FIND v(xtop.vss.n41) AT=29n
.meas tran an01097 FIND v(xtop.vss.n42) AT=29n
.meas tran an01098 FIND v(xtop.vss.n43) AT=29n
.meas tran an01099 FIND v(xtop.vss.n44) AT=29n
.meas tran an01100 FIND v(xtop.vss.n45) AT=29n
.meas tran an01101 FIND v(xtop.vss.n46) AT=29n
.meas tran an01102 FIND v(xtop.vss.n47) AT=29n
.meas tran an01103 FIND v(xtop.vss.n48) AT=29n
.meas tran an01104 FIND v(xtop.vss.n49) AT=29n
.meas tran an01105 FIND v(xtop.vss.n5) AT=29n
.meas tran an01106 FIND v(xtop.vss.n50) AT=29n
.meas tran an01107 FIND v(xtop.vss.n51) AT=29n
.meas tran an01108 FIND v(xtop.vss.n52) AT=29n
.meas tran an01109 FIND v(xtop.vss.n53) AT=29n
.meas tran an01110 FIND v(xtop.vss.n54) AT=29n
.meas tran an01111 FIND v(xtop.vss.n55) AT=29n
.meas tran an01112 FIND v(xtop.vss.n56) AT=29n
.meas tran an01113 FIND v(xtop.vss.n57) AT=29n
.meas tran an01114 FIND v(xtop.vss.n58) AT=29n
.meas tran an01115 FIND v(xtop.vss.n59) AT=29n
.meas tran an01116 FIND v(xtop.vss.n6) AT=29n
.meas tran an01117 FIND v(xtop.vss.n60) AT=29n
.meas tran an01118 FIND v(xtop.vss.n61) AT=29n
.meas tran an01119 FIND v(xtop.vss.n62) AT=29n
.meas tran an01120 FIND v(xtop.vss.n63) AT=29n
.meas tran an01121 FIND v(xtop.vss.n64) AT=29n
.meas tran an01122 FIND v(xtop.vss.n65) AT=29n
.meas tran an01123 FIND v(xtop.vss.n66) AT=29n
.meas tran an01124 FIND v(xtop.vss.n67) AT=29n
.meas tran an01125 FIND v(xtop.vss.n68) AT=29n
.meas tran an01126 FIND v(xtop.vss.n69) AT=29n
.meas tran an01127 FIND v(xtop.vss.n7) AT=29n
.meas tran an01128 FIND v(xtop.vss.n70) AT=29n
.meas tran an01129 FIND v(xtop.vss.n71) AT=29n
.meas tran an01130 FIND v(xtop.vss.n72) AT=29n
.meas tran an01131 FIND v(xtop.vss.n73) AT=29n
.meas tran an01132 FIND v(xtop.vss.n74) AT=29n
.meas tran an01133 FIND v(xtop.vss.n75) AT=29n
.meas tran an01134 FIND v(xtop.vss.n76) AT=29n
.meas tran an01135 FIND v(xtop.vss.n77) AT=29n
.meas tran an01136 FIND v(xtop.vss.n78) AT=29n
.meas tran an01137 FIND v(xtop.vss.n79) AT=29n
.meas tran an01138 FIND v(xtop.vss.n8) AT=29n
.meas tran an01139 FIND v(xtop.vss.n9) AT=29n
.meas tran an01140 FIND v(xtop.vss.t0) AT=29n
.meas tran an01141 FIND v(xtop.vss.t1) AT=29n
.meas tran an01142 FIND v(xtop.vss.t10) AT=29n
.meas tran an01143 FIND v(xtop.vss.t11) AT=29n
.meas tran an01144 FIND v(xtop.vss.t12) AT=29n
.meas tran an01145 FIND v(xtop.vss.t13) AT=29n
.meas tran an01146 FIND v(xtop.vss.t14) AT=29n
.meas tran an01147 FIND v(xtop.vss.t15) AT=29n
.meas tran an01148 FIND v(xtop.vss.t16) AT=29n
.meas tran an01149 FIND v(xtop.vss.t17) AT=29n
.meas tran an01150 FIND v(xtop.vss.t18) AT=29n
.meas tran an01151 FIND v(xtop.vss.t19) AT=29n
.meas tran an01152 FIND v(xtop.vss.t2) AT=29n
.meas tran an01153 FIND v(xtop.vss.t20) AT=29n
.meas tran an01154 FIND v(xtop.vss.t21) AT=29n
.meas tran an01155 FIND v(xtop.vss.t22) AT=29n
.meas tran an01156 FIND v(xtop.vss.t23) AT=29n
.meas tran an01157 FIND v(xtop.vss.t24) AT=29n
.meas tran an01158 FIND v(xtop.vss.t25) AT=29n
.meas tran an01159 FIND v(xtop.vss.t26) AT=29n
.meas tran an01160 FIND v(xtop.vss.t27) AT=29n
.meas tran an01161 FIND v(xtop.vss.t28) AT=29n
.meas tran an01162 FIND v(xtop.vss.t29) AT=29n
.meas tran an01163 FIND v(xtop.vss.t3) AT=29n
.meas tran an01164 FIND v(xtop.vss.t30) AT=29n
.meas tran an01165 FIND v(xtop.vss.t31) AT=29n
.meas tran an01166 FIND v(xtop.vss.t32) AT=29n
.meas tran an01167 FIND v(xtop.vss.t33) AT=29n
.meas tran an01168 FIND v(xtop.vss.t34) AT=29n
.meas tran an01169 FIND v(xtop.vss.t35) AT=29n
.meas tran an01170 FIND v(xtop.vss.t36) AT=29n
.meas tran an01171 FIND v(xtop.vss.t37) AT=29n
.meas tran an01172 FIND v(xtop.vss.t38) AT=29n
.meas tran an01173 FIND v(xtop.vss.t39) AT=29n
.meas tran an01174 FIND v(xtop.vss.t4) AT=29n
.meas tran an01175 FIND v(xtop.vss.t40) AT=29n
.meas tran an01176 FIND v(xtop.vss.t41) AT=29n
.meas tran an01177 FIND v(xtop.vss.t42) AT=29n
.meas tran an01178 FIND v(xtop.vss.t43) AT=29n
.meas tran an01179 FIND v(xtop.vss.t5) AT=29n
.meas tran an01180 FIND v(xtop.vss.t6) AT=29n
.meas tran an01181 FIND v(xtop.vss.t7) AT=29n
.meas tran an01182 FIND v(xtop.vss.t8) AT=29n
.meas tran an01183 FIND v(xtop.vss.t9) AT=29n
.meas tran an01184 FIND v(we) AT=29n
.meas tran an01185 FIND v(xtop.we.n0) AT=29n
.meas tran an01186 FIND v(xtop.we.n1) AT=29n
.meas tran an01187 FIND v(xtop.we.t0) AT=29n
.meas tran an01188 FIND v(xtop.we.t1) AT=29n
.meas tran an01189 FIND v(xtop.we.t2) AT=29n
.meas tran an01190 FIND v(xtop.we.t3) AT=29n
.meas tran an01191 FIND v(a) AT=36n
.meas tran an01192 FIND v(xtop.a.n0) AT=36n
.meas tran an01193 FIND v(xtop.a.t0) AT=36n
.meas tran an01194 FIND v(xtop.a.t1) AT=36n
.meas tran an01195 FIND v(xtop.a.t2) AT=36n
.meas tran an01196 FIND v(xtop.a.t3) AT=36n
.meas tran an01197 FIND v(xtop.a_0_83.n0) AT=36n
.meas tran an01198 FIND v(xtop.a_0_83.t0) AT=36n
.meas tran an01199 FIND v(xtop.a_0_83.t1) AT=36n
.meas tran an01200 FIND v(xtop.a_0_83.t2) AT=36n
.meas tran an01201 FIND v(xtop.a_0_83.t3) AT=36n
.meas tran an01202 FIND v(xtop.a_0_n11917.n0) AT=36n
.meas tran an01203 FIND v(xtop.a_0_n11917.n1) AT=36n
.meas tran an01204 FIND v(xtop.a_0_n11917.n2) AT=36n
.meas tran an01205 FIND v(xtop.a_0_n11917.n3) AT=36n
.meas tran an01206 FIND v(xtop.a_0_n11917.n4) AT=36n
.meas tran an01207 FIND v(xtop.a_0_n11917.t0) AT=36n
.meas tran an01208 FIND v(xtop.a_0_n11917.t1) AT=36n
.meas tran an01209 FIND v(xtop.a_0_n11917.t2) AT=36n
.meas tran an01210 FIND v(xtop.a_0_n11917.t3) AT=36n
.meas tran an01211 FIND v(xtop.a_0_n11917.t4) AT=36n
.meas tran an01212 FIND v(xtop.a_0_n11917.t5) AT=36n
.meas tran an01213 FIND v(xtop.a_0_n11917.t6) AT=36n
.meas tran an01214 FIND v(xtop.a_0_n23917.n0) AT=36n
.meas tran an01215 FIND v(xtop.a_0_n23917.n1) AT=36n
.meas tran an01216 FIND v(xtop.a_0_n23917.t0) AT=36n
.meas tran an01217 FIND v(xtop.a_0_n23917.t1) AT=36n
.meas tran an01218 FIND v(xtop.a_0_n23917.t2) AT=36n
.meas tran an01219 FIND v(xtop.a_0_n23917.t3) AT=36n
.meas tran an01220 FIND v(xtop.a_0_n35917.n0) AT=36n
.meas tran an01221 FIND v(xtop.a_0_n35917.t0) AT=36n
.meas tran an01222 FIND v(xtop.a_0_n35917.t1) AT=36n
.meas tran an01223 FIND v(xtop.a_0_n35917.t2) AT=36n
.meas tran an01224 FIND v(xtop.a_0_n35917.t3) AT=36n
.meas tran an01225 FIND v(xtop.a_11200_n23917.t0) AT=36n
.meas tran an01226 FIND v(xtop.a_11200_n23917.t1) AT=36n
.meas tran an01227 FIND v(xtop.a_12800_83.n0) AT=36n
.meas tran an01228 FIND v(xtop.a_12800_83.n1) AT=36n
.meas tran an01229 FIND v(xtop.a_12800_83.t0) AT=36n
.meas tran an01230 FIND v(xtop.a_12800_83.t1) AT=36n
.meas tran an01231 FIND v(xtop.a_12800_83.t2) AT=36n
.meas tran an01232 FIND v(xtop.a_12800_83.t3) AT=36n
.meas tran an01233 FIND v(xtop.a_16000_n24000.t0) AT=36n
.meas tran an01234 FIND v(xtop.a_16000_n24000.t1) AT=36n
.meas tran an01235 FIND v(xtop.a_1600_n11917.n0) AT=36n
.meas tran an01236 FIND v(xtop.a_1600_n11917.n1) AT=36n
.meas tran an01237 FIND v(xtop.a_1600_n11917.n2) AT=36n
.meas tran an01238 FIND v(xtop.a_1600_n11917.n3) AT=36n
.meas tran an01239 FIND v(xtop.a_1600_n11917.n4) AT=36n
.meas tran an01240 FIND v(xtop.a_1600_n11917.t0) AT=36n
.meas tran an01241 FIND v(xtop.a_1600_n11917.t1) AT=36n
.meas tran an01242 FIND v(xtop.a_1600_n11917.t2) AT=36n
.meas tran an01243 FIND v(xtop.a_1600_n11917.t3) AT=36n
.meas tran an01244 FIND v(xtop.a_1600_n11917.t4) AT=36n
.meas tran an01245 FIND v(xtop.a_1600_n11917.t5) AT=36n
.meas tran an01246 FIND v(xtop.a_1600_n11917.t6) AT=36n
.meas tran an01247 FIND v(xtop.a_19896_16041.n0) AT=36n
.meas tran an01248 FIND v(xtop.a_19896_16041.n1) AT=36n
.meas tran an01249 FIND v(xtop.a_19896_16041.t0) AT=36n
.meas tran an01250 FIND v(xtop.a_19896_16041.t1) AT=36n
.meas tran an01251 FIND v(xtop.a_19896_16041.t2) AT=36n
.meas tran an01252 FIND v(xtop.a_19896_16041.t3) AT=36n
.meas tran an01253 FIND v(xtop.a_19896_16041.t4) AT=36n
.meas tran an01254 FIND v(xtop.a_19896_8041.n0) AT=36n
.meas tran an01255 FIND v(xtop.a_19896_8041.n1) AT=36n
.meas tran an01256 FIND v(xtop.a_19896_8041.t0) AT=36n
.meas tran an01257 FIND v(xtop.a_19896_8041.t1) AT=36n
.meas tran an01258 FIND v(xtop.a_19896_8041.t2) AT=36n
.meas tran an01259 FIND v(xtop.a_19896_8041.t3) AT=36n
.meas tran an01260 FIND v(xtop.a_19896_8041.t4) AT=36n
.meas tran an01261 FIND v(xtop.a_20000_14483.n0) AT=36n
.meas tran an01262 FIND v(xtop.a_20000_14483.n1) AT=36n
.meas tran an01263 FIND v(xtop.a_20000_14483.t0) AT=36n
.meas tran an01264 FIND v(xtop.a_20000_14483.t1) AT=36n
.meas tran an01265 FIND v(xtop.a_20000_14483.t2) AT=36n
.meas tran an01266 FIND v(xtop.a_20000_14483.t3) AT=36n
.meas tran an01267 FIND v(xtop.a_20000_14483.t4) AT=36n
.meas tran an01268 FIND v(xtop.a_20000_6483.n0) AT=36n
.meas tran an01269 FIND v(xtop.a_20000_6483.n1) AT=36n
.meas tran an01270 FIND v(xtop.a_20000_6483.t0) AT=36n
.meas tran an01271 FIND v(xtop.a_20000_6483.t1) AT=36n
.meas tran an01272 FIND v(xtop.a_20000_6483.t2) AT=36n
.meas tran an01273 FIND v(xtop.a_20000_6483.t3) AT=36n
.meas tran an01274 FIND v(xtop.a_20000_6483.t4) AT=36n
.meas tran an01275 FIND v(xtop.a_20800_n23917.t0) AT=36n
.meas tran an01276 FIND v(xtop.a_20800_n23917.t1) AT=36n
.meas tran an01277 FIND v(xtop.a_3200_169.n0) AT=36n
.meas tran an01278 FIND v(xtop.a_3200_169.n1) AT=36n
.meas tran an01279 FIND v(xtop.a_3200_169.t0) AT=36n
.meas tran an01280 FIND v(xtop.a_3200_169.t1) AT=36n
.meas tran an01281 FIND v(xtop.a_3200_169.t2) AT=36n
.meas tran an01282 FIND v(xtop.a_3200_169.t3) AT=36n
.meas tran an01283 FIND v(xtop.a_3200_169.t4) AT=36n
.meas tran an01284 FIND v(xtop.a_3200_83.t0) AT=36n
.meas tran an01285 FIND v(xtop.a_3200_83.t1) AT=36n
.meas tran an01286 FIND v(xtop.a_3200_n23917.n0) AT=36n
.meas tran an01287 FIND v(xtop.a_3200_n23917.n1) AT=36n
.meas tran an01288 FIND v(xtop.a_3200_n23917.t0) AT=36n
.meas tran an01289 FIND v(xtop.a_3200_n23917.t1) AT=36n
.meas tran an01290 FIND v(xtop.a_3200_n23917.t2) AT=36n
.meas tran an01291 FIND v(xtop.a_3200_n23917.t3) AT=36n
.meas tran an01292 FIND v(xtop.a_3200_n35917.n0) AT=36n
.meas tran an01293 FIND v(xtop.a_3200_n35917.t0) AT=36n
.meas tran an01294 FIND v(xtop.a_3200_n35917.t1) AT=36n
.meas tran an01295 FIND v(xtop.a_3200_n35917.t2) AT=36n
.meas tran an01296 FIND v(xtop.a_3200_n35917.t3) AT=36n
.meas tran an01297 FIND v(xtop.a_6400_83.n0) AT=36n
.meas tran an01298 FIND v(xtop.a_6400_83.n1) AT=36n
.meas tran an01299 FIND v(xtop.a_6400_83.t0) AT=36n
.meas tran an01300 FIND v(xtop.a_6400_83.t1) AT=36n
.meas tran an01301 FIND v(xtop.a_6400_83.t2) AT=36n
.meas tran an01302 FIND v(xtop.a_6400_83.t3) AT=36n
.meas tran an01303 FIND v(xtop.a_6400_n24000.t0) AT=36n
.meas tran an01304 FIND v(xtop.a_6400_n24000.t1) AT=36n
.meas tran an01305 FIND v(xtop.a_9600_169.n0) AT=36n
.meas tran an01306 FIND v(xtop.a_9600_169.n1) AT=36n
.meas tran an01307 FIND v(xtop.a_9600_169.t0) AT=36n
.meas tran an01308 FIND v(xtop.a_9600_169.t1) AT=36n
.meas tran an01309 FIND v(xtop.a_9600_169.t2) AT=36n
.meas tran an01310 FIND v(xtop.a_9600_169.t3) AT=36n
.meas tran an01311 FIND v(xtop.a_9600_169.t4) AT=36n
.meas tran an01312 FIND v(xtop.a_9600_83.t0) AT=36n
.meas tran an01313 FIND v(xtop.a_9600_83.t1) AT=36n
.meas tran an01314 FIND v(xtop.a_9600_n35917.n0) AT=36n
.meas tran an01315 FIND v(xtop.a_9600_n35917.n1) AT=36n
.meas tran an01316 FIND v(xtop.a_9600_n35917.t0) AT=36n
.meas tran an01317 FIND v(xtop.a_9600_n35917.t1) AT=36n
.meas tran an01318 FIND v(xtop.a_9600_n35917.t2) AT=36n
.meas tran an01319 FIND v(xtop.a_9600_n36000.n0) AT=36n
.meas tran an01320 FIND v(xtop.a_9600_n36000.n1) AT=36n
.meas tran an01321 FIND v(xtop.a_9600_n36000.t0) AT=36n
.meas tran an01322 FIND v(xtop.a_9600_n36000.t1) AT=36n
.meas tran an01323 FIND v(xtop.a_9600_n36000.t2) AT=36n
.meas tran an01324 FIND v(xtop.a_9600_n36000.t3) AT=36n
.meas tran an01325 FIND v(xtop.a_n104_n35959.n0) AT=36n
.meas tran an01326 FIND v(xtop.a_n104_n35959.n1) AT=36n
.meas tran an01327 FIND v(xtop.a_n104_n35959.t0) AT=36n
.meas tran an01328 FIND v(xtop.a_n104_n35959.t1) AT=36n
.meas tran an01329 FIND v(xtop.a_n104_n35959.t2) AT=36n
.meas tran an01330 FIND v(xtop.a_n104_n35959.t3) AT=36n
.meas tran an01331 FIND v(xtop.a_n104_n35959.t4) AT=36n
.meas tran an01332 FIND v(dl) AT=36n
.meas tran an01333 FIND v(xtop.din.n0) AT=36n
.meas tran an01334 FIND v(xtop.din.n1) AT=36n
.meas tran an01335 FIND v(xtop.din.t0) AT=36n
.meas tran an01336 FIND v(xtop.din.t1) AT=36n
.meas tran an01337 FIND v(xtop.din.t2) AT=36n
.meas tran an01338 FIND v(xtop.din.t3) AT=36n
.meas tran an01339 FIND v(dout) AT=36n
.meas tran an01340 FIND v(xtop.dout.n0) AT=36n
.meas tran an01341 FIND v(xtop.dout.t0) AT=36n
.meas tran an01342 FIND v(xtop.dout.t1) AT=36n
.meas tran an01343 FIND v(en) AT=36n
.meas tran an01344 FIND v(xtop.en.n0) AT=36n
.meas tran an01345 FIND v(xtop.en.t0) AT=36n
.meas tran an01346 FIND v(xtop.en.t1) AT=36n
.meas tran an01347 FIND v(xtop.en.t2) AT=36n
.meas tran an01348 FIND v(xtop.en.t3) AT=36n
.meas tran an01349 FIND v(pc_b) AT=36n
.meas tran an01350 FIND v(xtop.pc_b.n0) AT=36n
.meas tran an01351 FIND v(xtop.pc_b.n1) AT=36n
.meas tran an01352 FIND v(xtop.pc_b.t0) AT=36n
.meas tran an01353 FIND v(xtop.pc_b.t1) AT=36n
.meas tran an01354 FIND v(xtop.pc_b.t2) AT=36n
.meas tran an01355 FIND v(sa_en) AT=36n
.meas tran an01356 FIND v(xtop.sa_en.n0) AT=36n
.meas tran an01357 FIND v(xtop.sa_en.t0) AT=36n
.meas tran an01358 FIND v(xtop.sa_en.t1) AT=36n
.meas tran an01359 FIND v(vdd) AT=36n
.meas tran an01360 FIND v(xtop.vdd.n0) AT=36n
.meas tran an01361 FIND v(xtop.vdd.n1) AT=36n
.meas tran an01362 FIND v(xtop.vdd.n10) AT=36n
.meas tran an01363 FIND v(xtop.vdd.n11) AT=36n
.meas tran an01364 FIND v(xtop.vdd.n12) AT=36n
.meas tran an01365 FIND v(xtop.vdd.n13) AT=36n
.meas tran an01366 FIND v(xtop.vdd.n14) AT=36n
.meas tran an01367 FIND v(xtop.vdd.n15) AT=36n
.meas tran an01368 FIND v(xtop.vdd.n16) AT=36n
.meas tran an01369 FIND v(xtop.vdd.n17) AT=36n
.meas tran an01370 FIND v(xtop.vdd.n18) AT=36n
.meas tran an01371 FIND v(xtop.vdd.n19) AT=36n
.meas tran an01372 FIND v(xtop.vdd.n2) AT=36n
.meas tran an01373 FIND v(xtop.vdd.n20) AT=36n
.meas tran an01374 FIND v(xtop.vdd.n21) AT=36n
.meas tran an01375 FIND v(xtop.vdd.n22) AT=36n
.meas tran an01376 FIND v(xtop.vdd.n23) AT=36n
.meas tran an01377 FIND v(xtop.vdd.n24) AT=36n
.meas tran an01378 FIND v(xtop.vdd.n25) AT=36n
.meas tran an01379 FIND v(xtop.vdd.n26) AT=36n
.meas tran an01380 FIND v(xtop.vdd.n27) AT=36n
.meas tran an01381 FIND v(xtop.vdd.n28) AT=36n
.meas tran an01382 FIND v(xtop.vdd.n29) AT=36n
.meas tran an01383 FIND v(xtop.vdd.n3) AT=36n
.meas tran an01384 FIND v(xtop.vdd.n30) AT=36n
.meas tran an01385 FIND v(xtop.vdd.n31) AT=36n
.meas tran an01386 FIND v(xtop.vdd.n32) AT=36n
.meas tran an01387 FIND v(xtop.vdd.n33) AT=36n
.meas tran an01388 FIND v(xtop.vdd.n34) AT=36n
.meas tran an01389 FIND v(xtop.vdd.n35) AT=36n
.meas tran an01390 FIND v(xtop.vdd.n36) AT=36n
.meas tran an01391 FIND v(xtop.vdd.n37) AT=36n
.meas tran an01392 FIND v(xtop.vdd.n38) AT=36n
.meas tran an01393 FIND v(xtop.vdd.n39) AT=36n
.meas tran an01394 FIND v(xtop.vdd.n4) AT=36n
.meas tran an01395 FIND v(xtop.vdd.n40) AT=36n
.meas tran an01396 FIND v(xtop.vdd.n41) AT=36n
.meas tran an01397 FIND v(xtop.vdd.n42) AT=36n
.meas tran an01398 FIND v(xtop.vdd.n43) AT=36n
.meas tran an01399 FIND v(xtop.vdd.n44) AT=36n
.meas tran an01400 FIND v(xtop.vdd.n45) AT=36n
.meas tran an01401 FIND v(xtop.vdd.n46) AT=36n
.meas tran an01402 FIND v(xtop.vdd.n5) AT=36n
.meas tran an01403 FIND v(xtop.vdd.n6) AT=36n
.meas tran an01404 FIND v(xtop.vdd.n7) AT=36n
.meas tran an01405 FIND v(xtop.vdd.n8) AT=36n
.meas tran an01406 FIND v(xtop.vdd.n9) AT=36n
.meas tran an01407 FIND v(xtop.vdd.t0) AT=36n
.meas tran an01408 FIND v(xtop.vdd.t1) AT=36n
.meas tran an01409 FIND v(xtop.vdd.t10) AT=36n
.meas tran an01410 FIND v(xtop.vdd.t11) AT=36n
.meas tran an01411 FIND v(xtop.vdd.t12) AT=36n
.meas tran an01412 FIND v(xtop.vdd.t13) AT=36n
.meas tran an01413 FIND v(xtop.vdd.t14) AT=36n
.meas tran an01414 FIND v(xtop.vdd.t15) AT=36n
.meas tran an01415 FIND v(xtop.vdd.t16) AT=36n
.meas tran an01416 FIND v(xtop.vdd.t17) AT=36n
.meas tran an01417 FIND v(xtop.vdd.t18) AT=36n
.meas tran an01418 FIND v(xtop.vdd.t19) AT=36n
.meas tran an01419 FIND v(xtop.vdd.t2) AT=36n
.meas tran an01420 FIND v(xtop.vdd.t20) AT=36n
.meas tran an01421 FIND v(xtop.vdd.t21) AT=36n
.meas tran an01422 FIND v(xtop.vdd.t22) AT=36n
.meas tran an01423 FIND v(xtop.vdd.t23) AT=36n
.meas tran an01424 FIND v(xtop.vdd.t24) AT=36n
.meas tran an01425 FIND v(xtop.vdd.t25) AT=36n
.meas tran an01426 FIND v(xtop.vdd.t26) AT=36n
.meas tran an01427 FIND v(xtop.vdd.t27) AT=36n
.meas tran an01428 FIND v(xtop.vdd.t28) AT=36n
.meas tran an01429 FIND v(xtop.vdd.t29) AT=36n
.meas tran an01430 FIND v(xtop.vdd.t3) AT=36n
.meas tran an01431 FIND v(xtop.vdd.t30) AT=36n
.meas tran an01432 FIND v(xtop.vdd.t31) AT=36n
.meas tran an01433 FIND v(xtop.vdd.t32) AT=36n
.meas tran an01434 FIND v(xtop.vdd.t33) AT=36n
.meas tran an01435 FIND v(xtop.vdd.t34) AT=36n
.meas tran an01436 FIND v(xtop.vdd.t35) AT=36n
.meas tran an01437 FIND v(xtop.vdd.t36) AT=36n
.meas tran an01438 FIND v(xtop.vdd.t37) AT=36n
.meas tran an01439 FIND v(xtop.vdd.t38) AT=36n
.meas tran an01440 FIND v(xtop.vdd.t39) AT=36n
.meas tran an01441 FIND v(xtop.vdd.t4) AT=36n
.meas tran an01442 FIND v(xtop.vdd.t40) AT=36n
.meas tran an01443 FIND v(xtop.vdd.t41) AT=36n
.meas tran an01444 FIND v(xtop.vdd.t42) AT=36n
.meas tran an01445 FIND v(xtop.vdd.t43) AT=36n
.meas tran an01446 FIND v(xtop.vdd.t44) AT=36n
.meas tran an01447 FIND v(xtop.vdd.t45) AT=36n
.meas tran an01448 FIND v(xtop.vdd.t46) AT=36n
.meas tran an01449 FIND v(xtop.vdd.t47) AT=36n
.meas tran an01450 FIND v(xtop.vdd.t48) AT=36n
.meas tran an01451 FIND v(xtop.vdd.t5) AT=36n
.meas tran an01452 FIND v(xtop.vdd.t6) AT=36n
.meas tran an01453 FIND v(xtop.vdd.t7) AT=36n
.meas tran an01454 FIND v(xtop.vdd.t8) AT=36n
.meas tran an01455 FIND v(xtop.vdd.t9) AT=36n
.meas tran an01457 FIND v(xtop.vss.n0) AT=36n
.meas tran an01458 FIND v(xtop.vss.n1) AT=36n
.meas tran an01459 FIND v(xtop.vss.n10) AT=36n
.meas tran an01460 FIND v(xtop.vss.n11) AT=36n
.meas tran an01461 FIND v(xtop.vss.n12) AT=36n
.meas tran an01462 FIND v(xtop.vss.n13) AT=36n
.meas tran an01463 FIND v(xtop.vss.n14) AT=36n
.meas tran an01464 FIND v(xtop.vss.n15) AT=36n
.meas tran an01465 FIND v(xtop.vss.n16) AT=36n
.meas tran an01466 FIND v(xtop.vss.n17) AT=36n
.meas tran an01467 FIND v(xtop.vss.n18) AT=36n
.meas tran an01468 FIND v(xtop.vss.n19) AT=36n
.meas tran an01469 FIND v(xtop.vss.n2) AT=36n
.meas tran an01470 FIND v(xtop.vss.n20) AT=36n
.meas tran an01471 FIND v(xtop.vss.n21) AT=36n
.meas tran an01472 FIND v(xtop.vss.n22) AT=36n
.meas tran an01473 FIND v(xtop.vss.n23) AT=36n
.meas tran an01474 FIND v(xtop.vss.n24) AT=36n
.meas tran an01475 FIND v(xtop.vss.n25) AT=36n
.meas tran an01476 FIND v(xtop.vss.n26) AT=36n
.meas tran an01477 FIND v(xtop.vss.n27) AT=36n
.meas tran an01478 FIND v(xtop.vss.n28) AT=36n
.meas tran an01479 FIND v(xtop.vss.n29) AT=36n
.meas tran an01480 FIND v(xtop.vss.n3) AT=36n
.meas tran an01481 FIND v(xtop.vss.n30) AT=36n
.meas tran an01482 FIND v(xtop.vss.n31) AT=36n
.meas tran an01483 FIND v(xtop.vss.n32) AT=36n
.meas tran an01484 FIND v(xtop.vss.n33) AT=36n
.meas tran an01485 FIND v(xtop.vss.n34) AT=36n
.meas tran an01486 FIND v(xtop.vss.n35) AT=36n
.meas tran an01487 FIND v(xtop.vss.n36) AT=36n
.meas tran an01488 FIND v(xtop.vss.n37) AT=36n
.meas tran an01489 FIND v(xtop.vss.n38) AT=36n
.meas tran an01490 FIND v(xtop.vss.n39) AT=36n
.meas tran an01491 FIND v(xtop.vss.n4) AT=36n
.meas tran an01492 FIND v(xtop.vss.n40) AT=36n
.meas tran an01493 FIND v(xtop.vss.n41) AT=36n
.meas tran an01494 FIND v(xtop.vss.n42) AT=36n
.meas tran an01495 FIND v(xtop.vss.n43) AT=36n
.meas tran an01496 FIND v(xtop.vss.n44) AT=36n
.meas tran an01497 FIND v(xtop.vss.n45) AT=36n
.meas tran an01498 FIND v(xtop.vss.n46) AT=36n
.meas tran an01499 FIND v(xtop.vss.n47) AT=36n
.meas tran an01500 FIND v(xtop.vss.n48) AT=36n
.meas tran an01501 FIND v(xtop.vss.n49) AT=36n
.meas tran an01502 FIND v(xtop.vss.n5) AT=36n
.meas tran an01503 FIND v(xtop.vss.n50) AT=36n
.meas tran an01504 FIND v(xtop.vss.n51) AT=36n
.meas tran an01505 FIND v(xtop.vss.n52) AT=36n
.meas tran an01506 FIND v(xtop.vss.n53) AT=36n
.meas tran an01507 FIND v(xtop.vss.n54) AT=36n
.meas tran an01508 FIND v(xtop.vss.n55) AT=36n
.meas tran an01509 FIND v(xtop.vss.n56) AT=36n
.meas tran an01510 FIND v(xtop.vss.n57) AT=36n
.meas tran an01511 FIND v(xtop.vss.n58) AT=36n
.meas tran an01512 FIND v(xtop.vss.n59) AT=36n
.meas tran an01513 FIND v(xtop.vss.n6) AT=36n
.meas tran an01514 FIND v(xtop.vss.n60) AT=36n
.meas tran an01515 FIND v(xtop.vss.n61) AT=36n
.meas tran an01516 FIND v(xtop.vss.n62) AT=36n
.meas tran an01517 FIND v(xtop.vss.n63) AT=36n
.meas tran an01518 FIND v(xtop.vss.n64) AT=36n
.meas tran an01519 FIND v(xtop.vss.n65) AT=36n
.meas tran an01520 FIND v(xtop.vss.n66) AT=36n
.meas tran an01521 FIND v(xtop.vss.n67) AT=36n
.meas tran an01522 FIND v(xtop.vss.n68) AT=36n
.meas tran an01523 FIND v(xtop.vss.n69) AT=36n
.meas tran an01524 FIND v(xtop.vss.n7) AT=36n
.meas tran an01525 FIND v(xtop.vss.n70) AT=36n
.meas tran an01526 FIND v(xtop.vss.n71) AT=36n
.meas tran an01527 FIND v(xtop.vss.n72) AT=36n
.meas tran an01528 FIND v(xtop.vss.n73) AT=36n
.meas tran an01529 FIND v(xtop.vss.n74) AT=36n
.meas tran an01530 FIND v(xtop.vss.n75) AT=36n
.meas tran an01531 FIND v(xtop.vss.n76) AT=36n
.meas tran an01532 FIND v(xtop.vss.n77) AT=36n
.meas tran an01533 FIND v(xtop.vss.n78) AT=36n
.meas tran an01534 FIND v(xtop.vss.n79) AT=36n
.meas tran an01535 FIND v(xtop.vss.n8) AT=36n
.meas tran an01536 FIND v(xtop.vss.n9) AT=36n
.meas tran an01537 FIND v(xtop.vss.t0) AT=36n
.meas tran an01538 FIND v(xtop.vss.t1) AT=36n
.meas tran an01539 FIND v(xtop.vss.t10) AT=36n
.meas tran an01540 FIND v(xtop.vss.t11) AT=36n
.meas tran an01541 FIND v(xtop.vss.t12) AT=36n
.meas tran an01542 FIND v(xtop.vss.t13) AT=36n
.meas tran an01543 FIND v(xtop.vss.t14) AT=36n
.meas tran an01544 FIND v(xtop.vss.t15) AT=36n
.meas tran an01545 FIND v(xtop.vss.t16) AT=36n
.meas tran an01546 FIND v(xtop.vss.t17) AT=36n
.meas tran an01547 FIND v(xtop.vss.t18) AT=36n
.meas tran an01548 FIND v(xtop.vss.t19) AT=36n
.meas tran an01549 FIND v(xtop.vss.t2) AT=36n
.meas tran an01550 FIND v(xtop.vss.t20) AT=36n
.meas tran an01551 FIND v(xtop.vss.t21) AT=36n
.meas tran an01552 FIND v(xtop.vss.t22) AT=36n
.meas tran an01553 FIND v(xtop.vss.t23) AT=36n
.meas tran an01554 FIND v(xtop.vss.t24) AT=36n
.meas tran an01555 FIND v(xtop.vss.t25) AT=36n
.meas tran an01556 FIND v(xtop.vss.t26) AT=36n
.meas tran an01557 FIND v(xtop.vss.t27) AT=36n
.meas tran an01558 FIND v(xtop.vss.t28) AT=36n
.meas tran an01559 FIND v(xtop.vss.t29) AT=36n
.meas tran an01560 FIND v(xtop.vss.t3) AT=36n
.meas tran an01561 FIND v(xtop.vss.t30) AT=36n
.meas tran an01562 FIND v(xtop.vss.t31) AT=36n
.meas tran an01563 FIND v(xtop.vss.t32) AT=36n
.meas tran an01564 FIND v(xtop.vss.t33) AT=36n
.meas tran an01565 FIND v(xtop.vss.t34) AT=36n
.meas tran an01566 FIND v(xtop.vss.t35) AT=36n
.meas tran an01567 FIND v(xtop.vss.t36) AT=36n
.meas tran an01568 FIND v(xtop.vss.t37) AT=36n
.meas tran an01569 FIND v(xtop.vss.t38) AT=36n
.meas tran an01570 FIND v(xtop.vss.t39) AT=36n
.meas tran an01571 FIND v(xtop.vss.t4) AT=36n
.meas tran an01572 FIND v(xtop.vss.t40) AT=36n
.meas tran an01573 FIND v(xtop.vss.t41) AT=36n
.meas tran an01574 FIND v(xtop.vss.t42) AT=36n
.meas tran an01575 FIND v(xtop.vss.t43) AT=36n
.meas tran an01576 FIND v(xtop.vss.t5) AT=36n
.meas tran an01577 FIND v(xtop.vss.t6) AT=36n
.meas tran an01578 FIND v(xtop.vss.t7) AT=36n
.meas tran an01579 FIND v(xtop.vss.t8) AT=36n
.meas tran an01580 FIND v(xtop.vss.t9) AT=36n
.meas tran an01581 FIND v(we) AT=36n
.meas tran an01582 FIND v(xtop.we.n0) AT=36n
.meas tran an01583 FIND v(xtop.we.n1) AT=36n
.meas tran an01584 FIND v(xtop.we.t0) AT=36n
.meas tran an01585 FIND v(xtop.we.t1) AT=36n
.meas tran an01586 FIND v(xtop.we.t2) AT=36n
.meas tran an01587 FIND v(xtop.we.t3) AT=36n
.meas tran an01588 FIND v(a) AT=39n
.meas tran an01589 FIND v(xtop.a.n0) AT=39n
.meas tran an01590 FIND v(xtop.a.t0) AT=39n
.meas tran an01591 FIND v(xtop.a.t1) AT=39n
.meas tran an01592 FIND v(xtop.a.t2) AT=39n
.meas tran an01593 FIND v(xtop.a.t3) AT=39n
.meas tran an01594 FIND v(xtop.a_0_83.n0) AT=39n
.meas tran an01595 FIND v(xtop.a_0_83.t0) AT=39n
.meas tran an01596 FIND v(xtop.a_0_83.t1) AT=39n
.meas tran an01597 FIND v(xtop.a_0_83.t2) AT=39n
.meas tran an01598 FIND v(xtop.a_0_83.t3) AT=39n
.meas tran an01599 FIND v(xtop.a_0_n11917.n0) AT=39n
.meas tran an01600 FIND v(xtop.a_0_n11917.n1) AT=39n
.meas tran an01601 FIND v(xtop.a_0_n11917.n2) AT=39n
.meas tran an01602 FIND v(xtop.a_0_n11917.n3) AT=39n
.meas tran an01603 FIND v(xtop.a_0_n11917.n4) AT=39n
.meas tran an01604 FIND v(xtop.a_0_n11917.t0) AT=39n
.meas tran an01605 FIND v(xtop.a_0_n11917.t1) AT=39n
.meas tran an01606 FIND v(xtop.a_0_n11917.t2) AT=39n
.meas tran an01607 FIND v(xtop.a_0_n11917.t3) AT=39n
.meas tran an01608 FIND v(xtop.a_0_n11917.t4) AT=39n
.meas tran an01609 FIND v(xtop.a_0_n11917.t5) AT=39n
.meas tran an01610 FIND v(xtop.a_0_n11917.t6) AT=39n
.meas tran an01611 FIND v(xtop.a_0_n23917.n0) AT=39n
.meas tran an01612 FIND v(xtop.a_0_n23917.n1) AT=39n
.meas tran an01613 FIND v(xtop.a_0_n23917.t0) AT=39n
.meas tran an01614 FIND v(xtop.a_0_n23917.t1) AT=39n
.meas tran an01615 FIND v(xtop.a_0_n23917.t2) AT=39n
.meas tran an01616 FIND v(xtop.a_0_n23917.t3) AT=39n
.meas tran an01617 FIND v(xtop.a_0_n35917.n0) AT=39n
.meas tran an01618 FIND v(xtop.a_0_n35917.t0) AT=39n
.meas tran an01619 FIND v(xtop.a_0_n35917.t1) AT=39n
.meas tran an01620 FIND v(xtop.a_0_n35917.t2) AT=39n
.meas tran an01621 FIND v(xtop.a_0_n35917.t3) AT=39n
.meas tran an01622 FIND v(xtop.a_11200_n23917.t0) AT=39n
.meas tran an01623 FIND v(xtop.a_11200_n23917.t1) AT=39n
.meas tran an01624 FIND v(xtop.a_12800_83.n0) AT=39n
.meas tran an01625 FIND v(xtop.a_12800_83.n1) AT=39n
.meas tran an01626 FIND v(xtop.a_12800_83.t0) AT=39n
.meas tran an01627 FIND v(xtop.a_12800_83.t1) AT=39n
.meas tran an01628 FIND v(xtop.a_12800_83.t2) AT=39n
.meas tran an01629 FIND v(xtop.a_12800_83.t3) AT=39n
.meas tran an01630 FIND v(xtop.a_16000_n24000.t0) AT=39n
.meas tran an01631 FIND v(xtop.a_16000_n24000.t1) AT=39n
.meas tran an01632 FIND v(xtop.a_1600_n11917.n0) AT=39n
.meas tran an01633 FIND v(xtop.a_1600_n11917.n1) AT=39n
.meas tran an01634 FIND v(xtop.a_1600_n11917.n2) AT=39n
.meas tran an01635 FIND v(xtop.a_1600_n11917.n3) AT=39n
.meas tran an01636 FIND v(xtop.a_1600_n11917.n4) AT=39n
.meas tran an01637 FIND v(xtop.a_1600_n11917.t0) AT=39n
.meas tran an01638 FIND v(xtop.a_1600_n11917.t1) AT=39n
.meas tran an01639 FIND v(xtop.a_1600_n11917.t2) AT=39n
.meas tran an01640 FIND v(xtop.a_1600_n11917.t3) AT=39n
.meas tran an01641 FIND v(xtop.a_1600_n11917.t4) AT=39n
.meas tran an01642 FIND v(xtop.a_1600_n11917.t5) AT=39n
.meas tran an01643 FIND v(xtop.a_1600_n11917.t6) AT=39n
.meas tran an01644 FIND v(xtop.a_19896_16041.n0) AT=39n
.meas tran an01645 FIND v(xtop.a_19896_16041.n1) AT=39n
.meas tran an01646 FIND v(xtop.a_19896_16041.t0) AT=39n
.meas tran an01647 FIND v(xtop.a_19896_16041.t1) AT=39n
.meas tran an01648 FIND v(xtop.a_19896_16041.t2) AT=39n
.meas tran an01649 FIND v(xtop.a_19896_16041.t3) AT=39n
.meas tran an01650 FIND v(xtop.a_19896_16041.t4) AT=39n
.meas tran an01651 FIND v(xtop.a_19896_8041.n0) AT=39n
.meas tran an01652 FIND v(xtop.a_19896_8041.n1) AT=39n
.meas tran an01653 FIND v(xtop.a_19896_8041.t0) AT=39n
.meas tran an01654 FIND v(xtop.a_19896_8041.t1) AT=39n
.meas tran an01655 FIND v(xtop.a_19896_8041.t2) AT=39n
.meas tran an01656 FIND v(xtop.a_19896_8041.t3) AT=39n
.meas tran an01657 FIND v(xtop.a_19896_8041.t4) AT=39n
.meas tran an01658 FIND v(xtop.a_20000_14483.n0) AT=39n
.meas tran an01659 FIND v(xtop.a_20000_14483.n1) AT=39n
.meas tran an01660 FIND v(xtop.a_20000_14483.t0) AT=39n
.meas tran an01661 FIND v(xtop.a_20000_14483.t1) AT=39n
.meas tran an01662 FIND v(xtop.a_20000_14483.t2) AT=39n
.meas tran an01663 FIND v(xtop.a_20000_14483.t3) AT=39n
.meas tran an01664 FIND v(xtop.a_20000_14483.t4) AT=39n
.meas tran an01665 FIND v(xtop.a_20000_6483.n0) AT=39n
.meas tran an01666 FIND v(xtop.a_20000_6483.n1) AT=39n
.meas tran an01667 FIND v(xtop.a_20000_6483.t0) AT=39n
.meas tran an01668 FIND v(xtop.a_20000_6483.t1) AT=39n
.meas tran an01669 FIND v(xtop.a_20000_6483.t2) AT=39n
.meas tran an01670 FIND v(xtop.a_20000_6483.t3) AT=39n
.meas tran an01671 FIND v(xtop.a_20000_6483.t4) AT=39n
.meas tran an01672 FIND v(xtop.a_20800_n23917.t0) AT=39n
.meas tran an01673 FIND v(xtop.a_20800_n23917.t1) AT=39n
.meas tran an01674 FIND v(xtop.a_3200_169.n0) AT=39n
.meas tran an01675 FIND v(xtop.a_3200_169.n1) AT=39n
.meas tran an01676 FIND v(xtop.a_3200_169.t0) AT=39n
.meas tran an01677 FIND v(xtop.a_3200_169.t1) AT=39n
.meas tran an01678 FIND v(xtop.a_3200_169.t2) AT=39n
.meas tran an01679 FIND v(xtop.a_3200_169.t3) AT=39n
.meas tran an01680 FIND v(xtop.a_3200_169.t4) AT=39n
.meas tran an01681 FIND v(xtop.a_3200_83.t0) AT=39n
.meas tran an01682 FIND v(xtop.a_3200_83.t1) AT=39n
.meas tran an01683 FIND v(xtop.a_3200_n23917.n0) AT=39n
.meas tran an01684 FIND v(xtop.a_3200_n23917.n1) AT=39n
.meas tran an01685 FIND v(xtop.a_3200_n23917.t0) AT=39n
.meas tran an01686 FIND v(xtop.a_3200_n23917.t1) AT=39n
.meas tran an01687 FIND v(xtop.a_3200_n23917.t2) AT=39n
.meas tran an01688 FIND v(xtop.a_3200_n23917.t3) AT=39n
.meas tran an01689 FIND v(xtop.a_3200_n35917.n0) AT=39n
.meas tran an01690 FIND v(xtop.a_3200_n35917.t0) AT=39n
.meas tran an01691 FIND v(xtop.a_3200_n35917.t1) AT=39n
.meas tran an01692 FIND v(xtop.a_3200_n35917.t2) AT=39n
.meas tran an01693 FIND v(xtop.a_3200_n35917.t3) AT=39n
.meas tran an01694 FIND v(xtop.a_6400_83.n0) AT=39n
.meas tran an01695 FIND v(xtop.a_6400_83.n1) AT=39n
.meas tran an01696 FIND v(xtop.a_6400_83.t0) AT=39n
.meas tran an01697 FIND v(xtop.a_6400_83.t1) AT=39n
.meas tran an01698 FIND v(xtop.a_6400_83.t2) AT=39n
.meas tran an01699 FIND v(xtop.a_6400_83.t3) AT=39n
.meas tran an01700 FIND v(xtop.a_6400_n24000.t0) AT=39n
.meas tran an01701 FIND v(xtop.a_6400_n24000.t1) AT=39n
.meas tran an01702 FIND v(xtop.a_9600_169.n0) AT=39n
.meas tran an01703 FIND v(xtop.a_9600_169.n1) AT=39n
.meas tran an01704 FIND v(xtop.a_9600_169.t0) AT=39n
.meas tran an01705 FIND v(xtop.a_9600_169.t1) AT=39n
.meas tran an01706 FIND v(xtop.a_9600_169.t2) AT=39n
.meas tran an01707 FIND v(xtop.a_9600_169.t3) AT=39n
.meas tran an01708 FIND v(xtop.a_9600_169.t4) AT=39n
.meas tran an01709 FIND v(xtop.a_9600_83.t0) AT=39n
.meas tran an01710 FIND v(xtop.a_9600_83.t1) AT=39n
.meas tran an01711 FIND v(xtop.a_9600_n35917.n0) AT=39n
.meas tran an01712 FIND v(xtop.a_9600_n35917.n1) AT=39n
.meas tran an01713 FIND v(xtop.a_9600_n35917.t0) AT=39n
.meas tran an01714 FIND v(xtop.a_9600_n35917.t1) AT=39n
.meas tran an01715 FIND v(xtop.a_9600_n35917.t2) AT=39n
.meas tran an01716 FIND v(xtop.a_9600_n36000.n0) AT=39n
.meas tran an01717 FIND v(xtop.a_9600_n36000.n1) AT=39n
.meas tran an01718 FIND v(xtop.a_9600_n36000.t0) AT=39n
.meas tran an01719 FIND v(xtop.a_9600_n36000.t1) AT=39n
.meas tran an01720 FIND v(xtop.a_9600_n36000.t2) AT=39n
.meas tran an01721 FIND v(xtop.a_9600_n36000.t3) AT=39n
.meas tran an01722 FIND v(xtop.a_n104_n35959.n0) AT=39n
.meas tran an01723 FIND v(xtop.a_n104_n35959.n1) AT=39n
.meas tran an01724 FIND v(xtop.a_n104_n35959.t0) AT=39n
.meas tran an01725 FIND v(xtop.a_n104_n35959.t1) AT=39n
.meas tran an01726 FIND v(xtop.a_n104_n35959.t2) AT=39n
.meas tran an01727 FIND v(xtop.a_n104_n35959.t3) AT=39n
.meas tran an01728 FIND v(xtop.a_n104_n35959.t4) AT=39n
.meas tran an01729 FIND v(dl) AT=39n
.meas tran an01730 FIND v(xtop.din.n0) AT=39n
.meas tran an01731 FIND v(xtop.din.n1) AT=39n
.meas tran an01732 FIND v(xtop.din.t0) AT=39n
.meas tran an01733 FIND v(xtop.din.t1) AT=39n
.meas tran an01734 FIND v(xtop.din.t2) AT=39n
.meas tran an01735 FIND v(xtop.din.t3) AT=39n
.meas tran an01736 FIND v(dout) AT=39n
.meas tran an01737 FIND v(xtop.dout.n0) AT=39n
.meas tran an01738 FIND v(xtop.dout.t0) AT=39n
.meas tran an01739 FIND v(xtop.dout.t1) AT=39n
.meas tran an01740 FIND v(en) AT=39n
.meas tran an01741 FIND v(xtop.en.n0) AT=39n
.meas tran an01742 FIND v(xtop.en.t0) AT=39n
.meas tran an01743 FIND v(xtop.en.t1) AT=39n
.meas tran an01744 FIND v(xtop.en.t2) AT=39n
.meas tran an01745 FIND v(xtop.en.t3) AT=39n
.meas tran an01746 FIND v(pc_b) AT=39n
.meas tran an01747 FIND v(xtop.pc_b.n0) AT=39n
.meas tran an01748 FIND v(xtop.pc_b.n1) AT=39n
.meas tran an01749 FIND v(xtop.pc_b.t0) AT=39n
.meas tran an01750 FIND v(xtop.pc_b.t1) AT=39n
.meas tran an01751 FIND v(xtop.pc_b.t2) AT=39n
.meas tran an01752 FIND v(sa_en) AT=39n
.meas tran an01753 FIND v(xtop.sa_en.n0) AT=39n
.meas tran an01754 FIND v(xtop.sa_en.t0) AT=39n
.meas tran an01755 FIND v(xtop.sa_en.t1) AT=39n
.meas tran an01756 FIND v(vdd) AT=39n
.meas tran an01757 FIND v(xtop.vdd.n0) AT=39n
.meas tran an01758 FIND v(xtop.vdd.n1) AT=39n
.meas tran an01759 FIND v(xtop.vdd.n10) AT=39n
.meas tran an01760 FIND v(xtop.vdd.n11) AT=39n
.meas tran an01761 FIND v(xtop.vdd.n12) AT=39n
.meas tran an01762 FIND v(xtop.vdd.n13) AT=39n
.meas tran an01763 FIND v(xtop.vdd.n14) AT=39n
.meas tran an01764 FIND v(xtop.vdd.n15) AT=39n
.meas tran an01765 FIND v(xtop.vdd.n16) AT=39n
.meas tran an01766 FIND v(xtop.vdd.n17) AT=39n
.meas tran an01767 FIND v(xtop.vdd.n18) AT=39n
.meas tran an01768 FIND v(xtop.vdd.n19) AT=39n
.meas tran an01769 FIND v(xtop.vdd.n2) AT=39n
.meas tran an01770 FIND v(xtop.vdd.n20) AT=39n
.meas tran an01771 FIND v(xtop.vdd.n21) AT=39n
.meas tran an01772 FIND v(xtop.vdd.n22) AT=39n
.meas tran an01773 FIND v(xtop.vdd.n23) AT=39n
.meas tran an01774 FIND v(xtop.vdd.n24) AT=39n
.meas tran an01775 FIND v(xtop.vdd.n25) AT=39n
.meas tran an01776 FIND v(xtop.vdd.n26) AT=39n
.meas tran an01777 FIND v(xtop.vdd.n27) AT=39n
.meas tran an01778 FIND v(xtop.vdd.n28) AT=39n
.meas tran an01779 FIND v(xtop.vdd.n29) AT=39n
.meas tran an01780 FIND v(xtop.vdd.n3) AT=39n
.meas tran an01781 FIND v(xtop.vdd.n30) AT=39n
.meas tran an01782 FIND v(xtop.vdd.n31) AT=39n
.meas tran an01783 FIND v(xtop.vdd.n32) AT=39n
.meas tran an01784 FIND v(xtop.vdd.n33) AT=39n
.meas tran an01785 FIND v(xtop.vdd.n34) AT=39n
.meas tran an01786 FIND v(xtop.vdd.n35) AT=39n
.meas tran an01787 FIND v(xtop.vdd.n36) AT=39n
.meas tran an01788 FIND v(xtop.vdd.n37) AT=39n
.meas tran an01789 FIND v(xtop.vdd.n38) AT=39n
.meas tran an01790 FIND v(xtop.vdd.n39) AT=39n
.meas tran an01791 FIND v(xtop.vdd.n4) AT=39n
.meas tran an01792 FIND v(xtop.vdd.n40) AT=39n
.meas tran an01793 FIND v(xtop.vdd.n41) AT=39n
.meas tran an01794 FIND v(xtop.vdd.n42) AT=39n
.meas tran an01795 FIND v(xtop.vdd.n43) AT=39n
.meas tran an01796 FIND v(xtop.vdd.n44) AT=39n
.meas tran an01797 FIND v(xtop.vdd.n45) AT=39n
.meas tran an01798 FIND v(xtop.vdd.n46) AT=39n
.meas tran an01799 FIND v(xtop.vdd.n5) AT=39n
.meas tran an01800 FIND v(xtop.vdd.n6) AT=39n
.meas tran an01801 FIND v(xtop.vdd.n7) AT=39n
.meas tran an01802 FIND v(xtop.vdd.n8) AT=39n
.meas tran an01803 FIND v(xtop.vdd.n9) AT=39n
.meas tran an01804 FIND v(xtop.vdd.t0) AT=39n
.meas tran an01805 FIND v(xtop.vdd.t1) AT=39n
.meas tran an01806 FIND v(xtop.vdd.t10) AT=39n
.meas tran an01807 FIND v(xtop.vdd.t11) AT=39n
.meas tran an01808 FIND v(xtop.vdd.t12) AT=39n
.meas tran an01809 FIND v(xtop.vdd.t13) AT=39n
.meas tran an01810 FIND v(xtop.vdd.t14) AT=39n
.meas tran an01811 FIND v(xtop.vdd.t15) AT=39n
.meas tran an01812 FIND v(xtop.vdd.t16) AT=39n
.meas tran an01813 FIND v(xtop.vdd.t17) AT=39n
.meas tran an01814 FIND v(xtop.vdd.t18) AT=39n
.meas tran an01815 FIND v(xtop.vdd.t19) AT=39n
.meas tran an01816 FIND v(xtop.vdd.t2) AT=39n
.meas tran an01817 FIND v(xtop.vdd.t20) AT=39n
.meas tran an01818 FIND v(xtop.vdd.t21) AT=39n
.meas tran an01819 FIND v(xtop.vdd.t22) AT=39n
.meas tran an01820 FIND v(xtop.vdd.t23) AT=39n
.meas tran an01821 FIND v(xtop.vdd.t24) AT=39n
.meas tran an01822 FIND v(xtop.vdd.t25) AT=39n
.meas tran an01823 FIND v(xtop.vdd.t26) AT=39n
.meas tran an01824 FIND v(xtop.vdd.t27) AT=39n
.meas tran an01825 FIND v(xtop.vdd.t28) AT=39n
.meas tran an01826 FIND v(xtop.vdd.t29) AT=39n
.meas tran an01827 FIND v(xtop.vdd.t3) AT=39n
.meas tran an01828 FIND v(xtop.vdd.t30) AT=39n
.meas tran an01829 FIND v(xtop.vdd.t31) AT=39n
.meas tran an01830 FIND v(xtop.vdd.t32) AT=39n
.meas tran an01831 FIND v(xtop.vdd.t33) AT=39n
.meas tran an01832 FIND v(xtop.vdd.t34) AT=39n
.meas tran an01833 FIND v(xtop.vdd.t35) AT=39n
.meas tran an01834 FIND v(xtop.vdd.t36) AT=39n
.meas tran an01835 FIND v(xtop.vdd.t37) AT=39n
.meas tran an01836 FIND v(xtop.vdd.t38) AT=39n
.meas tran an01837 FIND v(xtop.vdd.t39) AT=39n
.meas tran an01838 FIND v(xtop.vdd.t4) AT=39n
.meas tran an01839 FIND v(xtop.vdd.t40) AT=39n
.meas tran an01840 FIND v(xtop.vdd.t41) AT=39n
.meas tran an01841 FIND v(xtop.vdd.t42) AT=39n
.meas tran an01842 FIND v(xtop.vdd.t43) AT=39n
.meas tran an01843 FIND v(xtop.vdd.t44) AT=39n
.meas tran an01844 FIND v(xtop.vdd.t45) AT=39n
.meas tran an01845 FIND v(xtop.vdd.t46) AT=39n
.meas tran an01846 FIND v(xtop.vdd.t47) AT=39n
.meas tran an01847 FIND v(xtop.vdd.t48) AT=39n
.meas tran an01848 FIND v(xtop.vdd.t5) AT=39n
.meas tran an01849 FIND v(xtop.vdd.t6) AT=39n
.meas tran an01850 FIND v(xtop.vdd.t7) AT=39n
.meas tran an01851 FIND v(xtop.vdd.t8) AT=39n
.meas tran an01852 FIND v(xtop.vdd.t9) AT=39n
.meas tran an01854 FIND v(xtop.vss.n0) AT=39n
.meas tran an01855 FIND v(xtop.vss.n1) AT=39n
.meas tran an01856 FIND v(xtop.vss.n10) AT=39n
.meas tran an01857 FIND v(xtop.vss.n11) AT=39n
.meas tran an01858 FIND v(xtop.vss.n12) AT=39n
.meas tran an01859 FIND v(xtop.vss.n13) AT=39n
.meas tran an01860 FIND v(xtop.vss.n14) AT=39n
.meas tran an01861 FIND v(xtop.vss.n15) AT=39n
.meas tran an01862 FIND v(xtop.vss.n16) AT=39n
.meas tran an01863 FIND v(xtop.vss.n17) AT=39n
.meas tran an01864 FIND v(xtop.vss.n18) AT=39n
.meas tran an01865 FIND v(xtop.vss.n19) AT=39n
.meas tran an01866 FIND v(xtop.vss.n2) AT=39n
.meas tran an01867 FIND v(xtop.vss.n20) AT=39n
.meas tran an01868 FIND v(xtop.vss.n21) AT=39n
.meas tran an01869 FIND v(xtop.vss.n22) AT=39n
.meas tran an01870 FIND v(xtop.vss.n23) AT=39n
.meas tran an01871 FIND v(xtop.vss.n24) AT=39n
.meas tran an01872 FIND v(xtop.vss.n25) AT=39n
.meas tran an01873 FIND v(xtop.vss.n26) AT=39n
.meas tran an01874 FIND v(xtop.vss.n27) AT=39n
.meas tran an01875 FIND v(xtop.vss.n28) AT=39n
.meas tran an01876 FIND v(xtop.vss.n29) AT=39n
.meas tran an01877 FIND v(xtop.vss.n3) AT=39n
.meas tran an01878 FIND v(xtop.vss.n30) AT=39n
.meas tran an01879 FIND v(xtop.vss.n31) AT=39n
.meas tran an01880 FIND v(xtop.vss.n32) AT=39n
.meas tran an01881 FIND v(xtop.vss.n33) AT=39n
.meas tran an01882 FIND v(xtop.vss.n34) AT=39n
.meas tran an01883 FIND v(xtop.vss.n35) AT=39n
.meas tran an01884 FIND v(xtop.vss.n36) AT=39n
.meas tran an01885 FIND v(xtop.vss.n37) AT=39n
.meas tran an01886 FIND v(xtop.vss.n38) AT=39n
.meas tran an01887 FIND v(xtop.vss.n39) AT=39n
.meas tran an01888 FIND v(xtop.vss.n4) AT=39n
.meas tran an01889 FIND v(xtop.vss.n40) AT=39n
.meas tran an01890 FIND v(xtop.vss.n41) AT=39n
.meas tran an01891 FIND v(xtop.vss.n42) AT=39n
.meas tran an01892 FIND v(xtop.vss.n43) AT=39n
.meas tran an01893 FIND v(xtop.vss.n44) AT=39n
.meas tran an01894 FIND v(xtop.vss.n45) AT=39n
.meas tran an01895 FIND v(xtop.vss.n46) AT=39n
.meas tran an01896 FIND v(xtop.vss.n47) AT=39n
.meas tran an01897 FIND v(xtop.vss.n48) AT=39n
.meas tran an01898 FIND v(xtop.vss.n49) AT=39n
.meas tran an01899 FIND v(xtop.vss.n5) AT=39n
.meas tran an01900 FIND v(xtop.vss.n50) AT=39n
.meas tran an01901 FIND v(xtop.vss.n51) AT=39n
.meas tran an01902 FIND v(xtop.vss.n52) AT=39n
.meas tran an01903 FIND v(xtop.vss.n53) AT=39n
.meas tran an01904 FIND v(xtop.vss.n54) AT=39n
.meas tran an01905 FIND v(xtop.vss.n55) AT=39n
.meas tran an01906 FIND v(xtop.vss.n56) AT=39n
.meas tran an01907 FIND v(xtop.vss.n57) AT=39n
.meas tran an01908 FIND v(xtop.vss.n58) AT=39n
.meas tran an01909 FIND v(xtop.vss.n59) AT=39n
.meas tran an01910 FIND v(xtop.vss.n6) AT=39n
.meas tran an01911 FIND v(xtop.vss.n60) AT=39n
.meas tran an01912 FIND v(xtop.vss.n61) AT=39n
.meas tran an01913 FIND v(xtop.vss.n62) AT=39n
.meas tran an01914 FIND v(xtop.vss.n63) AT=39n
.meas tran an01915 FIND v(xtop.vss.n64) AT=39n
.meas tran an01916 FIND v(xtop.vss.n65) AT=39n
.meas tran an01917 FIND v(xtop.vss.n66) AT=39n
.meas tran an01918 FIND v(xtop.vss.n67) AT=39n
.meas tran an01919 FIND v(xtop.vss.n68) AT=39n
.meas tran an01920 FIND v(xtop.vss.n69) AT=39n
.meas tran an01921 FIND v(xtop.vss.n7) AT=39n
.meas tran an01922 FIND v(xtop.vss.n70) AT=39n
.meas tran an01923 FIND v(xtop.vss.n71) AT=39n
.meas tran an01924 FIND v(xtop.vss.n72) AT=39n
.meas tran an01925 FIND v(xtop.vss.n73) AT=39n
.meas tran an01926 FIND v(xtop.vss.n74) AT=39n
.meas tran an01927 FIND v(xtop.vss.n75) AT=39n
.meas tran an01928 FIND v(xtop.vss.n76) AT=39n
.meas tran an01929 FIND v(xtop.vss.n77) AT=39n
.meas tran an01930 FIND v(xtop.vss.n78) AT=39n
.meas tran an01931 FIND v(xtop.vss.n79) AT=39n
.meas tran an01932 FIND v(xtop.vss.n8) AT=39n
.meas tran an01933 FIND v(xtop.vss.n9) AT=39n
.meas tran an01934 FIND v(xtop.vss.t0) AT=39n
.meas tran an01935 FIND v(xtop.vss.t1) AT=39n
.meas tran an01936 FIND v(xtop.vss.t10) AT=39n
.meas tran an01937 FIND v(xtop.vss.t11) AT=39n
.meas tran an01938 FIND v(xtop.vss.t12) AT=39n
.meas tran an01939 FIND v(xtop.vss.t13) AT=39n
.meas tran an01940 FIND v(xtop.vss.t14) AT=39n
.meas tran an01941 FIND v(xtop.vss.t15) AT=39n
.meas tran an01942 FIND v(xtop.vss.t16) AT=39n
.meas tran an01943 FIND v(xtop.vss.t17) AT=39n
.meas tran an01944 FIND v(xtop.vss.t18) AT=39n
.meas tran an01945 FIND v(xtop.vss.t19) AT=39n
.meas tran an01946 FIND v(xtop.vss.t2) AT=39n
.meas tran an01947 FIND v(xtop.vss.t20) AT=39n
.meas tran an01948 FIND v(xtop.vss.t21) AT=39n
.meas tran an01949 FIND v(xtop.vss.t22) AT=39n
.meas tran an01950 FIND v(xtop.vss.t23) AT=39n
.meas tran an01951 FIND v(xtop.vss.t24) AT=39n
.meas tran an01952 FIND v(xtop.vss.t25) AT=39n
.meas tran an01953 FIND v(xtop.vss.t26) AT=39n
.meas tran an01954 FIND v(xtop.vss.t27) AT=39n
.meas tran an01955 FIND v(xtop.vss.t28) AT=39n
.meas tran an01956 FIND v(xtop.vss.t29) AT=39n
.meas tran an01957 FIND v(xtop.vss.t3) AT=39n
.meas tran an01958 FIND v(xtop.vss.t30) AT=39n
.meas tran an01959 FIND v(xtop.vss.t31) AT=39n
.meas tran an01960 FIND v(xtop.vss.t32) AT=39n
.meas tran an01961 FIND v(xtop.vss.t33) AT=39n
.meas tran an01962 FIND v(xtop.vss.t34) AT=39n
.meas tran an01963 FIND v(xtop.vss.t35) AT=39n
.meas tran an01964 FIND v(xtop.vss.t36) AT=39n
.meas tran an01965 FIND v(xtop.vss.t37) AT=39n
.meas tran an01966 FIND v(xtop.vss.t38) AT=39n
.meas tran an01967 FIND v(xtop.vss.t39) AT=39n
.meas tran an01968 FIND v(xtop.vss.t4) AT=39n
.meas tran an01969 FIND v(xtop.vss.t40) AT=39n
.meas tran an01970 FIND v(xtop.vss.t41) AT=39n
.meas tran an01971 FIND v(xtop.vss.t42) AT=39n
.meas tran an01972 FIND v(xtop.vss.t43) AT=39n
.meas tran an01973 FIND v(xtop.vss.t5) AT=39n
.meas tran an01974 FIND v(xtop.vss.t6) AT=39n
.meas tran an01975 FIND v(xtop.vss.t7) AT=39n
.meas tran an01976 FIND v(xtop.vss.t8) AT=39n
.meas tran an01977 FIND v(xtop.vss.t9) AT=39n
.meas tran an01978 FIND v(we) AT=39n
.meas tran an01979 FIND v(xtop.we.n0) AT=39n
.meas tran an01980 FIND v(xtop.we.n1) AT=39n
.meas tran an01981 FIND v(xtop.we.t0) AT=39n
.meas tran an01982 FIND v(xtop.we.t1) AT=39n
.meas tran an01983 FIND v(xtop.we.t2) AT=39n
.meas tran an01984 FIND v(xtop.we.t3) AT=39n
.control
set wr_singlescale
set wr_vecnames
run
wrdata waveform.tsv v(xtop.a_0_n11917.t0) v(xtop.a_1600_n11917.t0) v(dout) v(en) v(we) i(vdd)
quit
.endc
.end
