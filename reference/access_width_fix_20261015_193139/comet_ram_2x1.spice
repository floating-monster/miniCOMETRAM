* comet_ram_2x1
* Schematic generated by Substrate

.subckt comet_ram_2x1
+ vdd
+ vss
+ a
+ en
+ din
+ we
+ pc_b
+ sa_en
+ dout

XCORE
+ vdd
+ vss
+ bl
+ br
+ a
+ en
+ comet_decoded_array_2x1
XPRE
+ vdd
+ bl
+ br
+ pc_b
+ comet_precharge_3p
XDRV
+ vdd
+ vss
+ din
+ we
+ bl
+ br
+ comet_write_driver
XSA
+ vdd
+ vss
+ bl
+ br
+ sa_en
+ dout
+ comet_sense_amp
.ends comet_ram_2x1

.subckt comet_decoded_array_2x1
+ vdd
+ vss
+ bl
+ br
+ a
+ en

XDEC
+ vdd
+ vss
+ a
+ en
+ wl0
+ wl1
+ comet_row_decoder_1to2
XARRAY
+ vdd
+ vss
+ bl
+ br
+ wl0
+ wl1
+ comet_array_2x1
.ends comet_decoded_array_2x1

.subckt comet_precharge_3p
+ vdd
+ bl
+ br
+ pc_b

XPBL
+ bl
+ pc_b
+ vdd
+ vdd
+ mos_w800_l150_m1_nf1_id1
XPBR
+ br
+ pc_b
+ vdd
+ vdd
+ mos_w800_l150_m1_nf1_id1
XPEQ
+ bl
+ pc_b
+ br
+ vdd
+ mos_w800_l150_m1_nf1_id1
.ends comet_precharge_3p

.subckt comet_write_driver
+ vdd
+ vss
+ din
+ we
+ bl
+ br

XDATA_INV
+ vdd
+ vss
+ din
+ db
+ comet_inv_r0
XWE_INV
+ vdd
+ vss
+ we
+ web
+ comet_inv_r0
XBL_PEN
+ BL_p_mid
+ web
+ vdd
+ vdd
+ mos_w4800_l150_m1_nf1_id1
XBL_PDATA
+ bl
+ db
+ BL_p_mid
+ vdd
+ mos_w4800_l150_m1_nf1_id1
XBL_NDATA
+ bl
+ db
+ BL_n_mid
+ vss
+ mos_w3200_l150_m1_nf1_id0
XBL_NEN
+ BL_n_mid
+ we
+ vss
+ vss
+ mos_w3200_l150_m1_nf1_id0
XBR_PEN
+ BR_p_mid
+ web
+ vdd
+ vdd
+ mos_w4800_l150_m1_nf1_id1
XBR_PDATA
+ br
+ din
+ BR_p_mid
+ vdd
+ mos_w4800_l150_m1_nf1_id1
XBR_NDATA
+ br
+ din
+ BR_n_mid
+ vss
+ mos_w3200_l150_m1_nf1_id0
XBR_NEN
+ BR_n_mid
+ we
+ vss
+ vss
+ mos_w3200_l150_m1_nf1_id0
.ends comet_write_driver

.subckt comet_sense_amp
+ vdd
+ vss
+ bl
+ br
+ sa_en
+ dout

XNLEFT
+ mirror
+ br
+ tail
+ vss
+ mos_w1600_l150_m1_nf1_id0
XNRIGHT
+ sense
+ bl
+ tail
+ vss
+ mos_w1600_l150_m1_nf1_id0
XNTAIL
+ tail
+ sa_en
+ vss
+ vss
+ mos_w420_l600_m1_nf1_id0
XPMIRROR_REF
+ mirror
+ mirror
+ vdd
+ vdd
+ mos_w2400_l150_m1_nf1_id1
XPMIRROR_OUT
+ sense
+ mirror
+ vdd
+ vdd
+ mos_w2400_l150_m1_nf1_id1
XPRESET
+ sense
+ sa_en
+ vdd
+ vdd
+ mos_w2400_l150_m1_nf1_id1
XOUTPUT_INV
+ vdd
+ vss
+ sense
+ raw
+ comet_inv_r0
XRESTORE_INV0
+ vdd
+ vss
+ raw
+ buffered_b
+ comet_inv_r0
XRESTORE_INV1
+ vdd
+ vss
+ buffered_b
+ dout
+ comet_inv_r0
.ends comet_sense_amp

.subckt comet_row_decoder_1to2
+ vdd
+ vss
+ a
+ en
+ wl0
+ wl1

XADDR_INV
+ vdd
+ vss
+ a
+ ab
+ comet_inv_r0
XROW0_NAND
+ vdd
+ vss
+ en
+ ab
+ n0
+ comet_nand2
XROW0_DRIVER
+ vdd
+ vss
+ n0
+ wl0
+ comet_inv_r0
XROW1_NAND
+ vdd
+ vss
+ en
+ a
+ n1
+ comet_nand2
XROW1_DRIVER
+ vdd
+ vss
+ n1
+ wl1
+ comet_inv_r0
.ends comet_row_decoder_1to2

.subckt comet_array_2x1
+ vdd
+ vss
+ bl
+ br
+ wl0
+ wl1

XROW0
+ vdd
+ vss
+ bl
+ br
+ wl0
+ comet_bitcell_6t
XROW1
+ vdd
+ vss
+ bl
+ br
+ wl1
+ comet_bitcell_6t
.ends comet_array_2x1

.subckt mos_w800_l150_m1_nf1_id1
+ d
+ g
+ s
+ b

X0 d g s b sky130_fd_pr__pfet_01v8 w=0.800 l=0.150
.ends mos_w800_l150_m1_nf1_id1

.subckt comet_inv_r0
+ vdd
+ vss
+ a
+ y

XMP0
+ y
+ a
+ vdd
+ vdd
+ mos_w2400_l150_m1_nf1_id1
XMN0
+ y
+ a
+ vss
+ vss
+ mos_w1600_l150_m1_nf1_id0
.ends comet_inv_r0

.subckt mos_w4800_l150_m1_nf1_id1
+ d
+ g
+ s
+ b

X0 d g s b sky130_fd_pr__pfet_01v8 w=4.800 l=0.150
.ends mos_w4800_l150_m1_nf1_id1

.subckt mos_w3200_l150_m1_nf1_id0
+ d
+ g
+ s
+ b

X0 d g s b sky130_fd_pr__nfet_01v8 w=3.200 l=0.150
.ends mos_w3200_l150_m1_nf1_id0

.subckt mos_w1600_l150_m1_nf1_id0
+ d
+ g
+ s
+ b

X0 d g s b sky130_fd_pr__nfet_01v8 w=1.600 l=0.150
.ends mos_w1600_l150_m1_nf1_id0

.subckt mos_w420_l600_m1_nf1_id0
+ d
+ g
+ s
+ b

X0 d g s b sky130_fd_pr__nfet_01v8 w=0.420 l=0.600
.ends mos_w420_l600_m1_nf1_id0

.subckt mos_w2400_l150_m1_nf1_id1
+ d
+ g
+ s
+ b

X0 d g s b sky130_fd_pr__pfet_01v8 w=2.400 l=0.150
.ends mos_w2400_l150_m1_nf1_id1

.subckt comet_nand2
+ vdd
+ vss
+ a
+ b
+ y

XPA
+ y
+ a
+ vdd
+ vdd
+ mos_w2400_l150_m1_nf1_id1
XPB
+ y
+ b
+ vdd
+ vdd
+ mos_w2400_l150_m1_nf1_id1
XNA
+ y
+ a
+ mid
+ vss
+ mos_w3200_l150_m1_nf1_id0
XNB
+ mid
+ b
+ vss
+ vss
+ mos_w3200_l150_m1_nf1_id0
.ends comet_nand2

.subckt comet_bitcell_6t
+ vdd
+ vss
+ bl
+ br
+ wl

XIL
+ vdd
+ vss
+ qb
+ q
+ comet_inv_r0
XIR
+ vdd
+ vss
+ q
+ qb
+ comet_inv_r0
XAXL
+ bl
+ wl
+ q
+ vss
+ mos_w40000_l150_m1_nf1_id0
XAXR
+ br
+ wl
+ qb
+ vss
+ mos_w40000_l150_m1_nf1_id0
.ends comet_bitcell_6t

.subckt mos_w40000_l150_m1_nf1_id0
+ d
+ g
+ s
+ b

X0 d g s b sky130_fd_pr__nfet_01v8 w=40.000 l=0.150
.ends mos_w40000_l150_m1_nf1_id0
